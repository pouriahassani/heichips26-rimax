* NGSPICE file created from heichips26_RiMaX.ext - technology: ihp-sg13cmos5l

* Black-box entry subcircuit for sg13cmos5l_inv_1 abstract view
.subckt sg13cmos5l_inv_1 Y A VDD VSS
.ends

* Black-box entry subcircuit for sg13cmos5l_fill_2 abstract view
.subckt sg13cmos5l_fill_2 VDD VSS
.ends

* Black-box entry subcircuit for sg13cmos5l_mux2_1 abstract view
.subckt sg13cmos5l_mux2_1 X A0 A1 S VDD VSS
.ends

* Black-box entry subcircuit for sg13cmos5l_decap_8 abstract view
.subckt sg13cmos5l_decap_8 VDD VSS
.ends

* Black-box entry subcircuit for sg13cmos5l_o21ai_1 abstract view
.subckt sg13cmos5l_o21ai_1 Y A1 A2 B1 VDD VSS
.ends

* Black-box entry subcircuit for sg13cmos5l_nor2_1 abstract view
.subckt sg13cmos5l_nor2_1 Y A B VDD VSS
.ends

* Black-box entry subcircuit for sg13cmos5l_decap_4 abstract view
.subckt sg13cmos5l_decap_4 VDD VSS
.ends

* Black-box entry subcircuit for sg13cmos5l_nand2_1 abstract view
.subckt sg13cmos5l_nand2_1 Y A B VDD VSS
.ends

* Black-box entry subcircuit for sg13cmos5l_tiehi abstract view
.subckt sg13cmos5l_tiehi L_HI VDD VSS
.ends

* Black-box entry subcircuit for sg13cmos5l_a21oi_1 abstract view
.subckt sg13cmos5l_a21oi_1 Y A1 A2 B1 VDD VSS
.ends

* Black-box entry subcircuit for sg13cmos5l_fill_1 abstract view
.subckt sg13cmos5l_fill_1 VDD VSS
.ends

* Black-box entry subcircuit for sg13cmos5l_nor3_1 abstract view
.subckt sg13cmos5l_nor3_1 Y A B C VDD VSS
.ends

* Black-box entry subcircuit for sg13cmos5l_and4_1 abstract view
.subckt sg13cmos5l_and4_1 X A B C D VDD VSS
.ends

* Black-box entry subcircuit for sg13cmos5l_and3_1 abstract view
.subckt sg13cmos5l_and3_1 X A B C VDD VSS
.ends

* Black-box entry subcircuit for sg13cmos5l_buf_1 abstract view
.subckt sg13cmos5l_buf_1 X A VDD VSS
.ends

* Black-box entry subcircuit for sg13cmos5l_a221oi_1 abstract view
.subckt sg13cmos5l_a221oi_1 Y A1 A2 B1 B2 C1 VDD VSS
.ends

* Black-box entry subcircuit for sg13cmos5l_dfrbpq_1 abstract view
.subckt sg13cmos5l_dfrbpq_1 Q CLK D RESET_B VDD VSS
.ends

* Black-box entry subcircuit for sg13cmos5l_a21o_1 abstract view
.subckt sg13cmos5l_a21o_1 X A1 A2 B1 VDD VSS
.ends

* Black-box entry subcircuit for sg13cmos5l_a22oi_1 abstract view
.subckt sg13cmos5l_a22oi_1 Y A1 A2 B1 B2 VDD VSS
.ends

* Black-box entry subcircuit for sg13cmos5l_nor4_1 abstract view
.subckt sg13cmos5l_nor4_1 Y A B C D VDD VSS
.ends

* Black-box entry subcircuit for sg13cmos5l_nor2b_1 abstract view
.subckt sg13cmos5l_nor2b_1 Y A B_N VDD VSS
.ends

* Black-box entry subcircuit for sg13cmos5l_xnor2_1 abstract view
.subckt sg13cmos5l_xnor2_1 Y A B VDD VSS
.ends

* Black-box entry subcircuit for sg13cmos5l_xor2_1 abstract view
.subckt sg13cmos5l_xor2_1 X A B VDD VSS
.ends

* Black-box entry subcircuit for sg13cmos5l_buf_8 abstract view
.subckt sg13cmos5l_buf_8 X A VDD VSS
.ends

* Black-box entry subcircuit for sg13cmos5l_or2_1 abstract view
.subckt sg13cmos5l_or2_1 X A B VDD VSS
.ends

* Black-box entry subcircuit for sg13cmos5l_mux4_1 abstract view
.subckt sg13cmos5l_mux4_1 X A0 A1 A2 A3 S0 S1 VDD VSS
.ends

* Black-box entry subcircuit for sg13cmos5l_dlygate4sd3_1 abstract view
.subckt sg13cmos5l_dlygate4sd3_1 X A VDD VSS
.ends

* Black-box entry subcircuit for sg13cmos5l_and2_1 abstract view
.subckt sg13cmos5l_and2_1 X A B VDD VSS
.ends

* Black-box entry subcircuit for sg13cmos5l_nand3_1 abstract view
.subckt sg13cmos5l_nand3_1 Y A B C VDD VSS
.ends

* Black-box entry subcircuit for sg13cmos5l_nand2b_1 abstract view
.subckt sg13cmos5l_nand2b_1 Y A_N B VDD VSS
.ends

* Black-box entry subcircuit for sg13cmos5l_antennanp abstract view
.subckt sg13cmos5l_antennanp A VDD VSS
.ends

* Black-box entry subcircuit for sg13cmos5l_or3_1 abstract view
.subckt sg13cmos5l_or3_1 X A B C VDD VSS
.ends

* Black-box entry subcircuit for sg13cmos5l_nand4_1 abstract view
.subckt sg13cmos5l_nand4_1 Y A B C D VDD VSS
.ends

* Black-box entry subcircuit for sg13cmos5l_or4_1 abstract view
.subckt sg13cmos5l_or4_1 X A B C D VDD VSS
.ends

* Black-box entry subcircuit for sg13cmos5l_inv_2 abstract view
.subckt sg13cmos5l_inv_2 Y A VDD VSS
.ends

* Black-box entry subcircuit for sg13cmos5l_nand3b_1 abstract view
.subckt sg13cmos5l_nand3b_1 Y A_N B C VDD VSS
.ends

* Black-box entry subcircuit for sg13cmos5l_inv_4 abstract view
.subckt sg13cmos5l_inv_4 Y A VDD VSS
.ends

* Black-box entry subcircuit for sg13cmos5l_inv_8 abstract view
.subckt sg13cmos5l_inv_8 Y A VDD VSS
.ends

* Black-box entry subcircuit for sg13cmos5l_tielo abstract view
.subckt sg13cmos5l_tielo L_LO VDD VSS
.ends

.subckt heichips26_RiMaX VGND VPWR clk ena rst_n ui_in[0] ui_in[10] ui_in[11] ui_in[12]
+ ui_in[13] ui_in[14] ui_in[15] ui_in[1] ui_in[2] ui_in[3] ui_in[4] ui_in[5] ui_in[6]
+ ui_in[7] ui_in[8] ui_in[9] uio_in[0] uio_in[10] uio_in[11] uio_in[12] uio_in[13]
+ uio_in[14] uio_in[15] uio_in[1] uio_in[2] uio_in[3] uio_in[4] uio_in[5] uio_in[6]
+ uio_in[7] uio_in[8] uio_in[9] uio_oe[0] uio_oe[10] uio_oe[11] uio_oe[12] uio_oe[13]
+ uio_oe[14] uio_oe[15] uio_oe[1] uio_oe[2] uio_oe[3] uio_oe[4] uio_oe[5] uio_oe[6]
+ uio_oe[7] uio_oe[8] uio_oe[9] uio_out[0] uio_out[10] uio_out[11] uio_out[12] uio_out[13]
+ uio_out[14] uio_out[15] uio_out[1] uio_out[2] uio_out[3] uio_out[4] uio_out[5] uio_out[6]
+ uio_out[7] uio_out[8] uio_out[9] uo_out[0] uo_out[10] uo_out[11] uo_out[12] uo_out[13]
+ uo_out[14] uo_out[15] uo_out[1] uo_out[2] uo_out[3] uo_out[4] uo_out[5] uo_out[6]
+ uo_out[7] uo_out[8] uo_out[9]
X_05903_ _09885_/A _05903_/A VPWR VGND sg13cmos5l_inv_1
XFILLER_95_884 VPWR VGND sg13cmos5l_fill_2
X_06883_ _11626_/D _11691_/D hold2561/X _08642_/S VPWR VGND sg13cmos5l_mux2_1
XFILLER_39_255 VPWR VGND sg13cmos5l_fill_2
XFILLER_27_406 VPWR VGND sg13cmos5l_decap_8
X_09671_ _09672_/C _09722_/A _09667_/Y _09670_/Y VPWR VGND sg13cmos5l_o21ai_1
X_08622_ _08622_/Y _08625_/B _08625_/C VPWR VGND sg13cmos5l_nor2_1
XFILLER_82_567 VPWR VGND sg13cmos5l_decap_4
X_08553_ _08553_/Y _08553_/A _08553_/B VPWR VGND sg13cmos5l_nor2_1
X_08484_ _08484_/Y _08484_/A _08494_/B VPWR VGND sg13cmos5l_nand2_1
X_10946__1036 _10946_/RESET_B VPWR VGND sg13cmos5l_tiehi
XFILLER_51_932 VPWR VGND sg13cmos5l_fill_2
X_07504_ _10899_/D _07526_/B _08331_/A1 _07503_/Y VPWR VGND sg13cmos5l_a21oi_1
XFILLER_22_100 VPWR VGND sg13cmos5l_decap_4
XFILLER_23_623 VPWR VGND sg13cmos5l_decap_4
X_07435_ _07786_/D _11558_/Q _11556_/Q VPWR VGND sg13cmos5l_nor2_1
XFILLER_52_29 VPWR VGND sg13cmos5l_decap_4
XFILLER_35_1009 VPWR VGND sg13cmos5l_fill_2
XFILLER_50_464 VPWR VGND sg13cmos5l_fill_1
XFILLER_50_453 VPWR VGND sg13cmos5l_decap_8
XFILLER_23_689 VPWR VGND sg13cmos5l_fill_1
X_07366_ _10878_/D _07365_/B _07364_/Y _07365_/Y VPWR VGND sg13cmos5l_a21oi_1
X_09105_ _09105_/Y _09131_/A _09105_/B _09105_/C VPWR VGND sg13cmos5l_nor3_1
X_07297_ _07297_/Y _07295_/Y _07296_/Y _07304_/A2 VPWR VGND sg13cmos5l_a21oi_1
X_06317_ _06317_/Y _06726_/B _06710_/A _06313_/A VPWR VGND sg13cmos5l_a21oi_1
X_11235__1666 _11235_/RESET_B VPWR VGND sg13cmos5l_tiehi
X_06248_ _10658_/A _06248_/A _06429_/A VPWR VGND sg13cmos5l_nor2_1
X_09036_ _09068_/D _09036_/A _09036_/B _09036_/C _09036_/D VPWR VGND sg13cmos5l_and4_1
X_11721__1238 _11721_/RESET_B VPWR VGND sg13cmos5l_tiehi
XFILLER_7_7 VPWR VGND sg13cmos5l_decap_8
XFILLER_2_516 VPWR VGND sg13cmos5l_decap_4
X_06179_ _06272_/A _06179_/A _06179_/B _06645_/A VPWR VGND sg13cmos5l_and3_1
XFILLER_105_967 VPWR VGND sg13cmos5l_decap_8
XFILLER_77_37 VPWR VGND sg13cmos5l_decap_8
Xfanout831 _10326_/A input1/X VPWR VGND sg13cmos5l_buf_1
X_09938_ _09939_/B _09938_/A _09968_/B VPWR VGND sg13cmos5l_nor2_1
Xfanout820 _08627_/C _07071_/A VPWR VGND sg13cmos5l_buf_1
XFILLER_93_14 VPWR VGND sg13cmos5l_decap_8
X_09869_ _09875_/B _09865_/Y _09866_/Y _09867_/Y _09868_/Y _09983_/C1 VPWR VGND sg13cmos5l_a221oi_1
XFILLER_46_704 VPWR VGND sg13cmos5l_decap_8
XFILLER_45_236 VPWR VGND sg13cmos5l_decap_8
XFILLER_18_439 VPWR VGND sg13cmos5l_decap_8
XFILLER_42_910 VPWR VGND sg13cmos5l_fill_2
XFILLER_14_623 VPWR VGND sg13cmos5l_decap_8
XFILLER_26_461 VPWR VGND sg13cmos5l_decap_8
X_11762_ _11762_/Q _11767_/CLK _11762_/D _11762_/RESET_B VPWR VGND sg13cmos5l_dfrbpq_1
XFILLER_14_634 VPWR VGND sg13cmos5l_fill_1
X_10713_ _10713_/Y _10713_/A _10713_/B _10731_/C VPWR VGND sg13cmos5l_nor3_1
X_11693_ _11693_/Q clkload30/A _11693_/D _11693_/RESET_B VPWR VGND sg13cmos5l_dfrbpq_1
XFILLER_42_987 VPWR VGND sg13cmos5l_decap_8
XFILLER_13_166 VPWR VGND sg13cmos5l_decap_8
X_10644_ _10644_/X _10643_/A _10643_/B _10644_/B1 VPWR VGND sg13cmos5l_a21o_1
X_10575_ _10592_/A _11416_/Q _10853_/Q VPWR VGND sg13cmos5l_nand2_1
X_11403__1484 _11403_/RESET_B VPWR VGND sg13cmos5l_tiehi
XFILLER_69_807 VPWR VGND sg13cmos5l_fill_2
X_11531__1525 _11531_/RESET_B VPWR VGND sg13cmos5l_tiehi
X_11127_ _11127_/Q clkload17/A _11127_/D _11127_/RESET_B VPWR VGND sg13cmos5l_dfrbpq_1
XFILLER_95_125 VPWR VGND sg13cmos5l_decap_8
XFILLER_49_542 VPWR VGND sg13cmos5l_fill_2
XFILLER_37_715 VPWR VGND sg13cmos5l_fill_1
X_11058_ _11058_/Q clkload8/A _11058_/D _11058_/RESET_B VPWR VGND sg13cmos5l_dfrbpq_1
XFILLER_3_1018 VPWR VGND sg13cmos5l_decap_8
X_10009_ _10009_/Y _11079_/Q _10012_/B VPWR VGND sg13cmos5l_nand2_1
XFILLER_77_895 VPWR VGND sg13cmos5l_decap_4
XFILLER_37_737 VPWR VGND sg13cmos5l_fill_2
XFILLER_92_887 VPWR VGND sg13cmos5l_fill_2
XFILLER_91_353 VPWR VGND sg13cmos5l_fill_2
XFILLER_64_578 VPWR VGND sg13cmos5l_decap_8
XFILLER_24_409 VPWR VGND sg13cmos5l_decap_8
X_11313__1588 _11313_/RESET_B VPWR VGND sg13cmos5l_tiehi
XFILLER_33_976 VPWR VGND sg13cmos5l_fill_2
X_07220_ _07220_/Y _05970_/Y _07237_/A2 _07226_/B1 _07219_/Y VPWR VGND sg13cmos5l_a22oi_1
X_07151_ _07151_/Y hold2742/X _07154_/A2 _06091_/A VPWR VGND sg13cmos5l_o21ai_1
XFILLER_9_660 VPWR VGND sg13cmos5l_fill_2
XFILLER_66_0 VPWR VGND sg13cmos5l_fill_2
X_06102_ _06103_/C _10886_/Q _10887_/Q _10888_/Q _10889_/Q VPWR VGND sg13cmos5l_nor4_1
X_07082_ _07082_/Y _07071_/Y _07081_/Y _06952_/A VPWR VGND sg13cmos5l_o21ai_1
XFILLER_8_192 VPWR VGND sg13cmos5l_fill_1
X_06033_ _06092_/B _10691_/C _06033_/B VPWR VGND sg13cmos5l_nand2_1
XFILLER_99_453 VPWR VGND sg13cmos5l_fill_1
XFILLER_99_442 VPWR VGND sg13cmos5l_fill_2
XFILLER_102_937 VPWR VGND sg13cmos5l_fill_2
Xfanout138 _08236_/B _08244_/B VPWR VGND sg13cmos5l_buf_1
Xfanout127 _08496_/B _08500_/B VPWR VGND sg13cmos5l_buf_1
Xfanout116 _08633_/S _06142_/Y VPWR VGND sg13cmos5l_buf_1
Xfanout105 _08532_/A1 _08337_/A1 VPWR VGND sg13cmos5l_buf_1
Xfanout149 _07978_/B _07919_/Y VPWR VGND sg13cmos5l_buf_1
XFILLER_102_948 VPWR VGND sg13cmos5l_decap_8
X_07984_ _07984_/Y _08506_/C _07984_/B VPWR VGND sg13cmos5l_nor2_1
XFILLER_101_469 VPWR VGND sg13cmos5l_fill_2
XFILLER_101_458 VPWR VGND sg13cmos5l_decap_4
X_11012__970 _11012_/RESET_B VPWR VGND sg13cmos5l_tiehi
X_06935_ _10777_/C _10776_/B _06943_/C _06935_/C VPWR VGND sg13cmos5l_nor3_1
XFILLER_68_873 VPWR VGND sg13cmos5l_decap_8
X_09723_ _09723_/Y _10250_/A _09828_/B VPWR VGND sg13cmos5l_nor2_1
X_06866_ _06866_/Y _06782_/B _06845_/Y _06865_/Y VPWR VGND sg13cmos5l_o21ai_1
XFILLER_83_832 VPWR VGND sg13cmos5l_fill_2
X_09654_ _09654_/Y _10906_/Q _09652_/S _09735_/B1 VPWR VGND sg13cmos5l_a21oi_1
XFILLER_27_214 VPWR VGND sg13cmos5l_fill_2
XFILLER_103_35 VPWR VGND sg13cmos5l_decap_8
X_08605_ _09316_/A _08605_/A _08605_/B VPWR VGND sg13cmos5l_nor2_1
XFILLER_43_718 VPWR VGND sg13cmos5l_decap_4
X_06797_ _06825_/B _06820_/C _06820_/B VPWR VGND sg13cmos5l_nor2b_1
XFILLER_70_526 VPWR VGND sg13cmos5l_decap_8
X_09585_ _09585_/Y hold2793/X _09725_/B _09506_/B _09584_/Y VPWR VGND sg13cmos5l_a22oi_1
XFILLER_51_740 VPWR VGND sg13cmos5l_decap_4
X_08536_ _11352_/D _08536_/A1 _08535_/B _08535_/Y VPWR VGND sg13cmos5l_a21oi_1
X_08467_ _11318_/D _08532_/A1 _08466_/B _08466_/Y VPWR VGND sg13cmos5l_o21ai_1
X_07418_ _07418_/Y _09262_/A _07430_/A2 _07417_/Y VPWR VGND sg13cmos5l_a21oi_1
XFILLER_50_294 VPWR VGND sg13cmos5l_fill_1
X_08398_ _11284_/D _08528_/A1 _08397_/B _08397_/Y VPWR VGND sg13cmos5l_a21oi_1
X_07349_ _07349_/Y _11537_/Q _08721_/A VPWR VGND sg13cmos5l_nand2_1
X_10360_ _10361_/B _10488_/A _10360_/B VPWR VGND sg13cmos5l_nand2_1
XFILLER_88_14 VPWR VGND sg13cmos5l_decap_8
X_09019_ _09019_/Y _09019_/A _09019_/B VPWR VGND sg13cmos5l_nor2_1
X_10291_ _10291_/Y _10423_/A _10305_/B VPWR VGND sg13cmos5l_nor2_1
XFILLER_105_731 VPWR VGND sg13cmos5l_decap_8
XFILLER_104_252 VPWR VGND sg13cmos5l_decap_8
XFILLER_77_136 VPWR VGND sg13cmos5l_fill_1
Xfanout650 _06132_/B _06134_/B VPWR VGND sg13cmos5l_buf_1
Xfanout694 _06825_/A _06779_/D VPWR VGND sg13cmos5l_buf_1
Xfanout661 fanout661/X _11756_/Q VPWR VGND sg13cmos5l_buf_1
Xfanout683 _10709_/A _10731_/B VPWR VGND sg13cmos5l_buf_1
Xfanout672 _10408_/A _10526_/A VPWR VGND sg13cmos5l_buf_1
XFILLER_19_704 VPWR VGND sg13cmos5l_decap_4
XFILLER_101_981 VPWR VGND sg13cmos5l_decap_8
XFILLER_73_331 VPWR VGND sg13cmos5l_fill_2
XFILLER_18_258 VPWR VGND sg13cmos5l_fill_2
XFILLER_19_759 VPWR VGND sg13cmos5l_fill_2
XFILLER_15_910 VPWR VGND sg13cmos5l_fill_2
XFILLER_18_269 VPWR VGND sg13cmos5l_fill_1
XFILLER_61_537 VPWR VGND sg13cmos5l_decap_8
XFILLER_14_431 VPWR VGND sg13cmos5l_fill_2
XFILLER_26_280 VPWR VGND sg13cmos5l_fill_1
X_11745_ _11745_/Q clkload23/A _11745_/D _11745_/RESET_B VPWR VGND sg13cmos5l_dfrbpq_1
XFILLER_42_751 VPWR VGND sg13cmos5l_fill_1
XFILLER_30_913 VPWR VGND sg13cmos5l_decap_8
XFILLER_41_272 VPWR VGND sg13cmos5l_fill_1
XFILLER_30_957 VPWR VGND sg13cmos5l_fill_1
X_11676_ _11676_/Q clkload12/A _11676_/D _11676_/RESET_B VPWR VGND sg13cmos5l_dfrbpq_1
X_10627_ _10632_/B _11419_/Q _10856_/Q VPWR VGND sg13cmos5l_xnor2_1
X_10558_ _10560_/B _11479_/Q _10656_/B _10557_/Y _10584_/A _10614_/C1 VPWR VGND sg13cmos5l_a221oi_1
XFILLER_52_6 VPWR VGND sg13cmos5l_fill_1
X_10489_ _11536_/D _10489_/A _10489_/B VPWR VGND sg13cmos5l_nor2_1
XFILLER_38_4 VPWR VGND sg13cmos5l_fill_2
XFILLER_69_637 VPWR VGND sg13cmos5l_decap_8
XFILLER_49_361 VPWR VGND sg13cmos5l_decap_8
XFILLER_37_523 VPWR VGND sg13cmos5l_decap_8
X_06720_ _06721_/B _06739_/A _06717_/Y _06718_/Y _06719_/Y VPWR VGND sg13cmos5l_a22oi_1
XFILLER_92_662 VPWR VGND sg13cmos5l_fill_2
XFILLER_92_640 VPWR VGND sg13cmos5l_decap_4
XFILLER_64_331 VPWR VGND sg13cmos5l_decap_8
X_06651_ _06651_/Y _06168_/A _06400_/B _06400_/D _06649_/A _06650_/Y VPWR VGND sg13cmos5l_a221oi_1
XFILLER_92_695 VPWR VGND sg13cmos5l_fill_2
XFILLER_92_684 VPWR VGND sg13cmos5l_decap_8
XFILLER_91_161 VPWR VGND sg13cmos5l_fill_2
XFILLER_91_183 VPWR VGND sg13cmos5l_fill_1
X_06582_ _06583_/B _06582_/A _06582_/B VPWR VGND sg13cmos5l_xor2_1
X_09370_ _09370_/Y _11343_/Q _09363_/B _09688_/S1 VPWR VGND sg13cmos5l_a21oi_1
XFILLER_18_792 VPWR VGND sg13cmos5l_fill_1
XFILLER_24_228 VPWR VGND sg13cmos5l_fill_2
X_08321_ _11246_/D _08321_/A1 _08328_/B _08320_/Y VPWR VGND sg13cmos5l_o21ai_1
X_08252_ _11212_/D _08317_/A1 _08293_/B _08251_/Y VPWR VGND sg13cmos5l_a21oi_1
XFILLER_33_795 VPWR VGND sg13cmos5l_decap_4
X_07203_ _07204_/B _10838_/Q _06927_/B _07185_/X _07201_/X VPWR VGND sg13cmos5l_a22oi_1
XFILLER_20_456 VPWR VGND sg13cmos5l_fill_2
X_08183_ _11178_/D _08313_/A1 _08234_/B _08182_/Y VPWR VGND sg13cmos5l_o21ai_1
Xclkbuf_4_12_0_clk clkbuf_4_12_0_clk/X clkbuf_0_clk/X VPWR VGND sg13cmos5l_buf_8
X_07134_ _11732_/D _05890_/Y _07142_/A2 _07133_/Y VPWR VGND sg13cmos5l_a21oi_1
XFILLER_106_539 VPWR VGND sg13cmos5l_decap_8
X_07065_ _07067_/B _10165_/B _07065_/B VPWR VGND sg13cmos5l_or2_1
X_10896__1086 _10896_/RESET_B VPWR VGND sg13cmos5l_tiehi
X_06016_ _06017_/B _06809_/A _06019_/B _10727_/B _06007_/D VPWR VGND sg13cmos5l_a22oi_1
XFILLER_88_924 VPWR VGND sg13cmos5l_decap_8
XFILLER_0_817 VPWR VGND sg13cmos5l_decap_8
XFILLER_99_283 VPWR VGND sg13cmos5l_decap_4
XFILLER_87_434 VPWR VGND sg13cmos5l_decap_8
XFILLER_102_789 VPWR VGND sg13cmos5l_decap_8
XFILLER_87_478 VPWR VGND sg13cmos5l_decap_4
XFILLER_87_456 VPWR VGND sg13cmos5l_fill_1
X_07967_ _11073_/D fanout67/X _07966_/B _07966_/Y VPWR VGND sg13cmos5l_o21ai_1
XFILLER_101_288 VPWR VGND sg13cmos5l_decap_4
X_06918_ _06918_/Y hold2645/X _06917_/B _06917_/Y VPWR VGND sg13cmos5l_o21ai_1
XFILLER_74_139 VPWR VGND sg13cmos5l_fill_1
XFILLER_74_106 VPWR VGND sg13cmos5l_decap_8
XFILLER_74_16 VPWR VGND sg13cmos5l_decap_8
XFILLER_56_832 VPWR VGND sg13cmos5l_decap_8
X_09706_ _09706_/Y _09729_/C _09706_/B VPWR VGND sg13cmos5l_nand2_1
X_07898_ _11039_/D fanout75/X _07899_/B _07897_/Y VPWR VGND sg13cmos5l_a21oi_1
XFILLER_56_843 VPWR VGND sg13cmos5l_fill_2
X_06849_ _11615_/D _06631_/S _06784_/Y _06848_/X VPWR VGND sg13cmos5l_o21ai_1
XFILLER_83_695 VPWR VGND sg13cmos5l_fill_2
XFILLER_83_684 VPWR VGND sg13cmos5l_fill_1
XFILLER_82_150 VPWR VGND sg13cmos5l_fill_1
XFILLER_70_301 VPWR VGND sg13cmos5l_fill_2
X_09637_ _09637_/Y _11289_/Q _09850_/A2 _09636_/Y VPWR VGND sg13cmos5l_o21ai_1
XFILLER_28_589 VPWR VGND sg13cmos5l_fill_1
XFILLER_43_559 VPWR VGND sg13cmos5l_fill_1
X_09568_ _09568_/X _11127_/Q _11095_/Q _11063_/Q _11031_/Q _09440_/B _09575_/S1 VPWR
+ VGND sg13cmos5l_mux4_1
X_08519_ _08519_/Y _08519_/A _08527_/B VPWR VGND sg13cmos5l_nor2_1
X_09499_ _09499_/Y _11348_/Q _09499_/B VPWR VGND sg13cmos5l_nand2_1
X_11530_ _11530_/Q clkload20/A _11530_/D _11530_/RESET_B VPWR VGND sg13cmos5l_dfrbpq_1
X_11563__1425 _11563_/RESET_B VPWR VGND sg13cmos5l_tiehi
X_11461_ _11461_/Q clkload18/A _11461_/D _11461_/RESET_B VPWR VGND sg13cmos5l_dfrbpq_1
XFILLER_99_46 VPWR VGND sg13cmos5l_decap_8
XFILLER_87_1013 VPWR VGND sg13cmos5l_decap_8
XFILLER_87_1002 VPWR VGND sg13cmos5l_fill_2
X_11392_ _11392_/Q clkload24/A _11392_/D _11392_/RESET_B VPWR VGND sg13cmos5l_dfrbpq_1
X_10412_ _10412_/Y _11729_/Q _10166_/B _10411_/Y VPWR VGND sg13cmos5l_o21ai_1
X_10343_ _10343_/Y _06229_/B _06236_/A _09557_/A _10479_/C _06234_/A VPWR VGND sg13cmos5l_a221oi_1
XFILLER_105_572 VPWR VGND sg13cmos5l_decap_8
XFILLER_97_209 VPWR VGND sg13cmos5l_fill_1
X_11606__1376 _11606_/RESET_B VPWR VGND sg13cmos5l_tiehi
X_10274_ _10277_/B _10273_/B _10273_/C _10264_/Y VPWR VGND sg13cmos5l_a21oi_1
X_10941__1041 _10941_/RESET_B VPWR VGND sg13cmos5l_tiehi
Xfanout480 _09824_/A2 fanout481/X VPWR VGND sg13cmos5l_buf_1
XFILLER_78_489 VPWR VGND sg13cmos5l_decap_8
Xfanout491 _10135_/B _10149_/B VPWR VGND sg13cmos5l_buf_1
XFILLER_47_832 VPWR VGND sg13cmos5l_fill_2
XFILLER_48_94 VPWR VGND sg13cmos5l_fill_1
XFILLER_46_331 VPWR VGND sg13cmos5l_decap_8
XFILLER_0_35 VPWR VGND sg13cmos5l_decap_8
XFILLER_62_835 VPWR VGND sg13cmos5l_fill_1
XFILLER_62_824 VPWR VGND sg13cmos5l_decap_8
XFILLER_34_526 VPWR VGND sg13cmos5l_fill_1
XFILLER_64_71 VPWR VGND sg13cmos5l_decap_4
XFILLER_0_79 VPWR VGND sg13cmos5l_decap_8
XFILLER_9_11 VPWR VGND sg13cmos5l_decap_4
X_11194__1707 _11194_/RESET_B VPWR VGND sg13cmos5l_tiehi
XFILLER_15_751 VPWR VGND sg13cmos5l_fill_1
X_11230__1671 _11230_/RESET_B VPWR VGND sg13cmos5l_tiehi
XFILLER_15_795 VPWR VGND sg13cmos5l_fill_2
X_11728_ _11728_/Q clkload22/A _11728_/D _11728_/RESET_B VPWR VGND sg13cmos5l_dfrbpq_1
X_11659_ _11659_/Q clkload12/A _11659_/D _11659_/RESET_B VPWR VGND sg13cmos5l_dfrbpq_1
XFILLER_30_798 VPWR VGND sg13cmos5l_fill_2
X_11002__980 _11002_/RESET_B VPWR VGND sg13cmos5l_tiehi
XFILLER_7_972 VPWR VGND sg13cmos5l_decap_8
Xhold2318 _08027_/A _11103_/Q VPWR VGND sg13cmos5l_dlygate4sd3_1
XFILLER_97_721 VPWR VGND sg13cmos5l_fill_2
X_08870_ _11432_/D _08868_/Y _08869_/Y _08858_/Y VPWR VGND sg13cmos5l_o21ai_1
Xhold2307 _07694_/A _10941_/Q VPWR VGND sg13cmos5l_dlygate4sd3_1
Xhold2329 _08521_/A _11345_/Q VPWR VGND sg13cmos5l_dlygate4sd3_1
X_07821_ _11002_/D fanout96/X _07834_/B _07820_/Y VPWR VGND sg13cmos5l_o21ai_1
XFILLER_96_297 VPWR VGND sg13cmos5l_fill_2
XFILLER_37_331 VPWR VGND sg13cmos5l_fill_2
X_07752_ _07752_/Y _07752_/A _07760_/B VPWR VGND sg13cmos5l_nor2_1
X_11641__1325 _11641_/RESET_B VPWR VGND sg13cmos5l_tiehi
X_07683_ _10935_/D _08534_/A1 _07682_/B _07682_/Y VPWR VGND sg13cmos5l_a21oi_1
X_06703_ _06703_/Y _10329_/A _06368_/Y _06702_/Y VPWR VGND sg13cmos5l_o21ai_1
XFILLER_37_397 VPWR VGND sg13cmos5l_decap_8
X_09422_ _09422_/Y _09633_/A _09422_/B _09422_/C VPWR VGND sg13cmos5l_nor3_1
X_06634_ _06634_/Y _06177_/B _06614_/A _06400_/D _06353_/B _06633_/Y VPWR VGND sg13cmos5l_a221oi_1
X_09353_ _09353_/Y _09193_/Y _09345_/Y _09352_/Y VPWR VGND sg13cmos5l_a21oi_1
XFILLER_100_14 VPWR VGND sg13cmos5l_decap_8
X_08304_ _11238_/D fanout55/X _08309_/B _08303_/Y VPWR VGND sg13cmos5l_a21oi_1
X_06565_ _06566_/B _06573_/A1 _11676_/Q _10886_/Q _06134_/B VPWR VGND sg13cmos5l_a22oi_1
XFILLER_33_570 VPWR VGND sg13cmos5l_fill_2
XFILLER_33_581 VPWR VGND sg13cmos5l_decap_4
X_09284_ _09305_/B _06861_/A _06838_/A _09298_/A VPWR VGND sg13cmos5l_o21ai_1
X_06496_ _06496_/X _11117_/Q _11085_/Q _11053_/Q _11021_/Q _09544_/S _09707_/S1 VPWR
+ VGND sg13cmos5l_mux4_1
X_08235_ _11204_/D fanout60/X _08234_/B _08234_/Y VPWR VGND sg13cmos5l_o21ai_1
X_08166_ _11170_/D fanout63/X _08173_/B _08165_/Y VPWR VGND sg13cmos5l_a21oi_1
X_07117_ _07117_/Y hold2802/X _07120_/A2 _06091_/A VPWR VGND sg13cmos5l_o21ai_1
XFILLER_106_336 VPWR VGND sg13cmos5l_decap_8
X_08097_ _11137_/D fanout67/X _08096_/B _08096_/Y VPWR VGND sg13cmos5l_o21ai_1
XFILLER_79_209 VPWR VGND sg13cmos5l_decap_8
X_07048_ _07048_/X hold2492/X _08626_/A1 _07047_/Y VPWR VGND sg13cmos5l_a21o_1
XFILLER_0_636 VPWR VGND sg13cmos5l_decap_8
X_11272__1629 _11272_/RESET_B VPWR VGND sg13cmos5l_tiehi
Xhold2830 hold2830/X _11633_/Q VPWR VGND sg13cmos5l_dlygate4sd3_1
Xhold2841 _06184_/A _11494_/Q VPWR VGND sg13cmos5l_dlygate4sd3_1
XFILLER_87_286 VPWR VGND sg13cmos5l_decap_4
Xhold2874 hold2874/X _11747_/Q VPWR VGND sg13cmos5l_dlygate4sd3_1
X_08999_ _08999_/Y _09061_/A _08999_/B VPWR VGND sg13cmos5l_nand2_1
Xhold2863 _11497_/D _10088_/X VPWR VGND sg13cmos5l_dlygate4sd3_1
Xhold2852 _11468_/D _09564_/Y VPWR VGND sg13cmos5l_dlygate4sd3_1
Xhold2885 hold2885/X _11698_/Q VPWR VGND sg13cmos5l_dlygate4sd3_1
Xhold2896 hold2896/X _10831_/Q VPWR VGND sg13cmos5l_dlygate4sd3_1
XFILLER_29_865 VPWR VGND sg13cmos5l_fill_2
XFILLER_55_150 VPWR VGND sg13cmos5l_decap_8
X_10961_ _10961_/Q clkload38/A _10961_/D _10961_/RESET_B VPWR VGND sg13cmos5l_dfrbpq_1
XFILLER_28_375 VPWR VGND sg13cmos5l_decap_8
X_11589__1431 _11589_/RESET_B VPWR VGND sg13cmos5l_tiehi
XFILLER_71_643 VPWR VGND sg13cmos5l_fill_2
XFILLER_44_835 VPWR VGND sg13cmos5l_fill_2
XFILLER_71_654 VPWR VGND sg13cmos5l_decap_8
X_10892_ _10892_/Q _11352_/CLK _10892_/D _10892_/RESET_B VPWR VGND sg13cmos5l_dfrbpq_1
XFILLER_12_721 VPWR VGND sg13cmos5l_decap_8
XFILLER_34_63 VPWR VGND sg13cmos5l_fill_2
XFILLER_15_1007 VPWR VGND sg13cmos5l_decap_8
X_11513_ _11513_/Q _11715_/CLK _11513_/D _11513_/RESET_B VPWR VGND sg13cmos5l_dfrbpq_1
XFILLER_8_747 VPWR VGND sg13cmos5l_decap_8
XFILLER_8_736 VPWR VGND sg13cmos5l_fill_2
X_11444_ _11444_/Q clkload55/A _11444_/D _11444_/RESET_B VPWR VGND sg13cmos5l_dfrbpq_1
X_10959__1023 _10959_/RESET_B VPWR VGND sg13cmos5l_tiehi
X_11375_ _11375_/Q _11766_/CLK _11375_/D _11375_/RESET_B VPWR VGND sg13cmos5l_dfrbpq_1
X_11763__924 _11763_/RESET_B VPWR VGND sg13cmos5l_tiehi
X_10326_ _11527_/D _10326_/A _10326_/B _10326_/C VPWR VGND sg13cmos5l_and3_1
XFILLER_4_986 VPWR VGND sg13cmos5l_decap_8
XFILLER_3_452 VPWR VGND sg13cmos5l_decap_4
XFILLER_79_732 VPWR VGND sg13cmos5l_decap_4
X_10257_ _10257_/Y _10279_/A _10279_/B VPWR VGND sg13cmos5l_nor2_1
XFILLER_3_496 VPWR VGND sg13cmos5l_decap_8
XFILLER_105_391 VPWR VGND sg13cmos5l_decap_8
XFILLER_61_1027 VPWR VGND sg13cmos5l_fill_2
XFILLER_39_618 VPWR VGND sg13cmos5l_decap_8
X_11248__1653 _11248_/RESET_B VPWR VGND sg13cmos5l_tiehi
XFILLER_66_426 VPWR VGND sg13cmos5l_decap_4
XFILLER_66_415 VPWR VGND sg13cmos5l_fill_1
X_10188_ _10188_/Y _10694_/A _10188_/B VPWR VGND sg13cmos5l_nor2_1
XFILLER_82_908 VPWR VGND sg13cmos5l_fill_1
XFILLER_74_492 VPWR VGND sg13cmos5l_decap_8
XFILLER_46_161 VPWR VGND sg13cmos5l_decap_8
XFILLER_90_985 VPWR VGND sg13cmos5l_fill_1
XFILLER_62_654 VPWR VGND sg13cmos5l_decap_8
XFILLER_61_175 VPWR VGND sg13cmos5l_decap_8
X_06350_ _06351_/C _06618_/B _06618_/C _06192_/B VPWR VGND sg13cmos5l_o21ai_1
XFILLER_30_540 VPWR VGND sg13cmos5l_fill_1
X_06281_ _06602_/C _07020_/A _09180_/A _06590_/A _06279_/X _06276_/Y VPWR VGND sg13cmos5l_a221oi_1
X_08020_ _11099_/D fanout83/X _08041_/B _08019_/Y VPWR VGND sg13cmos5l_a21oi_1
XFILLER_104_818 VPWR VGND sg13cmos5l_decap_8
X_09971_ _09971_/X _09998_/A _09998_/B VPWR VGND sg13cmos5l_and2_1
X_08922_ _08922_/Y _08922_/A _08922_/B VPWR VGND sg13cmos5l_nand2_1
XFILLER_97_562 VPWR VGND sg13cmos5l_fill_1
Xhold2126 _08567_/A _11368_/Q VPWR VGND sg13cmos5l_dlygate4sd3_1
Xhold2115 _07712_/A _10950_/Q VPWR VGND sg13cmos5l_dlygate4sd3_1
Xhold2104 _08301_/A _11237_/Q VPWR VGND sg13cmos5l_dlygate4sd3_1
Xhold2137 _10725_/A _11559_/Q VPWR VGND sg13cmos5l_dlygate4sd3_1
XFILLER_69_264 VPWR VGND sg13cmos5l_fill_2
Xhold2159 _07710_/A _10949_/Q VPWR VGND sg13cmos5l_dlygate4sd3_1
X_08853_ _08853_/Y _08853_/A _08853_/B VPWR VGND sg13cmos5l_xnor2_1
Xhold2148 _07692_/A _10940_/Q VPWR VGND sg13cmos5l_dlygate4sd3_1
XFILLER_69_297 VPWR VGND sg13cmos5l_fill_1
X_05996_ _05996_/Y _05996_/A _08614_/B _08615_/A VPWR VGND sg13cmos5l_nor3_1
X_08784_ _08784_/X _08784_/A _08784_/B VPWR VGND sg13cmos5l_or2_1
X_07804_ _07804_/Y _07804_/A _07808_/B VPWR VGND sg13cmos5l_nand2_1
XFILLER_29_128 VPWR VGND sg13cmos5l_fill_2
XFILLER_29_139 VPWR VGND sg13cmos5l_decap_8
XFILLER_84_267 VPWR VGND sg13cmos5l_decap_8
XFILLER_72_418 VPWR VGND sg13cmos5l_decap_8
X_07735_ _10960_/D _08063_/A1 _07748_/B _07734_/Y VPWR VGND sg13cmos5l_a21oi_1
XFILLER_53_621 VPWR VGND sg13cmos5l_decap_4
XFILLER_38_684 VPWR VGND sg13cmos5l_fill_1
XFILLER_26_846 VPWR VGND sg13cmos5l_decap_4
XFILLER_80_462 VPWR VGND sg13cmos5l_decap_8
XFILLER_80_451 VPWR VGND sg13cmos5l_decap_8
XFILLER_53_676 VPWR VGND sg13cmos5l_fill_2
XFILLER_53_665 VPWR VGND sg13cmos5l_decap_8
X_07666_ _07666_/Y _07666_/A _07684_/B VPWR VGND sg13cmos5l_nor2_1
X_09405_ _09481_/B _09405_/A _09456_/B VPWR VGND sg13cmos5l_nor2_1
XFILLER_80_473 VPWR VGND sg13cmos5l_fill_2
X_07597_ _07604_/B _11415_/Q _11414_/Q _07597_/C VPWR VGND sg13cmos5l_nand3_1
X_06617_ _06619_/A _06274_/Y _06284_/Y _06639_/A VPWR VGND sg13cmos5l_o21ai_1
X_09336_ _09403_/B _11458_/Q _09336_/B VPWR VGND sg13cmos5l_nand2b_1
X_06548_ _06548_/Y _06548_/A _06548_/B VPWR VGND sg13cmos5l_nand2_1
X_09267_ _10031_/B _09261_/Y _10005_/B _09260_/Y VPWR VGND sg13cmos5l_o21ai_1
X_11326__1575 _11326_/RESET_B VPWR VGND sg13cmos5l_tiehi
X_08218_ _08218_/Y _08218_/A _08218_/B VPWR VGND sg13cmos5l_nand2_1
X_06479_ _06479_/Y _11308_/Q _09529_/B VPWR VGND sg13cmos5l_nand2b_1
X_11747__908 _11747_/RESET_B VPWR VGND sg13cmos5l_tiehi
XFILLER_5_728 VPWR VGND sg13cmos5l_decap_8
X_09198_ _09206_/A _09198_/A _10837_/Q VPWR VGND sg13cmos5l_xnor2_1
XFILLER_106_133 VPWR VGND sg13cmos5l_decap_8
X_08149_ _08149_/Y _08149_/A _08163_/B VPWR VGND sg13cmos5l_nor2_1
X_11160_ _11160_/Q _11349_/CLK _11160_/D _11160_/RESET_B VPWR VGND sg13cmos5l_dfrbpq_1
XFILLER_96_14 VPWR VGND sg13cmos5l_decap_8
X_11091_ _11091_/Q clkload8/A _11091_/D _11091_/RESET_B VPWR VGND sg13cmos5l_dfrbpq_1
X_10111_ _10111_/X _10114_/A1 _09720_/B _10110_/Y VPWR VGND sg13cmos5l_a21o_1
X_10042_ _10042_/Y _10920_/Q _09894_/B _10042_/B1 VPWR VGND sg13cmos5l_a21oi_1
XFILLER_88_551 VPWR VGND sg13cmos5l_fill_1
XFILLER_0_444 VPWR VGND sg13cmos5l_fill_1
XFILLER_1_967 VPWR VGND sg13cmos5l_decap_8
XFILLER_49_938 VPWR VGND sg13cmos5l_decap_8
XFILLER_0_466 VPWR VGND sg13cmos5l_fill_1
Xhold2671 _07201_/A _11713_/Q VPWR VGND sg13cmos5l_dlygate4sd3_1
XFILLER_76_768 VPWR VGND sg13cmos5l_decap_8
Xhold2660 _06881_/A _11723_/Q VPWR VGND sg13cmos5l_dlygate4sd3_1
Xhold2682 _11386_/D _08641_/Y VPWR VGND sg13cmos5l_dlygate4sd3_1
XFILLER_29_63 VPWR VGND sg13cmos5l_fill_1
XFILLER_29_640 VPWR VGND sg13cmos5l_fill_2
Xhold1981 _08354_/A _11263_/Q VPWR VGND sg13cmos5l_dlygate4sd3_1
X_11730__1220 _11730_/RESET_B VPWR VGND sg13cmos5l_tiehi
Xhold1970 _08871_/A _11433_/Q VPWR VGND sg13cmos5l_dlygate4sd3_1
X_10812__949 _10812_/RESET_B VPWR VGND sg13cmos5l_tiehi
XFILLER_29_673 VPWR VGND sg13cmos5l_fill_2
Xhold2693 _10069_/A _11492_/Q VPWR VGND sg13cmos5l_dlygate4sd3_1
Xhold1992 _08458_/A _11314_/Q VPWR VGND sg13cmos5l_dlygate4sd3_1
XFILLER_16_301 VPWR VGND sg13cmos5l_decap_8
XFILLER_28_172 VPWR VGND sg13cmos5l_decap_8
X_10944_ _10944_/Q clkload57/A _10944_/D _10944_/RESET_B VPWR VGND sg13cmos5l_dfrbpq_1
XFILLER_90_248 VPWR VGND sg13cmos5l_fill_1
XFILLER_72_952 VPWR VGND sg13cmos5l_decap_4
XFILLER_43_131 VPWR VGND sg13cmos5l_decap_4
XFILLER_16_356 VPWR VGND sg13cmos5l_fill_2
XFILLER_16_367 VPWR VGND sg13cmos5l_fill_2
XFILLER_28_194 VPWR VGND sg13cmos5l_decap_8
X_10875_ _10875_/Q clkload7/A _10875_/D _10875_/RESET_B VPWR VGND sg13cmos5l_dfrbpq_1
XFILLER_31_326 VPWR VGND sg13cmos5l_decap_8
X_10891__1091 _10891_/RESET_B VPWR VGND sg13cmos5l_tiehi
XFILLER_8_522 VPWR VGND sg13cmos5l_decap_4
XFILLER_77_8 VPWR VGND sg13cmos5l_fill_2
XFILLER_61_72 VPWR VGND sg13cmos5l_fill_2
XFILLER_8_588 VPWR VGND sg13cmos5l_decap_8
XANTENNA_5 _11732_/Q VPWR VGND sg13cmos5l_antennanp
X_11427_ _11427_/Q clkload14/A _11427_/D _11427_/RESET_B VPWR VGND sg13cmos5l_dfrbpq_1
XFILLER_6_56 VPWR VGND sg13cmos5l_decap_4
XFILLER_99_816 VPWR VGND sg13cmos5l_decap_8
X_11358_ _11358_/Q clkload52/A _11358_/D _11358_/RESET_B VPWR VGND sg13cmos5l_dfrbpq_1
XFILLER_98_348 VPWR VGND sg13cmos5l_decap_8
XFILLER_98_337 VPWR VGND sg13cmos5l_fill_1
XFILLER_98_326 VPWR VGND sg13cmos5l_fill_2
X_10309_ _10538_/B _10479_/A _10309_/B VPWR VGND sg13cmos5l_xnor2_1
X_11289_ _11289_/Q clkload39/A _11289_/D _11289_/RESET_B VPWR VGND sg13cmos5l_dfrbpq_1
XFILLER_39_415 VPWR VGND sg13cmos5l_decap_8
XFILLER_94_587 VPWR VGND sg13cmos5l_decap_4
XFILLER_82_727 VPWR VGND sg13cmos5l_fill_2
XFILLER_48_960 VPWR VGND sg13cmos5l_decap_4
XFILLER_26_109 VPWR VGND sg13cmos5l_fill_1
XFILLER_63_930 VPWR VGND sg13cmos5l_fill_2
X_11376__1524 _11376_/RESET_B VPWR VGND sg13cmos5l_tiehi
X_07520_ _08689_/B _11531_/Q _10806_/Q _07527_/S VPWR VGND sg13cmos5l_mux2_1
XFILLER_81_248 VPWR VGND sg13cmos5l_fill_2
XFILLER_63_974 VPWR VGND sg13cmos5l_decap_8
XFILLER_62_451 VPWR VGND sg13cmos5l_decap_8
X_07451_ _10891_/D _07640_/B _08053_/A1 _07450_/Y VPWR VGND sg13cmos5l_a21oi_1
XFILLER_90_793 VPWR VGND sg13cmos5l_fill_2
XFILLER_63_996 VPWR VGND sg13cmos5l_fill_1
XFILLER_23_827 VPWR VGND sg13cmos5l_fill_1
XFILLER_96_0 VPWR VGND sg13cmos5l_decap_8
X_06402_ _06402_/Y _10620_/A _06402_/B VPWR VGND sg13cmos5l_xnor2_1
X_07382_ _07382_/Y _11479_/Q _07400_/A2 _07381_/Y VPWR VGND sg13cmos5l_a21oi_1
XFILLER_50_657 VPWR VGND sg13cmos5l_fill_2
XFILLER_22_326 VPWR VGND sg13cmos5l_decap_8
X_11565__1417 _11565_/RESET_B VPWR VGND sg13cmos5l_tiehi
X_06333_ _06333_/Y _11517_/Q _09940_/A VPWR VGND sg13cmos5l_nor2_1
X_09121_ _09121_/X _09121_/A _09121_/B VPWR VGND sg13cmos5l_or2_1
XFILLER_31_871 VPWR VGND sg13cmos5l_decap_4
X_11496__1191 _11496_/RESET_B VPWR VGND sg13cmos5l_tiehi
X_06264_ _06389_/A _06264_/A _06264_/B VPWR VGND sg13cmos5l_or2_1
X_09052_ _09052_/Y _09052_/A _09068_/A VPWR VGND sg13cmos5l_nor2_1
X_06195_ _06582_/A _11488_/Q _07077_/A VPWR VGND sg13cmos5l_xnor2_1
X_08003_ _08003_/Y _08003_/A _08011_/B VPWR VGND sg13cmos5l_nor2_1
XFILLER_104_626 VPWR VGND sg13cmos5l_decap_8
XFILLER_106_35 VPWR VGND sg13cmos5l_decap_8
XFILLER_103_147 VPWR VGND sg13cmos5l_decap_8
Xheichips26_RiMaX_1829 uio_oe[14] VPWR VGND sg13cmos5l_tiehi
X_09954_ _09960_/B _09950_/Y _09951_/Y _09952_/Y _09953_/Y _09983_/C1 VPWR VGND sg13cmos5l_a221oi_1
XFILLER_44_1000 VPWR VGND sg13cmos5l_fill_2
X_09885_ _09885_/Y _09885_/A _09885_/B VPWR VGND sg13cmos5l_nand2_1
XFILLER_58_724 VPWR VGND sg13cmos5l_fill_2
X_08905_ _08905_/Y _08905_/A _08936_/B VPWR VGND sg13cmos5l_nand2_1
XFILLER_97_392 VPWR VGND sg13cmos5l_decap_4
XFILLER_85_554 VPWR VGND sg13cmos5l_fill_2
XFILLER_58_757 VPWR VGND sg13cmos5l_decap_8
XFILLER_57_212 VPWR VGND sg13cmos5l_decap_8
X_08836_ _08861_/B _11381_/Q _08841_/A VPWR VGND sg13cmos5l_xnor2_1
XFILLER_46_908 VPWR VGND sg13cmos5l_fill_1
XFILLER_85_576 VPWR VGND sg13cmos5l_decap_8
XFILLER_73_727 VPWR VGND sg13cmos5l_decap_8
XFILLER_45_418 VPWR VGND sg13cmos5l_fill_1
XFILLER_100_898 VPWR VGND sg13cmos5l_decap_4
X_08767_ _09138_/B _08767_/A _08767_/B VPWR VGND sg13cmos5l_nand2_1
X_05979_ _09164_/B _10850_/Q VPWR VGND sg13cmos5l_inv_1
XFILLER_39_993 VPWR VGND sg13cmos5l_decap_8
X_07718_ _07718_/Y _07718_/A _07718_/B VPWR VGND sg13cmos5l_nor2_1
XFILLER_81_760 VPWR VGND sg13cmos5l_decap_4
X_08698_ _11405_/D _08698_/A VPWR VGND sg13cmos5l_inv_1
X_07649_ _07650_/B _11423_/Q _07649_/B VPWR VGND sg13cmos5l_xor2_1
XFILLER_54_985 VPWR VGND sg13cmos5l_fill_1
XFILLER_25_164 VPWR VGND sg13cmos5l_fill_1
XFILLER_26_698 VPWR VGND sg13cmos5l_fill_1
X_10660_ _10661_/A _10659_/A _10659_/B _10681_/B2 VPWR VGND sg13cmos5l_o21ai_1
XFILLER_41_635 VPWR VGND sg13cmos5l_decap_8
XFILLER_40_123 VPWR VGND sg13cmos5l_fill_1
X_09319_ _09319_/Y _09319_/A _09335_/B _09319_/C VPWR VGND sg13cmos5l_nand3_1
XFILLER_40_156 VPWR VGND sg13cmos5l_fill_2
XFILLER_40_145 VPWR VGND sg13cmos5l_decap_8
X_10591_ _10633_/B _10591_/A _10854_/Q VPWR VGND sg13cmos5l_xor2_1
XFILLER_21_370 VPWR VGND sg13cmos5l_decap_8
XFILLER_5_503 VPWR VGND sg13cmos5l_fill_2
X_11212_ _11212_/Q clkload39/A _11212_/D _11212_/RESET_B VPWR VGND sg13cmos5l_dfrbpq_1
Xoutput42 uo_out[3] _06539_/Y VPWR VGND sg13cmos5l_buf_1
Xoutput31 uio_out[8] _11680_/Q VPWR VGND sg13cmos5l_buf_1
X_11143_ _11143_/Q _11364_/CLK _11143_/D _11143_/RESET_B VPWR VGND sg13cmos5l_dfrbpq_1
XFILLER_95_329 VPWR VGND sg13cmos5l_fill_1
X_11074_ _11074_/Q _11362_/CLK _11074_/D _11074_/RESET_B VPWR VGND sg13cmos5l_dfrbpq_1
XFILLER_49_713 VPWR VGND sg13cmos5l_decap_4
X_10025_ _10026_/B _09264_/A _09970_/B _09941_/B VPWR VGND sg13cmos5l_o21ai_1
XFILLER_0_285 VPWR VGND sg13cmos5l_fill_1
XFILLER_76_587 VPWR VGND sg13cmos5l_fill_1
Xhold2490 hold2490/X _11672_/Q VPWR VGND sg13cmos5l_dlygate4sd3_1
XFILLER_91_535 VPWR VGND sg13cmos5l_fill_2
XFILLER_60_922 VPWR VGND sg13cmos5l_fill_1
X_10927_ _10927_/Q clkload44/A _10927_/D _10927_/RESET_B VPWR VGND sg13cmos5l_dfrbpq_1
X_11658__1306 _11658_/RESET_B VPWR VGND sg13cmos5l_tiehi
XFILLER_16_175 VPWR VGND sg13cmos5l_fill_1
XFILLER_31_134 VPWR VGND sg13cmos5l_fill_2
X_10858_ _10858_/Q clkload49/A _10858_/D _10858_/RESET_B VPWR VGND sg13cmos5l_dfrbpq_1
X_10789_ _10789_/Y _10789_/A _10791_/B VPWR VGND sg13cmos5l_nand2_1
XFILLER_8_352 VPWR VGND sg13cmos5l_decap_8
XFILLER_9_875 VPWR VGND sg13cmos5l_fill_1
XFILLER_68_4 VPWR VGND sg13cmos5l_fill_2
XFILLER_98_112 VPWR VGND sg13cmos5l_decap_8
X_10793__930 _10793_/RESET_B VPWR VGND sg13cmos5l_tiehi
Xfanout309 _08516_/A1 _08321_/A1 VPWR VGND sg13cmos5l_buf_1
XFILLER_67_510 VPWR VGND sg13cmos5l_fill_1
X_06951_ _06952_/B _11554_/Q _08614_/B VPWR VGND sg13cmos5l_nand2_1
XFILLER_39_234 VPWR VGND sg13cmos5l_decap_8
X_09670_ _09670_/Y _10477_/A _09725_/B _09669_/Y _09775_/A VPWR VGND sg13cmos5l_a22oi_1
X_05902_ _06209_/A _05902_/A VPWR VGND sg13cmos5l_inv_1
XFILLER_82_502 VPWR VGND sg13cmos5l_decap_8
X_06882_ _06882_/Y _05944_/Y _07088_/S _06881_/Y VPWR VGND sg13cmos5l_a21oi_1
X_08621_ _08625_/C _11553_/Q _08621_/B _08624_/A _08621_/D VPWR VGND sg13cmos5l_nor4_1
XFILLER_11_0 VPWR VGND sg13cmos5l_decap_8
XFILLER_28_908 VPWR VGND sg13cmos5l_fill_1
XFILLER_82_535 VPWR VGND sg13cmos5l_fill_1
XFILLER_39_289 VPWR VGND sg13cmos5l_decap_8
X_08552_ _11360_/D fanout72/X _08555_/B _08551_/Y VPWR VGND sg13cmos5l_a21oi_1
XFILLER_54_248 VPWR VGND sg13cmos5l_fill_1
XFILLER_36_974 VPWR VGND sg13cmos5l_decap_8
X_08483_ _11326_/D fanout77/X _08504_/B _08482_/Y VPWR VGND sg13cmos5l_o21ai_1
XFILLER_74_1015 VPWR VGND sg13cmos5l_decap_8
X_07503_ _07503_/Y _07503_/A _07526_/B VPWR VGND sg13cmos5l_nor2_1
X_07434_ _08441_/A _08376_/A _08376_/B VPWR VGND sg13cmos5l_nor2_1
XFILLER_50_410 VPWR VGND sg13cmos5l_fill_2
X_07365_ _07365_/Y _07365_/A _07365_/B VPWR VGND sg13cmos5l_nor2_1
X_09104_ _09105_/C _09104_/A _09104_/B _09112_/B VPWR VGND sg13cmos5l_nor3_1
X_07296_ _07296_/Y _08858_/A _07296_/B VPWR VGND sg13cmos5l_nand2_1
X_06316_ _06710_/A _06709_/A _06701_/B _06314_/Y VPWR VGND sg13cmos5l_o21ai_1
X_06247_ _06429_/A _11516_/Q _09262_/A VPWR VGND sg13cmos5l_nor2_1
X_09035_ _09035_/X _09069_/B _09035_/B VPWR VGND sg13cmos5l_xor2_1
XFILLER_11_1021 VPWR VGND sg13cmos5l_decap_8
XFILLER_105_946 VPWR VGND sg13cmos5l_decap_8
XFILLER_104_423 VPWR VGND sg13cmos5l_decap_8
X_06178_ _06645_/A _06642_/A _06353_/B VPWR VGND sg13cmos5l_nor2_1
XFILLER_104_434 VPWR VGND sg13cmos5l_fill_2
XFILLER_78_819 VPWR VGND sg13cmos5l_decap_8
X_11442__1406 _11442_/RESET_B VPWR VGND sg13cmos5l_tiehi
X_09937_ _09937_/Y _06476_/B _09931_/Y _09936_/Y _10049_/A1 _09933_/Y VPWR VGND sg13cmos5l_a221oi_1
XFILLER_77_307 VPWR VGND sg13cmos5l_fill_2
Xfanout810 _08921_/A _10793_/Q VPWR VGND sg13cmos5l_buf_1
Xfanout821 _07145_/B1 _07071_/A VPWR VGND sg13cmos5l_buf_1
Xfanout832 _10488_/A _10503_/A VPWR VGND sg13cmos5l_buf_1
XFILLER_86_830 VPWR VGND sg13cmos5l_fill_2
X_09868_ _09868_/Y _10914_/Q _09984_/B _09987_/B1 VPWR VGND sg13cmos5l_a21oi_1
X_09799_ _09799_/Y _11327_/Q _10021_/A2 _09798_/X VPWR VGND sg13cmos5l_o21ai_1
XFILLER_86_896 VPWR VGND sg13cmos5l_decap_8
XFILLER_73_524 VPWR VGND sg13cmos5l_decap_8
X_08819_ _08819_/Y _08819_/A _08819_/B VPWR VGND sg13cmos5l_nor2_1
XFILLER_46_738 VPWR VGND sg13cmos5l_fill_1
XFILLER_39_790 VPWR VGND sg13cmos5l_fill_2
XFILLER_18_418 VPWR VGND sg13cmos5l_fill_1
XFILLER_73_579 VPWR VGND sg13cmos5l_fill_2
X_11761_ _11761_/Q _11766_/CLK _11761_/D _11761_/RESET_B VPWR VGND sg13cmos5l_dfrbpq_1
XFILLER_42_922 VPWR VGND sg13cmos5l_fill_1
X_10712_ _10731_/C _10731_/A _10712_/B VPWR VGND sg13cmos5l_nor2_1
XFILLER_53_281 VPWR VGND sg13cmos5l_fill_2
XFILLER_42_933 VPWR VGND sg13cmos5l_fill_1
X_11692_ _11692_/Q clkload30/A _11692_/D _11692_/RESET_B VPWR VGND sg13cmos5l_dfrbpq_1
XFILLER_14_679 VPWR VGND sg13cmos5l_fill_2
X_10643_ _10659_/A _10643_/A _10643_/B VPWR VGND sg13cmos5l_nor2_1
XFILLER_41_487 VPWR VGND sg13cmos5l_fill_1
X_10574_ _10578_/A _10474_/A _10569_/X _10573_/Y VPWR VGND sg13cmos5l_a21oi_1
XFILLER_42_96 VPWR VGND sg13cmos5l_fill_2
XFILLER_6_845 VPWR VGND sg13cmos5l_fill_2
XFILLER_6_834 VPWR VGND sg13cmos5l_decap_8
XFILLER_5_355 VPWR VGND sg13cmos5l_decap_8
X_10818__955 _10818_/RESET_B VPWR VGND sg13cmos5l_tiehi
X_11126_ _11126_/Q clkload33/A _11126_/D _11126_/RESET_B VPWR VGND sg13cmos5l_dfrbpq_1
XFILLER_49_532 VPWR VGND sg13cmos5l_decap_4
X_11106__1795 _11106_/RESET_B VPWR VGND sg13cmos5l_tiehi
XFILLER_92_811 VPWR VGND sg13cmos5l_fill_2
X_11057_ _11057_/Q _11265_/CLK _11057_/D _11057_/RESET_B VPWR VGND sg13cmos5l_dfrbpq_1
X_10008_ _10008_/Y _11143_/Q _10012_/B _10021_/B1 VPWR VGND sg13cmos5l_a21oi_1
XFILLER_76_373 VPWR VGND sg13cmos5l_fill_1
XFILLER_64_535 VPWR VGND sg13cmos5l_decap_8
XFILLER_45_782 VPWR VGND sg13cmos5l_decap_8
XFILLER_18_974 VPWR VGND sg13cmos5l_fill_2
XFILLER_18_985 VPWR VGND sg13cmos5l_fill_1
X_11285__1616 _11285_/RESET_B VPWR VGND sg13cmos5l_tiehi
XFILLER_33_911 VPWR VGND sg13cmos5l_decap_8
X_11321__1580 _11321_/RESET_B VPWR VGND sg13cmos5l_tiehi
XFILLER_33_944 VPWR VGND sg13cmos5l_decap_8
XFILLER_20_616 VPWR VGND sg13cmos5l_fill_1
XFILLER_60_796 VPWR VGND sg13cmos5l_fill_2
X_07150_ _11740_/D _05882_/Y _07150_/A2 _07149_/Y VPWR VGND sg13cmos5l_a21oi_1
X_07081_ _07081_/Y _10173_/A _07081_/B VPWR VGND sg13cmos5l_nor2_1
X_06101_ _06104_/C _07389_/A _07395_/A VPWR VGND sg13cmos5l_or2_1
XFILLER_9_672 VPWR VGND sg13cmos5l_decap_4
X_06032_ _06093_/A _08648_/A _06033_/B VPWR VGND sg13cmos5l_nor2_1
Xfanout128 _08500_/B _08441_/Y VPWR VGND sg13cmos5l_buf_1
XFILLER_59_307 VPWR VGND sg13cmos5l_fill_2
Xfanout117 _08468_/B _08466_/B VPWR VGND sg13cmos5l_buf_1
Xfanout106 _08337_/A1 _07524_/Y VPWR VGND sg13cmos5l_buf_1
X_07983_ _11081_/D fanout50/X _07982_/B _07982_/Y VPWR VGND sg13cmos5l_o21ai_1
Xfanout139 _08244_/B _08181_/Y VPWR VGND sg13cmos5l_buf_1
X_09722_ _09727_/C _09722_/A _09722_/B _09722_/C VPWR VGND sg13cmos5l_nor3_1
X_06934_ _06934_/Y _06844_/Y _06925_/Y _06933_/Y VPWR VGND sg13cmos5l_o21ai_1
XFILLER_28_716 VPWR VGND sg13cmos5l_decap_4
XFILLER_103_14 VPWR VGND sg13cmos5l_decap_8
XFILLER_95_682 VPWR VGND sg13cmos5l_fill_2
X_06865_ _06865_/Y _06865_/A _10785_/B VPWR VGND sg13cmos5l_nand2_1
XFILLER_83_844 VPWR VGND sg13cmos5l_fill_1
XFILLER_83_811 VPWR VGND sg13cmos5l_decap_8
XFILLER_68_896 VPWR VGND sg13cmos5l_decap_8
X_09653_ _09653_/Y _10938_/Q _09734_/B VPWR VGND sg13cmos5l_nand2_1
X_08604_ _08605_/B _09933_/A _08599_/X _08603_/Y VPWR VGND sg13cmos5l_o21ai_1
XFILLER_27_259 VPWR VGND sg13cmos5l_fill_1
X_09584_ _09584_/Y _09722_/A _09669_/A VPWR VGND sg13cmos5l_nor2_1
X_06796_ _06796_/Y _06796_/A _10762_/S VPWR VGND sg13cmos5l_nand2_1
XFILLER_82_387 VPWR VGND sg13cmos5l_fill_1
XFILLER_42_218 VPWR VGND sg13cmos5l_decap_4
XFILLER_24_922 VPWR VGND sg13cmos5l_fill_2
X_08535_ _08535_/Y _08535_/A _08535_/B VPWR VGND sg13cmos5l_nor2_1
XFILLER_42_229 VPWR VGND sg13cmos5l_decap_8
XFILLER_23_421 VPWR VGND sg13cmos5l_decap_4
XFILLER_24_944 VPWR VGND sg13cmos5l_decap_4
X_08466_ _08466_/Y _08466_/A _08466_/B VPWR VGND sg13cmos5l_nand2_1
XFILLER_23_454 VPWR VGND sg13cmos5l_decap_8
X_07417_ _07417_/Y _07415_/Y _08763_/A _07429_/B1 VPWR VGND sg13cmos5l_a21oi_1
XFILLER_10_115 VPWR VGND sg13cmos5l_fill_2
X_08397_ _08397_/Y _08397_/A _08397_/B VPWR VGND sg13cmos5l_nor2_1
XFILLER_11_649 VPWR VGND sg13cmos5l_fill_1
XFILLER_23_476 VPWR VGND sg13cmos5l_fill_1
XFILLER_23_498 VPWR VGND sg13cmos5l_decap_8
X_07348_ _10875_/D _07347_/B _07346_/Y _07347_/Y VPWR VGND sg13cmos5l_a21oi_1
X_07279_ _07279_/Y _07277_/Y _07278_/Y _06956_/B VPWR VGND sg13cmos5l_a21oi_1
XFILLER_105_710 VPWR VGND sg13cmos5l_decap_8
X_09018_ _09022_/C _09018_/A _09018_/B VPWR VGND sg13cmos5l_nor2_1
X_10290_ _10305_/B _10290_/A _10290_/B VPWR VGND sg13cmos5l_xnor2_1
XFILLER_3_826 VPWR VGND sg13cmos5l_fill_1
XFILLER_2_314 VPWR VGND sg13cmos5l_decap_8
XFILLER_104_231 VPWR VGND sg13cmos5l_decap_8
XFILLER_105_765 VPWR VGND sg13cmos5l_decap_4
X_11363__1538 _11363_/RESET_B VPWR VGND sg13cmos5l_tiehi
XFILLER_2_358 VPWR VGND sg13cmos5l_decap_4
XFILLER_77_115 VPWR VGND sg13cmos5l_decap_8
Xfanout651 _06134_/B _11762_/Q VPWR VGND sg13cmos5l_buf_1
Xfanout640 _06133_/B hold2923/X VPWR VGND sg13cmos5l_buf_1
XFILLER_101_960 VPWR VGND sg13cmos5l_decap_8
XFILLER_86_660 VPWR VGND sg13cmos5l_decap_8
Xfanout662 _10703_/A _10353_/A VPWR VGND sg13cmos5l_buf_1
Xfanout684 _10707_/A _11752_/Q VPWR VGND sg13cmos5l_buf_1
Xfanout673 _10526_/A _11754_/Q VPWR VGND sg13cmos5l_buf_1
XFILLER_86_693 VPWR VGND sg13cmos5l_fill_2
XFILLER_74_833 VPWR VGND sg13cmos5l_fill_1
XFILLER_59_896 VPWR VGND sg13cmos5l_fill_2
Xfanout695 _06779_/D hold2885/X VPWR VGND sg13cmos5l_buf_1
XFILLER_46_502 VPWR VGND sg13cmos5l_fill_1
X_11406__1478 _11406_/RESET_B VPWR VGND sg13cmos5l_tiehi
X_11567__1409 _11567_/RESET_B VPWR VGND sg13cmos5l_tiehi
X_11744_ _11744_/Q clkload22/A _11744_/D _11744_/RESET_B VPWR VGND sg13cmos5l_dfrbpq_1
XFILLER_14_465 VPWR VGND sg13cmos5l_decap_4
XFILLER_42_785 VPWR VGND sg13cmos5l_decap_4
X_11675_ _11675_/Q _11767_/CLK _11675_/D _11675_/RESET_B VPWR VGND sg13cmos5l_dfrbpq_1
X_10626_ _10626_/Y fanout85/X _10625_/X _10630_/B VPWR VGND sg13cmos5l_o21ai_1
X_10557_ _10557_/Y _10583_/A _10583_/B VPWR VGND sg13cmos5l_xnor2_1
X_10488_ _10489_/B _10488_/A _10488_/B VPWR VGND sg13cmos5l_nand2_1
XFILLER_5_152 VPWR VGND sg13cmos5l_fill_1
XFILLER_5_141 VPWR VGND sg13cmos5l_fill_2
XFILLER_97_903 VPWR VGND sg13cmos5l_fill_1
XFILLER_64_1014 VPWR VGND sg13cmos5l_decap_4
XFILLER_2_870 VPWR VGND sg13cmos5l_decap_8
X_11339__1562 _11339_/RESET_B VPWR VGND sg13cmos5l_tiehi
XFILLER_68_115 VPWR VGND sg13cmos5l_decap_8
X_11109_ _11109_/Q _11355_/CLK _11109_/D _11109_/RESET_B VPWR VGND sg13cmos5l_dfrbpq_1
XFILLER_49_340 VPWR VGND sg13cmos5l_fill_2
XFILLER_65_811 VPWR VGND sg13cmos5l_fill_1
X_06650_ _06650_/Y _06650_/A _06733_/B VPWR VGND sg13cmos5l_nor2_1
XFILLER_80_825 VPWR VGND sg13cmos5l_fill_1
XFILLER_80_814 VPWR VGND sg13cmos5l_decap_8
XFILLER_37_568 VPWR VGND sg13cmos5l_decap_8
XFILLER_18_760 VPWR VGND sg13cmos5l_fill_2
XFILLER_52_549 VPWR VGND sg13cmos5l_decap_4
XFILLER_52_538 VPWR VGND sg13cmos5l_decap_4
X_06581_ _06583_/A _06631_/S _11487_/Q VPWR VGND sg13cmos5l_nand2_1
X_08320_ _08320_/Y _08320_/A _08328_/B VPWR VGND sg13cmos5l_nand2_1
XFILLER_71_1018 VPWR VGND sg13cmos5l_fill_2
XFILLER_60_582 VPWR VGND sg13cmos5l_decap_8
XFILLER_20_424 VPWR VGND sg13cmos5l_decap_4
X_08251_ _08251_/Y _08251_/A _08293_/B VPWR VGND sg13cmos5l_nor2_1
X_07202_ _07204_/A _08774_/A _07202_/B _07202_/C VPWR VGND sg13cmos5l_nand3_1
X_08182_ _08182_/Y _08182_/A _08234_/B VPWR VGND sg13cmos5l_nand2_1
XFILLER_20_479 VPWR VGND sg13cmos5l_decap_8
X_07133_ _07133_/Y _10470_/A _07142_/A2 _07145_/B1 VPWR VGND sg13cmos5l_o21ai_1
XFILLER_9_491 VPWR VGND sg13cmos5l_fill_2
XFILLER_106_518 VPWR VGND sg13cmos5l_decap_8
X_07064_ _07065_/B _10180_/B _07007_/A VPWR VGND sg13cmos5l_nor2b_1
X_06015_ _10727_/B _10728_/B _11758_/Q _10704_/A VPWR VGND sg13cmos5l_and3_1
XFILLER_88_947 VPWR VGND sg13cmos5l_fill_1
XFILLER_101_234 VPWR VGND sg13cmos5l_decap_4
XFILLER_75_608 VPWR VGND sg13cmos5l_decap_8
X_07966_ _07966_/Y _07966_/A _07966_/B VPWR VGND sg13cmos5l_nand2_1
X_11653__1311 _11653_/RESET_B VPWR VGND sg13cmos5l_tiehi
X_06917_ _06917_/Y _11690_/Q _06917_/B VPWR VGND sg13cmos5l_nand2b_1
XFILLER_68_682 VPWR VGND sg13cmos5l_decap_8
XFILLER_56_811 VPWR VGND sg13cmos5l_decap_8
X_09705_ _09706_/B _09704_/A _09704_/B _09755_/A VPWR VGND sg13cmos5l_a21oi_1
XFILLER_28_524 VPWR VGND sg13cmos5l_decap_4
X_07897_ _07897_/Y _07897_/A _07899_/B VPWR VGND sg13cmos5l_nor2_1
XFILLER_55_332 VPWR VGND sg13cmos5l_fill_2
XFILLER_55_321 VPWR VGND sg13cmos5l_decap_8
X_09636_ _09636_/Y _05969_/Y _09529_/B _09635_/Y VPWR VGND sg13cmos5l_a21oi_1
XFILLER_28_546 VPWR VGND sg13cmos5l_decap_8
X_06848_ _06848_/X _06875_/A _06848_/B _06848_/C VPWR VGND sg13cmos5l_or3_1
XFILLER_43_505 VPWR VGND sg13cmos5l_decap_8
XFILLER_16_708 VPWR VGND sg13cmos5l_fill_1
X_06779_ _06782_/B _10783_/B _06820_/C _06820_/B _06779_/D VPWR VGND sg13cmos5l_nand4_1
XFILLER_15_229 VPWR VGND sg13cmos5l_decap_4
X_09567_ _09587_/B _09223_/C _09565_/X _09566_/Y VPWR VGND sg13cmos5l_a21oi_1
X_11686__1278 _11686_/RESET_B VPWR VGND sg13cmos5l_tiehi
X_08518_ _11343_/D _08518_/A1 _08535_/B _08517_/Y VPWR VGND sg13cmos5l_a21oi_1
X_09498_ _09498_/X _11252_/Q _11220_/Q _11188_/Q _11156_/Q _09551_/S0 _09551_/S1 VPWR
+ VGND sg13cmos5l_mux4_1
XFILLER_24_763 VPWR VGND sg13cmos5l_fill_1
XFILLER_90_49 VPWR VGND sg13cmos5l_decap_8
X_08449_ _11309_/D _08514_/A1 _08466_/B _08448_/Y VPWR VGND sg13cmos5l_o21ai_1
XFILLER_8_907 VPWR VGND sg13cmos5l_fill_2
X_11460_ _11460_/Q clkload18/A _11460_/D _11460_/RESET_B VPWR VGND sg13cmos5l_dfrbpq_1
XFILLER_99_25 VPWR VGND sg13cmos5l_decap_8
X_10411_ _10411_/Y _10411_/A _10411_/B VPWR VGND sg13cmos5l_nor2_1
X_11391_ _11391_/Q _11766_/CLK _11391_/D _11391_/RESET_B VPWR VGND sg13cmos5l_dfrbpq_1
X_10342_ _11528_/D _10488_/A _10342_/B _10342_/C VPWR VGND sg13cmos5l_and3_1
XFILLER_2_111 VPWR VGND sg13cmos5l_decap_8
XFILLER_105_551 VPWR VGND sg13cmos5l_decap_8
XFILLER_79_914 VPWR VGND sg13cmos5l_decap_8
X_10273_ _10296_/B _10273_/A _10273_/B _10273_/C VPWR VGND sg13cmos5l_nand3_1
XFILLER_2_155 VPWR VGND sg13cmos5l_decap_8
XFILLER_2_177 VPWR VGND sg13cmos5l_decap_4
XFILLER_48_51 VPWR VGND sg13cmos5l_fill_1
XFILLER_93_427 VPWR VGND sg13cmos5l_decap_4
Xfanout481 fanout481/X fanout482/X VPWR VGND sg13cmos5l_buf_1
XFILLER_87_991 VPWR VGND sg13cmos5l_decap_8
Xfanout492 _10149_/B _10058_/Y VPWR VGND sg13cmos5l_buf_1
Xfanout470 _06468_/B fanout482/X VPWR VGND sg13cmos5l_buf_1
XFILLER_101_790 VPWR VGND sg13cmos5l_decap_8
XFILLER_74_652 VPWR VGND sg13cmos5l_decap_8
XFILLER_58_181 VPWR VGND sg13cmos5l_decap_8
XFILLER_58_170 VPWR VGND sg13cmos5l_decap_8
XFILLER_0_14 VPWR VGND sg13cmos5l_decap_8
XFILLER_94_1018 VPWR VGND sg13cmos5l_decap_8
XFILLER_62_803 VPWR VGND sg13cmos5l_decap_8
XFILLER_47_888 VPWR VGND sg13cmos5l_fill_1
XFILLER_34_505 VPWR VGND sg13cmos5l_decap_8
X_11727_ _11727_/Q clkload22/A _11727_/D _11727_/RESET_B VPWR VGND sg13cmos5l_dfrbpq_1
XFILLER_61_379 VPWR VGND sg13cmos5l_decap_8
XFILLER_42_582 VPWR VGND sg13cmos5l_decap_8
XFILLER_15_774 VPWR VGND sg13cmos5l_decap_8
XFILLER_30_722 VPWR VGND sg13cmos5l_decap_8
XFILLER_14_284 VPWR VGND sg13cmos5l_fill_1
XFILLER_30_744 VPWR VGND sg13cmos5l_decap_8
XFILLER_30_755 VPWR VGND sg13cmos5l_fill_1
X_11658_ _11658_/Q _11767_/CLK _11658_/D _11658_/RESET_B VPWR VGND sg13cmos5l_dfrbpq_1
XFILLER_30_777 VPWR VGND sg13cmos5l_decap_8
X_11589_ _11589_/Q clkload23/A _11589_/D _11589_/RESET_B VPWR VGND sg13cmos5l_dfrbpq_1
X_10609_ _10609_/Y _10632_/A _10608_/B _10449_/Y VPWR VGND sg13cmos5l_a21oi_1
XFILLER_6_461 VPWR VGND sg13cmos5l_fill_2
Xhold2319 _07875_/A _11028_/Q VPWR VGND sg13cmos5l_dlygate4sd3_1
Xhold2308 _07495_/A _10898_/Q VPWR VGND sg13cmos5l_dlygate4sd3_1
X_07820_ _07820_/Y _07820_/A _07820_/B VPWR VGND sg13cmos5l_nand2_1
XFILLER_96_276 VPWR VGND sg13cmos5l_fill_2
XFILLER_84_427 VPWR VGND sg13cmos5l_fill_1
X_07751_ _10968_/D _08536_/A1 _07750_/B _07750_/Y VPWR VGND sg13cmos5l_a21oi_1
XFILLER_38_866 VPWR VGND sg13cmos5l_fill_1
X_06702_ _06702_/Y _06739_/A _10437_/A VPWR VGND sg13cmos5l_nor2_1
XFILLER_65_663 VPWR VGND sg13cmos5l_fill_1
X_07682_ _07682_/Y _07682_/A _07682_/B VPWR VGND sg13cmos5l_nor2_1
XFILLER_64_195 VPWR VGND sg13cmos5l_fill_2
XFILLER_52_335 VPWR VGND sg13cmos5l_decap_8
X_09421_ _09422_/C _09417_/Y _09418_/Y _09419_/Y _09420_/Y _06474_/A VPWR VGND sg13cmos5l_a221oi_1
X_06633_ _06633_/Y _06633_/A _06722_/B VPWR VGND sg13cmos5l_nor2_1
XFILLER_80_666 VPWR VGND sg13cmos5l_fill_2
XFILLER_40_508 VPWR VGND sg13cmos5l_decap_8
X_06564_ _06566_/A _06564_/A1 _11660_/Q _10870_/Q _06564_/B2 VPWR VGND sg13cmos5l_a22oi_1
X_09352_ _09352_/Y _06523_/B _09534_/A _09351_/Y VPWR VGND sg13cmos5l_o21ai_1
X_08303_ _08303_/Y _08303_/A _08309_/B VPWR VGND sg13cmos5l_nor2_1
XFILLER_61_891 VPWR VGND sg13cmos5l_decap_8
XFILLER_40_519 VPWR VGND sg13cmos5l_fill_2
X_09283_ _09283_/Y _09283_/A _09283_/B _09283_/C VPWR VGND sg13cmos5l_nand3_1
XFILLER_60_390 VPWR VGND sg13cmos5l_decap_4
X_06495_ _06495_/Y _09707_/S1 _06491_/X _06494_/Y VPWR VGND sg13cmos5l_o21ai_1
X_08234_ _08234_/Y _08234_/A _08234_/B VPWR VGND sg13cmos5l_nand2_1
XFILLER_20_243 VPWR VGND sg13cmos5l_fill_2
X_08165_ _08165_/Y _08165_/A _08173_/B VPWR VGND sg13cmos5l_nor2_1
XFILLER_20_287 VPWR VGND sg13cmos5l_decap_8
XFILLER_106_315 VPWR VGND sg13cmos5l_decap_8
X_07116_ _11723_/D _05883_/Y _07120_/A2 _07115_/Y VPWR VGND sg13cmos5l_a21oi_1
XFILLER_4_409 VPWR VGND sg13cmos5l_decap_8
X_08096_ _08096_/Y _08096_/A _08096_/B VPWR VGND sg13cmos5l_nand2_1
X_07047_ _07047_/Y _06982_/Y _07046_/Y _07050_/B1 VPWR VGND sg13cmos5l_a21oi_1
XFILLER_88_722 VPWR VGND sg13cmos5l_fill_1
XFILLER_0_615 VPWR VGND sg13cmos5l_fill_2
XFILLER_102_532 VPWR VGND sg13cmos5l_decap_8
Xhold2831 hold2831/X _11728_/Q VPWR VGND sg13cmos5l_dlygate4sd3_1
Xhold2820 _11520_/D _10179_/Y VPWR VGND sg13cmos5l_dlygate4sd3_1
XFILLER_48_608 VPWR VGND sg13cmos5l_decap_4
X_11280__1621 _11280_/RESET_B VPWR VGND sg13cmos5l_tiehi
Xhold2864 hold2864/X _11455_/Q VPWR VGND sg13cmos5l_dlygate4sd3_1
XFILLER_75_416 VPWR VGND sg13cmos5l_fill_2
Xhold2875 _09298_/B _10826_/Q VPWR VGND sg13cmos5l_dlygate4sd3_1
XFILLER_47_118 VPWR VGND sg13cmos5l_decap_8
X_08998_ _08999_/B _08997_/A _08997_/C _08997_/B VPWR VGND sg13cmos5l_o21ai_1
Xhold2853 _06172_/A _11496_/Q VPWR VGND sg13cmos5l_dlygate4sd3_1
Xhold2842 _11494_/D _10079_/Y VPWR VGND sg13cmos5l_dlygate4sd3_1
Xhold2897 _06444_/A _11518_/Q VPWR VGND sg13cmos5l_dlygate4sd3_1
Xhold2886 hold2886/X _10833_/Q VPWR VGND sg13cmos5l_dlygate4sd3_1
Xclkbuf_leaf_67_clk _11347_/CLK clkbuf_4_2_0_clk/X VPWR VGND sg13cmos5l_buf_8
X_07949_ _11064_/D _08536_/A1 _07948_/B _07948_/Y VPWR VGND sg13cmos5l_o21ai_1
XFILLER_84_961 VPWR VGND sg13cmos5l_fill_1
XFILLER_56_663 VPWR VGND sg13cmos5l_decap_4
XFILLER_44_803 VPWR VGND sg13cmos5l_decap_4
X_10960_ _10960_/Q _11671_/CLK _10960_/D _10960_/RESET_B VPWR VGND sg13cmos5l_dfrbpq_1
XFILLER_28_343 VPWR VGND sg13cmos5l_decap_8
X_10891_ _10891_/Q clkload32/A _10891_/D _10891_/RESET_B VPWR VGND sg13cmos5l_dfrbpq_1
XFILLER_71_622 VPWR VGND sg13cmos5l_decap_4
XFILLER_43_302 VPWR VGND sg13cmos5l_decap_8
XFILLER_16_538 VPWR VGND sg13cmos5l_decap_8
XFILLER_16_549 VPWR VGND sg13cmos5l_fill_1
X_09619_ _09619_/Y _09643_/A _09672_/A _09592_/Y _09618_/Y VPWR VGND sg13cmos5l_a22oi_1
XFILLER_71_699 VPWR VGND sg13cmos5l_decap_8
XFILLER_70_187 VPWR VGND sg13cmos5l_decap_8
XFILLER_70_176 VPWR VGND sg13cmos5l_fill_2
XFILLER_52_891 VPWR VGND sg13cmos5l_fill_2
XFILLER_31_519 VPWR VGND sg13cmos5l_fill_2
XFILLER_70_198 VPWR VGND sg13cmos5l_fill_2
XFILLER_8_704 VPWR VGND sg13cmos5l_fill_2
XFILLER_11_232 VPWR VGND sg13cmos5l_fill_1
X_11512_ _11512_/Q clkload48/A _11512_/D _11512_/RESET_B VPWR VGND sg13cmos5l_dfrbpq_1
XFILLER_11_265 VPWR VGND sg13cmos5l_decap_8
X_11443_ _11443_/Q clkload43/A _11443_/D _11443_/RESET_B VPWR VGND sg13cmos5l_dfrbpq_1
XFILLER_50_74 VPWR VGND sg13cmos5l_decap_8
X_11374_ _11374_/Q clkload28/A _11374_/D _11374_/RESET_B VPWR VGND sg13cmos5l_dfrbpq_1
X_10325_ _10326_/C _10411_/A _10324_/Y _10443_/B1 VPWR VGND sg13cmos5l_o21ai_1
XFILLER_106_882 VPWR VGND sg13cmos5l_decap_8
XFILLER_105_370 VPWR VGND sg13cmos5l_decap_8
X_10256_ _10279_/B _10254_/X _10255_/X _10261_/A VPWR VGND sg13cmos5l_o21ai_1
XFILLER_3_475 VPWR VGND sg13cmos5l_decap_8
XFILLER_67_917 VPWR VGND sg13cmos5l_decap_8
XFILLER_94_714 VPWR VGND sg13cmos5l_fill_1
XFILLER_78_287 VPWR VGND sg13cmos5l_decap_4
X_10187_ _10187_/Y _10187_/A _10187_/B VPWR VGND sg13cmos5l_nand2_1
XFILLER_94_758 VPWR VGND sg13cmos5l_decap_4
XFILLER_47_641 VPWR VGND sg13cmos5l_decap_8
Xclkbuf_leaf_58_clk _11356_/CLK clkbuf_4_8_0_clk/X VPWR VGND sg13cmos5l_buf_8
XFILLER_19_310 VPWR VGND sg13cmos5l_fill_1
XFILLER_35_814 VPWR VGND sg13cmos5l_decap_4
XFILLER_19_343 VPWR VGND sg13cmos5l_decap_4
Xclkbuf_4_11_0_clk clkload4/A clkbuf_0_clk/X VPWR VGND sg13cmos5l_buf_8
XFILLER_62_611 VPWR VGND sg13cmos5l_decap_8
XFILLER_47_685 VPWR VGND sg13cmos5l_decap_4
XFILLER_35_836 VPWR VGND sg13cmos5l_decap_8
XFILLER_19_398 VPWR VGND sg13cmos5l_fill_2
X_11143__1758 _11143_/RESET_B VPWR VGND sg13cmos5l_tiehi
XFILLER_90_975 VPWR VGND sg13cmos5l_fill_2
XFILLER_61_154 VPWR VGND sg13cmos5l_decap_4
XFILLER_50_828 VPWR VGND sg13cmos5l_fill_2
XFILLER_34_379 VPWR VGND sg13cmos5l_fill_1
XFILLER_61_198 VPWR VGND sg13cmos5l_decap_8
X_06280_ _06280_/Y _06590_/A _06279_/X _06276_/Y VPWR VGND sg13cmos5l_a21oi_1
XFILLER_7_792 VPWR VGND sg13cmos5l_fill_2
XFILLER_7_781 VPWR VGND sg13cmos5l_decap_8
XFILLER_89_508 VPWR VGND sg13cmos5l_fill_1
X_09970_ _09998_/B hold2864/X _09970_/B VPWR VGND sg13cmos5l_nand2b_1
XFILLER_6_291 VPWR VGND sg13cmos5l_fill_1
XFILLER_103_318 VPWR VGND sg13cmos5l_fill_1
X_08921_ _08921_/Y _08921_/A _08921_/B VPWR VGND sg13cmos5l_nor2_1
Xhold2116 _08119_/A _11147_/Q VPWR VGND sg13cmos5l_dlygate4sd3_1
X_08852_ _08890_/D _08852_/A _08852_/B _08853_/A _08852_/D VPWR VGND sg13cmos5l_nor4_1
Xhold2105 _07702_/A _10945_/Q VPWR VGND sg13cmos5l_dlygate4sd3_1
Xhold2127 _08285_/A _11229_/Q VPWR VGND sg13cmos5l_dlygate4sd3_1
Xhold2149 _08045_/A _11112_/Q VPWR VGND sg13cmos5l_dlygate4sd3_1
Xhold2138 _10726_/B _10725_/Y VPWR VGND sg13cmos5l_dlygate4sd3_1
X_11388__1510 _11388_/RESET_B VPWR VGND sg13cmos5l_tiehi
XFILLER_57_405 VPWR VGND sg13cmos5l_fill_2
X_07803_ _10993_/D _08522_/A1 _07834_/B _07802_/Y VPWR VGND sg13cmos5l_o21ai_1
X_08783_ _08784_/B _08653_/A _08653_/B _11634_/Q VPWR VGND sg13cmos5l_o21ai_1
X_05995_ _05995_/Y _11760_/Q _12766_/A VPWR VGND sg13cmos5l_nand2_1
Xclkbuf_leaf_49_clk clkload44/A clkload4/A VPWR VGND sg13cmos5l_buf_8
XFILLER_38_652 VPWR VGND sg13cmos5l_decap_8
X_07734_ _07734_/Y _07734_/A _07748_/B VPWR VGND sg13cmos5l_nor2_1
XFILLER_52_110 VPWR VGND sg13cmos5l_decap_8
X_07665_ _10926_/D _08451_/A1 _07682_/B _07664_/Y VPWR VGND sg13cmos5l_a21oi_1
XFILLER_25_346 VPWR VGND sg13cmos5l_fill_2
XFILLER_26_858 VPWR VGND sg13cmos5l_decap_8
X_09404_ _09408_/C _10220_/A _09404_/B VPWR VGND sg13cmos5l_and2_1
X_06616_ _10799_/D _06201_/B _06614_/Y _06615_/Y VPWR VGND sg13cmos5l_o21ai_1
X_07596_ _08737_/B _11542_/Q _10817_/Q _07642_/S VPWR VGND sg13cmos5l_mux2_1
X_11119__1782 _11119_/RESET_B VPWR VGND sg13cmos5l_tiehi
X_09335_ _09335_/Y _09335_/A _09335_/B _09536_/B VPWR VGND sg13cmos5l_nand3_1
X_06547_ _06548_/B _06571_/B2 _10880_/Q _11670_/Q _06573_/A1 VPWR VGND sg13cmos5l_a22oi_1
X_09266_ _10031_/A _09259_/A _09259_/B _09265_/Y VPWR VGND sg13cmos5l_a21oi_1
X_06478_ _06478_/Y _11340_/Q _09840_/S _09848_/B1 VPWR VGND sg13cmos5l_a21oi_1
X_11298__1603 _11298_/RESET_B VPWR VGND sg13cmos5l_tiehi
X_08217_ _11195_/D fanout83/X _08216_/B _08216_/Y VPWR VGND sg13cmos5l_o21ai_1
X_09197_ _09199_/A _09173_/X _09196_/X _09172_/X VPWR VGND sg13cmos5l_a21oi_1
XFILLER_106_112 VPWR VGND sg13cmos5l_decap_8
X_08148_ _11161_/D fanout98/X _08163_/B _08147_/Y VPWR VGND sg13cmos5l_a21oi_1
X_08079_ _11128_/D _08471_/A1 _08078_/B _08078_/Y VPWR VGND sg13cmos5l_o21ai_1
XFILLER_106_189 VPWR VGND sg13cmos5l_decap_8
X_11090_ _11090_/Q clkload8/A _11090_/D _11090_/RESET_B VPWR VGND sg13cmos5l_dfrbpq_1
X_10110_ _10110_/Y _10114_/A1 _05976_/A _10131_/A2 VPWR VGND sg13cmos5l_o21ai_1
XFILLER_103_863 VPWR VGND sg13cmos5l_decap_8
X_10041_ _10041_/Y _10952_/Q _10041_/B VPWR VGND sg13cmos5l_nand2_1
XFILLER_49_906 VPWR VGND sg13cmos5l_fill_1
XFILLER_1_946 VPWR VGND sg13cmos5l_decap_8
XFILLER_103_874 VPWR VGND sg13cmos5l_fill_2
XFILLER_48_405 VPWR VGND sg13cmos5l_fill_2
Xhold2672 _07248_/B _07247_/Y VPWR VGND sg13cmos5l_dlygate4sd3_1
Xhold2650 _06861_/A _11621_/Q VPWR VGND sg13cmos5l_dlygate4sd3_1
XFILLER_76_747 VPWR VGND sg13cmos5l_decap_8
XFILLER_75_235 VPWR VGND sg13cmos5l_fill_1
Xhold2683 _07197_/A _11712_/Q VPWR VGND sg13cmos5l_dlygate4sd3_1
Xhold2661 _11691_/D _06882_/Y VPWR VGND sg13cmos5l_dlygate4sd3_1
Xhold1960 _08184_/A _11179_/Q VPWR VGND sg13cmos5l_dlygate4sd3_1
Xhold1971 _08454_/A _11312_/Q VPWR VGND sg13cmos5l_dlygate4sd3_1
Xhold2694 _11492_/D _10072_/Y VPWR VGND sg13cmos5l_dlygate4sd3_1
Xhold1993 _08234_/A _11204_/Q VPWR VGND sg13cmos5l_dlygate4sd3_1
X_10943_ _10943_/Q clkload58/A _10943_/D _10943_/RESET_B VPWR VGND sg13cmos5l_dfrbpq_1
XFILLER_72_942 VPWR VGND sg13cmos5l_decap_4
Xhold1982 _08350_/A _11261_/Q VPWR VGND sg13cmos5l_dlygate4sd3_1
XFILLER_71_474 VPWR VGND sg13cmos5l_decap_4
XFILLER_44_688 VPWR VGND sg13cmos5l_fill_2
XFILLER_16_379 VPWR VGND sg13cmos5l_decap_8
X_10874_ _10874_/Q clkload11/A _10874_/D _10874_/RESET_B VPWR VGND sg13cmos5l_dfrbpq_1
XFILLER_31_316 VPWR VGND sg13cmos5l_fill_1
X_11522__1139 _11522_/RESET_B VPWR VGND sg13cmos5l_tiehi
XFILLER_101_91 VPWR VGND sg13cmos5l_decap_8
XFILLER_12_552 VPWR VGND sg13cmos5l_decap_8
XFILLER_12_563 VPWR VGND sg13cmos5l_fill_2
X_10908__1074 _10908_/RESET_B VPWR VGND sg13cmos5l_tiehi
XFILLER_8_578 VPWR VGND sg13cmos5l_decap_4
XANTENNA_6 _10470_/A VPWR VGND sg13cmos5l_antennanp
X_11426_ _11426_/Q clkload28/A _11426_/D _11426_/RESET_B VPWR VGND sg13cmos5l_dfrbpq_1
XFILLER_6_35 VPWR VGND sg13cmos5l_decap_8
X_11357_ _11357_/Q clkload42/A _11357_/D _11357_/RESET_B VPWR VGND sg13cmos5l_dfrbpq_1
X_10308_ _10538_/A _10523_/A _10523_/B _10289_/X VPWR VGND sg13cmos5l_a21o_1
XFILLER_3_272 VPWR VGND sg13cmos5l_decap_4
X_11288_ _11288_/Q _11352_/CLK _11288_/D _11288_/RESET_B VPWR VGND sg13cmos5l_dfrbpq_1
XFILLER_3_294 VPWR VGND sg13cmos5l_decap_4
XFILLER_66_202 VPWR VGND sg13cmos5l_fill_2
X_10239_ _10240_/B _10237_/Y _10239_/B VPWR VGND sg13cmos5l_nand2b_1
XFILLER_86_70 VPWR VGND sg13cmos5l_decap_4
X_11681__1283 _11681_/RESET_B VPWR VGND sg13cmos5l_tiehi
XFILLER_39_449 VPWR VGND sg13cmos5l_fill_2
XFILLER_94_599 VPWR VGND sg13cmos5l_fill_1
XFILLER_81_227 VPWR VGND sg13cmos5l_fill_2
XFILLER_35_644 VPWR VGND sg13cmos5l_decap_8
X_07450_ _07450_/Y _07450_/A _07640_/B VPWR VGND sg13cmos5l_nor2_1
XFILLER_16_880 VPWR VGND sg13cmos5l_decap_8
XFILLER_22_305 VPWR VGND sg13cmos5l_fill_1
XFILLER_34_165 VPWR VGND sg13cmos5l_fill_2
X_06401_ _06401_/X _11646_/Q _06401_/B _06401_/C _06401_/D VPWR VGND sg13cmos5l_or4_1
X_07381_ _07381_/Y _07379_/Y _08738_/A _07400_/A2 VPWR VGND sg13cmos5l_a21oi_1
XFILLER_50_636 VPWR VGND sg13cmos5l_fill_2
XFILLER_89_0 VPWR VGND sg13cmos5l_decap_8
X_06332_ _06332_/Y _06332_/A VPWR VGND sg13cmos5l_inv_1
X_09120_ _09121_/B _09120_/A _09120_/B VPWR VGND sg13cmos5l_nand2_1
X_09051_ _09051_/Y _09051_/A1 _09050_/Y _09052_/A VPWR VGND sg13cmos5l_o21ai_1
XFILLER_30_382 VPWR VGND sg13cmos5l_fill_1
X_11601__1382 _11601_/RESET_B VPWR VGND sg13cmos5l_tiehi
X_06263_ _10597_/A _06264_/A _06264_/B VPWR VGND sg13cmos5l_nor2_1
X_08002_ _11090_/D _08329_/A1 _08011_/B _08001_/Y VPWR VGND sg13cmos5l_a21oi_1
X_06194_ _06588_/B _06194_/A _07077_/A VPWR VGND sg13cmos5l_nor2_1
XFILLER_104_605 VPWR VGND sg13cmos5l_decap_8
XFILLER_106_14 VPWR VGND sg13cmos5l_decap_8
XFILLER_103_126 VPWR VGND sg13cmos5l_decap_8
XFILLER_98_861 VPWR VGND sg13cmos5l_decap_4
X_09953_ _09953_/Y _10917_/Q _09955_/B _09982_/B1 VPWR VGND sg13cmos5l_a21oi_1
Xheichips26_RiMaX_1819 uio_oe[4] VPWR VGND sg13cmos5l_tiehi
XFILLER_97_371 VPWR VGND sg13cmos5l_fill_1
XFILLER_85_511 VPWR VGND sg13cmos5l_fill_2
X_09884_ _09889_/C _09884_/A _09884_/B VPWR VGND sg13cmos5l_nor2_1
X_08904_ _08904_/Y _08902_/Y _08903_/Y _08895_/Y VPWR VGND sg13cmos5l_o21ai_1
X_08835_ _08835_/Y _11381_/Q _08841_/A VPWR VGND sg13cmos5l_nand2_1
X_08766_ _08767_/B _08770_/A _08766_/B VPWR VGND sg13cmos5l_nand2_1
XFILLER_73_706 VPWR VGND sg13cmos5l_decap_8
XFILLER_57_257 VPWR VGND sg13cmos5l_fill_2
XFILLER_39_972 VPWR VGND sg13cmos5l_fill_1
XFILLER_39_961 VPWR VGND sg13cmos5l_decap_4
X_07717_ _10952_/D fanout51/X _07718_/B _07716_/Y VPWR VGND sg13cmos5l_a21oi_1
XFILLER_66_780 VPWR VGND sg13cmos5l_decap_8
X_05978_ _05978_/Y _05978_/A VPWR VGND sg13cmos5l_inv_1
XFILLER_38_460 VPWR VGND sg13cmos5l_fill_2
XFILLER_54_953 VPWR VGND sg13cmos5l_decap_4
X_08697_ _08698_/A hold2793/X _08895_/B _08921_/B _08922_/A VPWR VGND sg13cmos5l_a22oi_1
XFILLER_25_121 VPWR VGND sg13cmos5l_fill_2
X_07648_ _07648_/Y _07648_/A _07648_/B VPWR VGND sg13cmos5l_nor2_1
XFILLER_80_260 VPWR VGND sg13cmos5l_fill_2
X_07579_ _07579_/Y _07579_/A _07648_/B VPWR VGND sg13cmos5l_nor2_1
XFILLER_80_271 VPWR VGND sg13cmos5l_fill_2
XFILLER_13_338 VPWR VGND sg13cmos5l_decap_8
XFILLER_13_349 VPWR VGND sg13cmos5l_fill_1
X_09318_ _09318_/Y _11458_/Q _09336_/B _09349_/B VPWR VGND sg13cmos5l_o21ai_1
XFILLER_40_168 VPWR VGND sg13cmos5l_fill_1
X_10590_ _10590_/Y _10591_/A _10854_/Q VPWR VGND sg13cmos5l_nor2_1
X_11733__1214 _11733_/RESET_B VPWR VGND sg13cmos5l_tiehi
XFILLER_22_883 VPWR VGND sg13cmos5l_decap_8
X_09249_ _09254_/C _09948_/A _09919_/A VPWR VGND sg13cmos5l_nor2_1
XFILLER_5_537 VPWR VGND sg13cmos5l_decap_4
X_11211_ _11211_/Q _11339_/CLK _11211_/D _11211_/RESET_B VPWR VGND sg13cmos5l_dfrbpq_1
X_11142_ _11142_/Q _11362_/CLK _11142_/D _11142_/RESET_B VPWR VGND sg13cmos5l_dfrbpq_1
Xoutput32 uio_out[9] _11681_/Q VPWR VGND sg13cmos5l_buf_1
Xoutput21 uio_out[10] _11682_/Q VPWR VGND sg13cmos5l_buf_1
Xoutput43 uo_out[4] _06542_/Y VPWR VGND sg13cmos5l_buf_1
XFILLER_96_809 VPWR VGND sg13cmos5l_decap_4
XFILLER_89_850 VPWR VGND sg13cmos5l_decap_8
XFILLER_95_308 VPWR VGND sg13cmos5l_decap_8
XFILLER_89_861 VPWR VGND sg13cmos5l_fill_1
X_11073_ _11073_/Q _11356_/CLK _11073_/D _11073_/RESET_B VPWR VGND sg13cmos5l_dfrbpq_1
X_10024_ _10029_/B _10051_/A _10024_/B _10024_/C VPWR VGND sg13cmos5l_nor3_1
XFILLER_76_522 VPWR VGND sg13cmos5l_fill_1
XFILLER_76_511 VPWR VGND sg13cmos5l_fill_1
Xhold2480 _11585_/D _10769_/X VPWR VGND sg13cmos5l_dlygate4sd3_1
XFILLER_76_566 VPWR VGND sg13cmos5l_decap_8
XFILLER_64_717 VPWR VGND sg13cmos5l_fill_2
XFILLER_56_40 VPWR VGND sg13cmos5l_fill_2
XFILLER_48_257 VPWR VGND sg13cmos5l_fill_1
Xhold2491 _07419_/A _10887_/Q VPWR VGND sg13cmos5l_dlygate4sd3_1
XFILLER_56_51 VPWR VGND sg13cmos5l_decap_8
XFILLER_36_419 VPWR VGND sg13cmos5l_fill_1
XFILLER_56_290 VPWR VGND sg13cmos5l_decap_8
X_10926_ _10926_/Q clkload35/A _10926_/D _10926_/RESET_B VPWR VGND sg13cmos5l_dfrbpq_1
XFILLER_32_614 VPWR VGND sg13cmos5l_fill_2
X_10857_ _10857_/Q _11715_/CLK _10857_/D _10857_/RESET_B VPWR VGND sg13cmos5l_dfrbpq_1
XFILLER_31_146 VPWR VGND sg13cmos5l_fill_2
X_10788_ _10788_/Y _06801_/Y _10783_/Y _10787_/Y VPWR VGND sg13cmos5l_o21ai_1
X_10829__1184 _10829_/RESET_B VPWR VGND sg13cmos5l_tiehi
XFILLER_13_883 VPWR VGND sg13cmos5l_fill_1
XFILLER_13_894 VPWR VGND sg13cmos5l_fill_2
X_11415__1460 _11415_/RESET_B VPWR VGND sg13cmos5l_tiehi
XFILLER_8_364 VPWR VGND sg13cmos5l_decap_4
X_11699__1265 _11699_/RESET_B VPWR VGND sg13cmos5l_tiehi
X_11409_ _11409_/Q clkload37/A _11409_/D _11409_/RESET_B VPWR VGND sg13cmos5l_dfrbpq_1
XFILLER_4_570 VPWR VGND sg13cmos5l_fill_1
X_11448__1394 _11448_/RESET_B VPWR VGND sg13cmos5l_tiehi
XFILLER_98_168 VPWR VGND sg13cmos5l_fill_2
X_06950_ _06952_/A _11553_/Q _08611_/B _08614_/B VPWR VGND sg13cmos5l_o21ai_1
X_11499__1185 _11499_/RESET_B VPWR VGND sg13cmos5l_tiehi
XFILLER_79_371 VPWR VGND sg13cmos5l_decap_8
X_06881_ _06881_/Y _06881_/A _07088_/S VPWR VGND sg13cmos5l_nor2_1
X_05901_ _05901_/Y _09909_/A VPWR VGND sg13cmos5l_inv_1
XFILLER_95_886 VPWR VGND sg13cmos5l_fill_1
XFILLER_55_706 VPWR VGND sg13cmos5l_decap_4
X_08620_ _08620_/Y _08620_/A _08624_/B VPWR VGND sg13cmos5l_nor2_1
XFILLER_39_257 VPWR VGND sg13cmos5l_fill_1
X_11619__1353 _11619_/RESET_B VPWR VGND sg13cmos5l_tiehi
X_08551_ _08551_/Y _08551_/A _08569_/B VPWR VGND sg13cmos5l_nor2_1
X_08482_ _08482_/Y _08482_/A _08504_/B VPWR VGND sg13cmos5l_nand2_1
XFILLER_63_761 VPWR VGND sg13cmos5l_decap_8
XFILLER_51_901 VPWR VGND sg13cmos5l_decap_8
X_07502_ _07502_/Y _07521_/D _07501_/Y _07499_/Y VPWR VGND sg13cmos5l_a21oi_1
X_07433_ _07786_/B _11562_/Q _11561_/Q VPWR VGND sg13cmos5l_or2_1
XFILLER_23_636 VPWR VGND sg13cmos5l_fill_1
XFILLER_51_978 VPWR VGND sg13cmos5l_decap_8
X_09103_ _09112_/B _09103_/A _09118_/D VPWR VGND sg13cmos5l_nor2b_1
X_07364_ _07364_/Y _10267_/C _07376_/A2 _07363_/Y VPWR VGND sg13cmos5l_a21oi_1
X_07295_ _07295_/Y _11528_/Q _08689_/A VPWR VGND sg13cmos5l_nand2_1
X_06315_ _06701_/B _06236_/A _09557_/A VPWR VGND sg13cmos5l_nand2b_1
X_06246_ _06248_/A _11516_/Q _09262_/A VPWR VGND sg13cmos5l_and2_1
X_09034_ _09035_/B _09034_/A _09034_/B VPWR VGND sg13cmos5l_nor2_1
XFILLER_11_1000 VPWR VGND sg13cmos5l_decap_8
XFILLER_105_925 VPWR VGND sg13cmos5l_decap_8
XFILLER_104_402 VPWR VGND sg13cmos5l_decap_8
XFILLER_2_529 VPWR VGND sg13cmos5l_fill_2
X_06177_ _06636_/A _06633_/A _06177_/B VPWR VGND sg13cmos5l_nand2_1
Xfanout800 _10191_/A hold2915/X VPWR VGND sg13cmos5l_buf_1
X_09936_ _09936_/Y _11300_/Q _10019_/B _09935_/Y VPWR VGND sg13cmos5l_o21ai_1
Xfanout833 _10783_/B _10503_/A VPWR VGND sg13cmos5l_buf_1
Xfanout822 _07071_/A _06117_/A VPWR VGND sg13cmos5l_buf_1
Xfanout811 _09030_/A1 _09154_/A1 VPWR VGND sg13cmos5l_buf_1
XFILLER_85_352 VPWR VGND sg13cmos5l_decap_4
X_09867_ _09867_/Y _10946_/Q _09986_/B VPWR VGND sg13cmos5l_nand2_1
X_09798_ _09798_/X _11359_/Q _10007_/B _10021_/B1 VPWR VGND sg13cmos5l_a21o_1
X_08818_ _08819_/B _08817_/C _08806_/B _08817_/D VPWR VGND sg13cmos5l_a21oi_1
XFILLER_39_780 VPWR VGND sg13cmos5l_fill_1
XFILLER_93_49 VPWR VGND sg13cmos5l_decap_8
X_08749_ _11417_/D _08749_/A VPWR VGND sg13cmos5l_inv_1
XFILLER_26_430 VPWR VGND sg13cmos5l_decap_8
X_11760_ _11760_/Q _11766_/CLK _11760_/D _11760_/RESET_B VPWR VGND sg13cmos5l_dfrbpq_1
XFILLER_26_65 VPWR VGND sg13cmos5l_fill_2
X_10711_ _10713_/B _10711_/A _10730_/A VPWR VGND sg13cmos5l_nand2_1
XFILLER_42_956 VPWR VGND sg13cmos5l_fill_2
XFILLER_13_113 VPWR VGND sg13cmos5l_decap_8
XFILLER_13_124 VPWR VGND sg13cmos5l_fill_2
XFILLER_26_496 VPWR VGND sg13cmos5l_decap_4
X_11691_ _11691_/Q clkload28/A _11691_/D _11691_/RESET_B VPWR VGND sg13cmos5l_dfrbpq_1
XFILLER_42_967 VPWR VGND sg13cmos5l_decap_8
XFILLER_13_135 VPWR VGND sg13cmos5l_decap_4
X_10642_ _10643_/B _10642_/A _10642_/B VPWR VGND sg13cmos5l_xnor2_1
XFILLER_42_53 VPWR VGND sg13cmos5l_decap_8
X_10573_ _10573_/Y _10573_/A _10573_/B _10573_/C VPWR VGND sg13cmos5l_nand3_1
XFILLER_10_842 VPWR VGND sg13cmos5l_fill_2
XFILLER_6_879 VPWR VGND sg13cmos5l_fill_2
XFILLER_6_857 VPWR VGND sg13cmos5l_decap_4
XFILLER_3_14 VPWR VGND sg13cmos5l_decap_8
X_11125_ _11125_/Q _11349_/CLK _11125_/D _11125_/RESET_B VPWR VGND sg13cmos5l_dfrbpq_1
XFILLER_89_691 VPWR VGND sg13cmos5l_decap_8
XFILLER_49_511 VPWR VGND sg13cmos5l_decap_8
X_11056_ _11056_/Q _11671_/CLK _11056_/D _11056_/RESET_B VPWR VGND sg13cmos5l_dfrbpq_1
X_10007_ _10007_/Y _11111_/Q _10007_/B VPWR VGND sg13cmos5l_nand2_1
XFILLER_92_801 VPWR VGND sg13cmos5l_fill_1
XFILLER_37_706 VPWR VGND sg13cmos5l_decap_8
XFILLER_76_385 VPWR VGND sg13cmos5l_decap_8
XFILLER_64_514 VPWR VGND sg13cmos5l_fill_1
XFILLER_36_238 VPWR VGND sg13cmos5l_fill_2
XFILLER_92_889 VPWR VGND sg13cmos5l_fill_1
XFILLER_33_901 VPWR VGND sg13cmos5l_decap_4
XFILLER_91_399 VPWR VGND sg13cmos5l_decap_4
XFILLER_17_485 VPWR VGND sg13cmos5l_decap_8
XFILLER_32_411 VPWR VGND sg13cmos5l_fill_1
XFILLER_60_764 VPWR VGND sg13cmos5l_decap_4
X_10909_ _10909_/Q clkload41/A _10909_/D _10909_/RESET_B VPWR VGND sg13cmos5l_dfrbpq_1
XFILLER_80_4 VPWR VGND sg13cmos5l_decap_4
XFILLER_20_628 VPWR VGND sg13cmos5l_decap_4
XFILLER_32_477 VPWR VGND sg13cmos5l_decap_8
XFILLER_9_662 VPWR VGND sg13cmos5l_fill_1
X_07080_ _07080_/Y _08616_/A _07078_/Y _07079_/Y VPWR VGND sg13cmos5l_a21oi_1
X_06100_ _06103_/B _06100_/A _07353_/A _07371_/A _07365_/A VPWR VGND sg13cmos5l_nor4_1
X_06031_ _06033_/B _08621_/B _10177_/A _06030_/Y VPWR VGND sg13cmos5l_a21oi_1
XFILLER_66_2 VPWR VGND sg13cmos5l_fill_1
XFILLER_99_444 VPWR VGND sg13cmos5l_fill_1
XFILLER_99_433 VPWR VGND sg13cmos5l_decap_4
X_07982_ _07982_/Y _07982_/A _07982_/B VPWR VGND sg13cmos5l_nand2_1
XFILLER_59_319 VPWR VGND sg13cmos5l_fill_2
Xfanout129 _08198_/B _08208_/B VPWR VGND sg13cmos5l_buf_1
Xfanout118 _08462_/B _08466_/B VPWR VGND sg13cmos5l_buf_1
Xfanout107 _08530_/A1 _07516_/Y VPWR VGND sg13cmos5l_buf_1
XFILLER_99_499 VPWR VGND sg13cmos5l_decap_8
XFILLER_80_1020 VPWR VGND sg13cmos5l_decap_8
X_06933_ _06933_/Y _06933_/A _06933_/B VPWR VGND sg13cmos5l_nand2_1
XFILLER_68_842 VPWR VGND sg13cmos5l_decap_8
X_09721_ _09722_/C _09721_/A _09721_/B VPWR VGND sg13cmos5l_nor2_1
X_06864_ _11622_/D _06825_/Y _06851_/Y _06863_/Y VPWR VGND sg13cmos5l_o21ai_1
XFILLER_83_834 VPWR VGND sg13cmos5l_fill_1
XFILLER_68_886 VPWR VGND sg13cmos5l_decap_4
X_09652_ _09652_/X _11002_/Q _10970_/Q _09652_/S VPWR VGND sg13cmos5l_mux2_1
X_08603_ _08603_/Y _08600_/Y _08602_/Y _10049_/A1 VPWR VGND sg13cmos5l_o21ai_1
X_06795_ _06795_/Y _06790_/Y _06832_/A _06792_/Y VPWR VGND sg13cmos5l_o21ai_1
XFILLER_83_856 VPWR VGND sg13cmos5l_fill_1
XFILLER_55_558 VPWR VGND sg13cmos5l_fill_2
X_10867__1115 _10867_/RESET_B VPWR VGND sg13cmos5l_tiehi
X_09583_ _09669_/A _09583_/A _09721_/B VPWR VGND sg13cmos5l_nor2_1
XFILLER_83_889 VPWR VGND sg13cmos5l_fill_2
XFILLER_36_750 VPWR VGND sg13cmos5l_decap_8
X_08534_ _11351_/D _08534_/A1 _08533_/B _08533_/Y VPWR VGND sg13cmos5l_a21oi_1
XFILLER_51_720 VPWR VGND sg13cmos5l_fill_2
XFILLER_24_934 VPWR VGND sg13cmos5l_fill_1
XFILLER_11_606 VPWR VGND sg13cmos5l_decap_4
X_08465_ _11317_/D _08530_/A1 _08464_/B _08464_/Y VPWR VGND sg13cmos5l_o21ai_1
X_07416_ _08763_/A _07416_/A _07416_/B VPWR VGND sg13cmos5l_nand2_1
X_08396_ _11283_/D _08526_/A1 _08403_/B _08395_/Y VPWR VGND sg13cmos5l_a21oi_1
X_07347_ _07347_/Y _07347_/A _07347_/B VPWR VGND sg13cmos5l_nor2_1
X_11156__1745 _11156_/RESET_B VPWR VGND sg13cmos5l_tiehi
XFILLER_12_34 VPWR VGND sg13cmos5l_fill_1
X_09017_ _09069_/A _09043_/A _09036_/B VPWR VGND sg13cmos5l_xnor2_1
X_07278_ _07278_/Y _11429_/Q _07296_/B VPWR VGND sg13cmos5l_nand2_1
XFILLER_3_805 VPWR VGND sg13cmos5l_fill_2
X_06229_ _06714_/A _10479_/C _06229_/B VPWR VGND sg13cmos5l_nor2_1
XFILLER_105_744 VPWR VGND sg13cmos5l_decap_8
XFILLER_104_210 VPWR VGND sg13cmos5l_decap_8
XFILLER_88_49 VPWR VGND sg13cmos5l_decap_8
XFILLER_2_326 VPWR VGND sg13cmos5l_fill_2
XFILLER_105_788 VPWR VGND sg13cmos5l_decap_8
XFILLER_78_617 VPWR VGND sg13cmos5l_decap_4
Xfanout630 _10719_/B _05936_/Y VPWR VGND sg13cmos5l_buf_1
Xfanout641 _06564_/A1 _11765_/Q VPWR VGND sg13cmos5l_buf_1
Xfanout663 _10731_/A _10353_/A VPWR VGND sg13cmos5l_buf_1
Xfanout674 _10161_/B fanout682/X VPWR VGND sg13cmos5l_buf_1
X_09919_ _09948_/C _09919_/A _09919_/B _09919_/C VPWR VGND sg13cmos5l_or3_1
XFILLER_59_875 VPWR VGND sg13cmos5l_decap_8
Xfanout652 _09335_/B _06085_/A VPWR VGND sg13cmos5l_buf_1
Xfanout685 _07006_/A _07072_/B VPWR VGND sg13cmos5l_buf_1
Xfanout696 _06820_/B hold2891/X VPWR VGND sg13cmos5l_buf_1
XFILLER_37_42 VPWR VGND sg13cmos5l_fill_2
XFILLER_74_867 VPWR VGND sg13cmos5l_decap_8
XFILLER_74_889 VPWR VGND sg13cmos5l_decap_8
XFILLER_74_878 VPWR VGND sg13cmos5l_fill_2
XFILLER_61_528 VPWR VGND sg13cmos5l_decap_4
XFILLER_42_720 VPWR VGND sg13cmos5l_fill_2
XFILLER_15_934 VPWR VGND sg13cmos5l_fill_2
X_11743_ _11743_/Q clkload22/A _11743_/D _11743_/RESET_B VPWR VGND sg13cmos5l_dfrbpq_1
XFILLER_53_30 VPWR VGND sg13cmos5l_fill_1
XFILLER_42_742 VPWR VGND sg13cmos5l_decap_8
XFILLER_14_433 VPWR VGND sg13cmos5l_fill_1
XFILLER_105_1009 VPWR VGND sg13cmos5l_decap_8
X_11674_ _11674_/Q _11767_/CLK _11674_/D _11674_/RESET_B VPWR VGND sg13cmos5l_dfrbpq_1
X_10625_ _10625_/X _11743_/Q _10675_/B VPWR VGND sg13cmos5l_and2_1
X_10556_ _11541_/D _10547_/Y _10549_/Y _10555_/Y VPWR VGND sg13cmos5l_o21ai_1
X_10487_ _10489_/A hold2819/X _10548_/B fanout84/X VPWR VGND sg13cmos5l_a21oi_1
X_10945__1037 _10945_/RESET_B VPWR VGND sg13cmos5l_tiehi
XFILLER_97_926 VPWR VGND sg13cmos5l_fill_1
XFILLER_97_915 VPWR VGND sg13cmos5l_decap_8
XFILLER_69_617 VPWR VGND sg13cmos5l_decap_4
XFILLER_69_606 VPWR VGND sg13cmos5l_decap_4
X_11201__1700 _11201_/RESET_B VPWR VGND sg13cmos5l_tiehi
X_11108_ _11108_/Q _11339_/CLK _11108_/D _11108_/RESET_B VPWR VGND sg13cmos5l_dfrbpq_1
XFILLER_38_6 VPWR VGND sg13cmos5l_fill_1
X_11039_ _11039_/Q clkload57/A _11039_/D _11039_/RESET_B VPWR VGND sg13cmos5l_dfrbpq_1
XFILLER_65_823 VPWR VGND sg13cmos5l_fill_2
XFILLER_94_70 VPWR VGND sg13cmos5l_decap_4
XFILLER_92_620 VPWR VGND sg13cmos5l_decap_8
XFILLER_65_856 VPWR VGND sg13cmos5l_fill_2
XFILLER_64_344 VPWR VGND sg13cmos5l_decap_8
XFILLER_91_130 VPWR VGND sg13cmos5l_decap_4
X_11234__1667 _11234_/RESET_B VPWR VGND sg13cmos5l_tiehi
XFILLER_52_517 VPWR VGND sg13cmos5l_fill_1
X_06580_ _06580_/Y _06580_/A _06580_/B VPWR VGND sg13cmos5l_nand2_1
XFILLER_33_742 VPWR VGND sg13cmos5l_decap_8
X_08250_ _11211_/D _08510_/A1 _08299_/B _08249_/Y VPWR VGND sg13cmos5l_a21oi_1
XFILLER_20_403 VPWR VGND sg13cmos5l_decap_8
XFILLER_20_414 VPWR VGND sg13cmos5l_fill_2
XFILLER_21_915 VPWR VGND sg13cmos5l_decap_8
X_08181_ _08181_/Y _08441_/B _08311_/B VPWR VGND sg13cmos5l_nand2_1
X_07201_ _07201_/X _07201_/A _10783_/C VPWR VGND sg13cmos5l_and2_1
XFILLER_20_458 VPWR VGND sg13cmos5l_fill_1
XFILLER_71_0 VPWR VGND sg13cmos5l_decap_8
X_07132_ _11731_/D _05874_/Y _07132_/A2 _07131_/Y VPWR VGND sg13cmos5l_a21oi_1
X_07063_ _07063_/Y _07063_/A _07389_/B VPWR VGND sg13cmos5l_nor2_1
X_06014_ _06019_/B _10691_/C _06014_/B _06014_/C VPWR VGND sg13cmos5l_and3_1
XFILLER_59_127 VPWR VGND sg13cmos5l_fill_2
X_07965_ _11072_/D fanout73/X _07982_/B _07964_/Y VPWR VGND sg13cmos5l_o21ai_1
X_06916_ _11688_/D hold2749/X hold2803/X _06917_/B VPWR VGND sg13cmos5l_mux2_1
X_09704_ _09729_/C _09704_/A _09704_/B VPWR VGND sg13cmos5l_or2_1
XFILLER_28_503 VPWR VGND sg13cmos5l_decap_8
X_07896_ _11038_/D fanout77/X _07911_/B _07895_/Y VPWR VGND sg13cmos5l_a21oi_1
XFILLER_67_171 VPWR VGND sg13cmos5l_fill_1
X_09635_ _09635_/Y _11353_/Q _09659_/S0 _09659_/S1 VPWR VGND sg13cmos5l_a21oi_1
X_06847_ _06848_/C _10691_/C _06944_/A _07190_/C VPWR VGND sg13cmos5l_nand3_1
XFILLER_71_815 VPWR VGND sg13cmos5l_decap_8
XFILLER_70_303 VPWR VGND sg13cmos5l_fill_1
XFILLER_56_878 VPWR VGND sg13cmos5l_decap_4
XFILLER_55_377 VPWR VGND sg13cmos5l_fill_2
XFILLER_55_355 VPWR VGND sg13cmos5l_decap_8
XFILLER_43_517 VPWR VGND sg13cmos5l_decap_8
XFILLER_83_697 VPWR VGND sg13cmos5l_fill_1
XFILLER_70_336 VPWR VGND sg13cmos5l_decap_8
X_06778_ _10820_/D _06778_/A _06778_/B VPWR VGND sg13cmos5l_nand2_1
XFILLER_36_580 VPWR VGND sg13cmos5l_decap_4
XFILLER_24_720 VPWR VGND sg13cmos5l_fill_1
X_09566_ _09566_/Y _09223_/C _09565_/X _09731_/A VPWR VGND sg13cmos5l_o21ai_1
XFILLER_90_28 VPWR VGND sg13cmos5l_decap_8
X_11694__1270 _11694_/RESET_B VPWR VGND sg13cmos5l_tiehi
XFILLER_70_369 VPWR VGND sg13cmos5l_decap_8
X_08517_ _08517_/Y _08517_/A _08535_/B VPWR VGND sg13cmos5l_nor2_1
X_09497_ _09497_/Y _09572_/B1 _09496_/X _09574_/B1 VPWR VGND sg13cmos5l_a21oi_1
X_08448_ _08448_/Y _08448_/A _08466_/B VPWR VGND sg13cmos5l_nand2_1
XFILLER_12_937 VPWR VGND sg13cmos5l_fill_1
XFILLER_23_274 VPWR VGND sg13cmos5l_decap_8
XFILLER_23_285 VPWR VGND sg13cmos5l_fill_2
XFILLER_23_296 VPWR VGND sg13cmos5l_decap_8
XFILLER_104_1020 VPWR VGND sg13cmos5l_decap_8
X_08379_ _08379_/Y _08379_/A _08429_/B VPWR VGND sg13cmos5l_nor2_1
X_10410_ _10411_/B _11745_/Q _10414_/A2 _07067_/B VPWR VGND sg13cmos5l_a21oi_1
X_11390_ _11390_/Q _11715_/CLK _11390_/D _11390_/RESET_B VPWR VGND sg13cmos5l_dfrbpq_1
XFILLER_20_992 VPWR VGND sg13cmos5l_decap_4
X_10341_ _10342_/C _10339_/Y _10340_/Y _10443_/B1 VPWR VGND sg13cmos5l_o21ai_1
XFILLER_105_530 VPWR VGND sg13cmos5l_decap_8
X_10272_ _10273_/C _10265_/A _10265_/C _10265_/B VPWR VGND sg13cmos5l_o21ai_1
XFILLER_78_403 VPWR VGND sg13cmos5l_fill_1
XFILLER_3_679 VPWR VGND sg13cmos5l_decap_8
X_11312__1589 _11312_/RESET_B VPWR VGND sg13cmos5l_tiehi
XFILLER_78_458 VPWR VGND sg13cmos5l_fill_1
XFILLER_48_41 VPWR VGND sg13cmos5l_fill_1
Xfanout471 _10007_/B _10021_/A2 VPWR VGND sg13cmos5l_buf_1
Xfanout482 fanout482/X _06451_/Y VPWR VGND sg13cmos5l_buf_1
XFILLER_59_683 VPWR VGND sg13cmos5l_decap_8
XFILLER_47_823 VPWR VGND sg13cmos5l_decap_4
XFILLER_48_85 VPWR VGND sg13cmos5l_fill_1
Xfanout460 _09544_/S _09552_/B VPWR VGND sg13cmos5l_buf_1
Xfanout493 _10115_/A2 _10058_/Y VPWR VGND sg13cmos5l_buf_1
XFILLER_19_525 VPWR VGND sg13cmos5l_decap_8
XFILLER_94_1008 VPWR VGND sg13cmos5l_fill_1
XFILLER_34_517 VPWR VGND sg13cmos5l_decap_4
XFILLER_104_91 VPWR VGND sg13cmos5l_decap_8
XFILLER_74_697 VPWR VGND sg13cmos5l_fill_2
XFILLER_46_399 VPWR VGND sg13cmos5l_fill_1
X_11726_ _11726_/Q clkload23/A _11726_/D _11726_/RESET_B VPWR VGND sg13cmos5l_dfrbpq_1
XFILLER_30_701 VPWR VGND sg13cmos5l_decap_8
X_11657_ _11657_/Q clkload13/A _11657_/D _11657_/RESET_B VPWR VGND sg13cmos5l_dfrbpq_1
X_11588_ _11588_/Q clkload25/A _11588_/D _11588_/RESET_B VPWR VGND sg13cmos5l_dfrbpq_1
X_10608_ _10628_/B _10632_/A _10608_/B VPWR VGND sg13cmos5l_or2_1
X_10539_ _10539_/Y _10539_/A _10539_/B VPWR VGND sg13cmos5l_nand2_1
X_11539__1495 _11539_/RESET_B VPWR VGND sg13cmos5l_tiehi
XFILLER_43_4 VPWR VGND sg13cmos5l_decap_8
XFILLER_97_723 VPWR VGND sg13cmos5l_fill_1
Xhold2309 _06796_/A _11599_/Q VPWR VGND sg13cmos5l_dlygate4sd3_1
XFILLER_9_1026 VPWR VGND sg13cmos5l_fill_2
XFILLER_97_756 VPWR VGND sg13cmos5l_fill_2
XFILLER_57_609 VPWR VGND sg13cmos5l_decap_8
XFILLER_38_812 VPWR VGND sg13cmos5l_fill_2
XFILLER_37_300 VPWR VGND sg13cmos5l_decap_8
X_07750_ _07750_/Y _07750_/A _07750_/B VPWR VGND sg13cmos5l_nor2_1
XFILLER_96_299 VPWR VGND sg13cmos5l_fill_1
XFILLER_65_620 VPWR VGND sg13cmos5l_fill_2
XFILLER_38_834 VPWR VGND sg13cmos5l_fill_2
XFILLER_37_311 VPWR VGND sg13cmos5l_fill_2
X_06701_ _06701_/Y _06739_/A _06701_/B VPWR VGND sg13cmos5l_nand2_1
XFILLER_64_130 VPWR VGND sg13cmos5l_fill_1
XFILLER_37_366 VPWR VGND sg13cmos5l_decap_4
X_07681_ _10934_/D _08075_/A1 _07702_/B _07680_/Y VPWR VGND sg13cmos5l_a21oi_1
XFILLER_65_697 VPWR VGND sg13cmos5l_fill_1
XFILLER_52_314 VPWR VGND sg13cmos5l_decap_8
X_09420_ _09420_/Y _11025_/Q _09417_/B _09842_/B1 VPWR VGND sg13cmos5l_a21oi_1
X_06632_ _06632_/Y _06636_/A _06632_/B VPWR VGND sg13cmos5l_xnor2_1
XFILLER_25_539 VPWR VGND sg13cmos5l_decap_8
XFILLER_80_645 VPWR VGND sg13cmos5l_decap_8
XFILLER_52_369 VPWR VGND sg13cmos5l_decap_8
X_06563_ _06563_/Y _06563_/A _06563_/B VPWR VGND sg13cmos5l_nand2_1
X_09351_ _09351_/Y hold2780/X _09404_/B _09350_/Y VPWR VGND sg13cmos5l_a21oi_1
XFILLER_80_689 VPWR VGND sg13cmos5l_decap_8
X_09282_ _09944_/A _09283_/A _09283_/B _09283_/C VPWR VGND sg13cmos5l_and3_1
X_08302_ _11237_/D fanout58/X _08301_/B _08301_/Y VPWR VGND sg13cmos5l_a21oi_1
XFILLER_100_49 VPWR VGND sg13cmos5l_decap_8
X_08233_ _11203_/D fanout61/X _08242_/B _08232_/Y VPWR VGND sg13cmos5l_o21ai_1
X_06494_ _06494_/Y _06492_/Y _06493_/Y _09574_/A1 VPWR VGND sg13cmos5l_a21oi_1
XFILLER_33_594 VPWR VGND sg13cmos5l_fill_2
XFILLER_20_255 VPWR VGND sg13cmos5l_fill_1
X_08164_ _11169_/D fanout68/X _08163_/B _08163_/Y VPWR VGND sg13cmos5l_a21oi_1
X_08095_ _11136_/D fanout73/X _08112_/B _08094_/Y VPWR VGND sg13cmos5l_o21ai_1
X_07115_ _07115_/Y _06881_/A _07120_/A2 _06091_/A VPWR VGND sg13cmos5l_o21ai_1
X_07046_ _07046_/Y _11513_/Q _10165_/B VPWR VGND sg13cmos5l_nand2_1
XFILLER_102_522 VPWR VGND sg13cmos5l_decap_4
Xhold2821 _10604_/B _10855_/Q VPWR VGND sg13cmos5l_dlygate4sd3_1
Xhold2810 hold2810/X _11631_/Q VPWR VGND sg13cmos5l_dlygate4sd3_1
Xhold2832 hold2832/X _11635_/Q VPWR VGND sg13cmos5l_dlygate4sd3_1
XFILLER_87_266 VPWR VGND sg13cmos5l_decap_8
XFILLER_85_28 VPWR VGND sg13cmos5l_decap_4
Xhold2865 _10685_/B _10683_/Y VPWR VGND sg13cmos5l_dlygate4sd3_1
XFILLER_76_929 VPWR VGND sg13cmos5l_fill_1
XFILLER_75_406 VPWR VGND sg13cmos5l_fill_2
Xhold2843 hold2843/X _11483_/Q VPWR VGND sg13cmos5l_dlygate4sd3_1
X_08997_ _09036_/D _08997_/A _08997_/B _08997_/C VPWR VGND sg13cmos5l_nor3_1
XFILLER_47_108 VPWR VGND sg13cmos5l_fill_1
Xhold2854 _11496_/D _10085_/X VPWR VGND sg13cmos5l_dlygate4sd3_1
XFILLER_29_812 VPWR VGND sg13cmos5l_decap_8
Xhold2898 hold2898/X _11589_/Q VPWR VGND sg13cmos5l_dlygate4sd3_1
Xhold2876 _11482_/D _09946_/Y VPWR VGND sg13cmos5l_dlygate4sd3_1
XFILLER_68_491 VPWR VGND sg13cmos5l_decap_8
Xhold2887 hold2887/X _11461_/Q VPWR VGND sg13cmos5l_dlygate4sd3_1
X_07948_ _07948_/Y _07948_/A _07948_/B VPWR VGND sg13cmos5l_nand2_1
X_07879_ _07879_/Y _07879_/A _07901_/B VPWR VGND sg13cmos5l_nor2_1
XFILLER_28_355 VPWR VGND sg13cmos5l_fill_2
XFILLER_29_867 VPWR VGND sg13cmos5l_fill_1
X_10890_ _10890_/Q _11622_/CLK _10890_/D _10890_/RESET_B VPWR VGND sg13cmos5l_dfrbpq_1
XFILLER_83_472 VPWR VGND sg13cmos5l_fill_2
XFILLER_55_185 VPWR VGND sg13cmos5l_decap_4
X_09618_ _09618_/Y _09618_/A _09618_/B VPWR VGND sg13cmos5l_nor2_1
XFILLER_70_122 VPWR VGND sg13cmos5l_decap_4
X_09549_ _09549_/X _11126_/Q _11094_/Q _11062_/Q _11030_/Q _09544_/S _09707_/S1 VPWR
+ VGND sg13cmos5l_mux4_1
XFILLER_34_21 VPWR VGND sg13cmos5l_fill_2
XFILLER_70_166 VPWR VGND sg13cmos5l_fill_2
XFILLER_52_881 VPWR VGND sg13cmos5l_fill_2
XFILLER_52_870 VPWR VGND sg13cmos5l_decap_8
XFILLER_24_550 VPWR VGND sg13cmos5l_decap_4
X_11511_ _11511_/Q clkload48/A _11511_/D _11511_/RESET_B VPWR VGND sg13cmos5l_dfrbpq_1
X_11442_ _11442_/Q clkload43/A _11442_/D _11442_/RESET_B VPWR VGND sg13cmos5l_dfrbpq_1
X_11373_ _11373_/Q clkload28/A _11373_/D _11373_/RESET_B VPWR VGND sg13cmos5l_dfrbpq_1
X_10324_ _10324_/Y _11724_/Q _10441_/B1 _10159_/X _07007_/A VPWR VGND sg13cmos5l_a22oi_1
XFILLER_3_410 VPWR VGND sg13cmos5l_decap_8
XFILLER_106_861 VPWR VGND sg13cmos5l_decap_8
XFILLER_98_509 VPWR VGND sg13cmos5l_fill_2
XFILLER_79_723 VPWR VGND sg13cmos5l_decap_4
X_10255_ _10255_/X _10265_/A _10255_/B VPWR VGND sg13cmos5l_or2_1
XFILLER_1_0 VPWR VGND sg13cmos5l_decap_8
XFILLER_78_233 VPWR VGND sg13cmos5l_fill_1
X_10186_ _10188_/B _10187_/A _10187_/B VPWR VGND sg13cmos5l_nor2_1
X_10862__1120 _10862_/RESET_B VPWR VGND sg13cmos5l_tiehi
XFILLER_78_277 VPWR VGND sg13cmos5l_fill_1
XFILLER_67_929 VPWR VGND sg13cmos5l_decap_8
Xfanout290 _08102_/B _08108_/B VPWR VGND sg13cmos5l_buf_1
XFILLER_78_299 VPWR VGND sg13cmos5l_decap_8
XFILLER_47_620 VPWR VGND sg13cmos5l_fill_2
XFILLER_19_322 VPWR VGND sg13cmos5l_decap_8
XFILLER_19_366 VPWR VGND sg13cmos5l_decap_8
XFILLER_90_910 VPWR VGND sg13cmos5l_fill_1
XFILLER_74_483 VPWR VGND sg13cmos5l_decap_4
X_10895__1087 _10895_/RESET_B VPWR VGND sg13cmos5l_tiehi
XFILLER_19_377 VPWR VGND sg13cmos5l_fill_2
XFILLER_34_314 VPWR VGND sg13cmos5l_fill_2
XFILLER_50_807 VPWR VGND sg13cmos5l_decap_8
X_11151__1750 _11151_/RESET_B VPWR VGND sg13cmos5l_tiehi
XFILLER_34_369 VPWR VGND sg13cmos5l_decap_4
XFILLER_42_380 VPWR VGND sg13cmos5l_decap_4
X_11709_ _11709_/Q clkload28/A _11709_/D _11709_/RESET_B VPWR VGND sg13cmos5l_dfrbpq_1
XFILLER_30_575 VPWR VGND sg13cmos5l_decap_4
X_08920_ _08922_/B _08940_/A _08916_/Y _08919_/Y VPWR VGND sg13cmos5l_o21ai_1
XFILLER_97_531 VPWR VGND sg13cmos5l_fill_2
Xhold2117 _07579_/A _10910_/Q VPWR VGND sg13cmos5l_dlygate4sd3_1
X_08851_ _08851_/Y _08861_/D _08851_/B VPWR VGND sg13cmos5l_xnor2_1
Xhold2106 _07680_/A _10934_/Q VPWR VGND sg13cmos5l_dlygate4sd3_1
Xhold2128 _07903_/A _11042_/Q VPWR VGND sg13cmos5l_dlygate4sd3_1
XFILLER_85_704 VPWR VGND sg13cmos5l_decap_8
Xhold2139 _11559_/D _10726_/Y VPWR VGND sg13cmos5l_dlygate4sd3_1
XFILLER_69_266 VPWR VGND sg13cmos5l_fill_1
XFILLER_57_417 VPWR VGND sg13cmos5l_decap_4
X_07802_ _07802_/Y _07802_/A _07834_/B VPWR VGND sg13cmos5l_nand2_1
XFILLER_97_597 VPWR VGND sg13cmos5l_fill_2
X_08782_ _08784_/A _11635_/Q _08817_/A VPWR VGND sg13cmos5l_xnor2_1
X_05994_ _08614_/B _11376_/Q _08620_/A VPWR VGND sg13cmos5l_nor2_1
X_07733_ _10959_/D _08518_/A1 _07750_/B _07732_/Y VPWR VGND sg13cmos5l_a21oi_1
XFILLER_77_1014 VPWR VGND sg13cmos5l_decap_8
XFILLER_77_1003 VPWR VGND sg13cmos5l_fill_2
XFILLER_65_472 VPWR VGND sg13cmos5l_decap_8
XFILLER_38_675 VPWR VGND sg13cmos5l_decap_8
X_07664_ _07664_/Y _07664_/A _07682_/B VPWR VGND sg13cmos5l_nor2_1
XFILLER_25_303 VPWR VGND sg13cmos5l_decap_8
XFILLER_25_314 VPWR VGND sg13cmos5l_decap_8
XFILLER_53_645 VPWR VGND sg13cmos5l_decap_8
XFILLER_37_185 VPWR VGND sg13cmos5l_fill_1
X_09403_ _09403_/Y _09506_/A _09403_/B _09403_/C VPWR VGND sg13cmos5l_nand3_1
X_06615_ _06615_/Y _06618_/B _06400_/B _06643_/B1 _06612_/Y VPWR VGND sg13cmos5l_a22oi_1
XFILLER_41_829 VPWR VGND sg13cmos5l_decap_8
X_07595_ _07595_/Y _07595_/A _07595_/B VPWR VGND sg13cmos5l_nor2_1
XFILLER_52_188 VPWR VGND sg13cmos5l_decap_8
X_09334_ _11458_/D fanout95/X _09332_/Y _09333_/Y VPWR VGND sg13cmos5l_o21ai_1
XFILLER_21_531 VPWR VGND sg13cmos5l_fill_2
X_06546_ _06548_/A _06133_/B _11654_/Q _10864_/Q _06574_/B2 VPWR VGND sg13cmos5l_a22oi_1
X_09265_ _09265_/Y _10005_/A _09976_/B VPWR VGND sg13cmos5l_nand2b_1
X_06477_ _06477_/Y _09733_/S _06477_/B VPWR VGND sg13cmos5l_nand2_1
XFILLER_21_553 VPWR VGND sg13cmos5l_fill_1
X_08216_ _08216_/Y _08216_/A _08216_/B VPWR VGND sg13cmos5l_nand2_1
X_10940__1042 _10940_/RESET_B VPWR VGND sg13cmos5l_tiehi
X_09196_ _09196_/X _09175_/X _09195_/Y _09174_/X VPWR VGND sg13cmos5l_a21o_1
XFILLER_101_1023 VPWR VGND sg13cmos5l_decap_4
XFILLER_5_708 VPWR VGND sg13cmos5l_decap_8
X_08147_ _08147_/Y _08147_/A _08163_/B VPWR VGND sg13cmos5l_nor2_1
X_08078_ _08078_/Y _08078_/A _08078_/B VPWR VGND sg13cmos5l_nand2_1
XFILLER_106_168 VPWR VGND sg13cmos5l_decap_8
XFILLER_0_413 VPWR VGND sg13cmos5l_fill_1
XFILLER_1_925 VPWR VGND sg13cmos5l_decap_8
X_11193__1708 _11193_/RESET_B VPWR VGND sg13cmos5l_tiehi
X_07029_ _07029_/Y _11508_/Q _07055_/B _07028_/X VPWR VGND sg13cmos5l_a21oi_1
X_10040_ _10040_/Y _10984_/Q _10034_/B _10046_/B1 VPWR VGND sg13cmos5l_a21oi_1
XFILLER_96_49 VPWR VGND sg13cmos5l_decap_8
XFILLER_88_586 VPWR VGND sg13cmos5l_fill_2
XFILLER_76_704 VPWR VGND sg13cmos5l_decap_8
Xhold2640 _07063_/A _11680_/Q VPWR VGND sg13cmos5l_dlygate4sd3_1
Xhold2662 hold2662/X _11596_/Q VPWR VGND sg13cmos5l_dlygate4sd3_1
Xhold2651 _10122_/B _10850_/Q VPWR VGND sg13cmos5l_dlygate4sd3_1
Xhold2673 _06059_/A _11373_/Q VPWR VGND sg13cmos5l_dlygate4sd3_1
XFILLER_48_439 VPWR VGND sg13cmos5l_fill_2
XFILLER_21_1002 VPWR VGND sg13cmos5l_decap_4
Xhold1950 _06813_/A _11605_/Q VPWR VGND sg13cmos5l_dlygate4sd3_1
Xhold2695 _10679_/B _10829_/Q VPWR VGND sg13cmos5l_dlygate4sd3_1
XFILLER_75_269 VPWR VGND sg13cmos5l_decap_8
Xhold2684 _07246_/B _07245_/Y VPWR VGND sg13cmos5l_dlygate4sd3_1
Xhold1961 _08496_/A _11333_/Q VPWR VGND sg13cmos5l_dlygate4sd3_1
XFILLER_56_450 VPWR VGND sg13cmos5l_fill_2
Xhold1972 _08198_/A _11186_/Q VPWR VGND sg13cmos5l_dlygate4sd3_1
X_10942_ _10942_/Q clkload58/A _10942_/D _10942_/RESET_B VPWR VGND sg13cmos5l_dfrbpq_1
XFILLER_84_792 VPWR VGND sg13cmos5l_fill_2
XFILLER_72_910 VPWR VGND sg13cmos5l_decap_4
Xhold1994 _08062_/A _11120_/Q VPWR VGND sg13cmos5l_dlygate4sd3_1
Xhold1983 _07932_/A _11056_/Q VPWR VGND sg13cmos5l_dlygate4sd3_1
XFILLER_56_494 VPWR VGND sg13cmos5l_fill_2
XFILLER_16_358 VPWR VGND sg13cmos5l_fill_1
XFILLER_16_369 VPWR VGND sg13cmos5l_fill_1
X_10873_ _10873_/Q clkload12/A _10873_/D _10873_/RESET_B VPWR VGND sg13cmos5l_dfrbpq_1
XFILLER_101_70 VPWR VGND sg13cmos5l_decap_8
XFILLER_43_188 VPWR VGND sg13cmos5l_decap_8
XFILLER_24_380 VPWR VGND sg13cmos5l_fill_1
XFILLER_25_881 VPWR VGND sg13cmos5l_fill_1
XFILLER_40_840 VPWR VGND sg13cmos5l_fill_1
XFILLER_8_513 VPWR VGND sg13cmos5l_fill_1
XFILLER_40_884 VPWR VGND sg13cmos5l_decap_8
XFILLER_6_14 VPWR VGND sg13cmos5l_decap_8
X_11425_ _11425_/Q clkload14/A _11425_/D _11425_/RESET_B VPWR VGND sg13cmos5l_dfrbpq_1
XANTENNA_7 _07358_/Y VPWR VGND sg13cmos5l_antennanp
X_11640__1326 _11640_/RESET_B VPWR VGND sg13cmos5l_tiehi
X_11356_ _11356_/Q _11356_/CLK _11356_/D _11356_/RESET_B VPWR VGND sg13cmos5l_dfrbpq_1
X_10307_ _10523_/B _10307_/A _10307_/B VPWR VGND sg13cmos5l_xnor2_1
XFILLER_3_251 VPWR VGND sg13cmos5l_decap_8
X_11287_ _11287_/Q _11347_/CLK _11287_/D _11287_/RESET_B VPWR VGND sg13cmos5l_dfrbpq_1
X_11169__1732 _11169_/RESET_B VPWR VGND sg13cmos5l_tiehi
XFILLER_94_501 VPWR VGND sg13cmos5l_decap_4
X_10238_ _10239_/B _06881_/A _07067_/X _10166_/X hold2806/X VPWR VGND sg13cmos5l_a22oi_1
XFILLER_6_1018 VPWR VGND sg13cmos5l_decap_8
XFILLER_94_534 VPWR VGND sg13cmos5l_fill_1
XFILLER_94_523 VPWR VGND sg13cmos5l_decap_8
X_10169_ _10169_/Y _10703_/A hold2774/X _10162_/X _10171_/A VPWR VGND sg13cmos5l_a22oi_1
XFILLER_66_269 VPWR VGND sg13cmos5l_fill_1
XFILLER_81_217 VPWR VGND sg13cmos5l_fill_1
XFILLER_75_792 VPWR VGND sg13cmos5l_decap_8
XFILLER_35_601 VPWR VGND sg13cmos5l_fill_1
XFILLER_19_163 VPWR VGND sg13cmos5l_fill_2
XFILLER_34_100 VPWR VGND sg13cmos5l_decap_4
XFILLER_62_442 VPWR VGND sg13cmos5l_decap_4
XFILLER_47_494 VPWR VGND sg13cmos5l_fill_2
X_06400_ _06400_/Y _11646_/Q _06400_/B _06401_/C _06400_/D VPWR VGND sg13cmos5l_nor4_1
XFILLER_34_144 VPWR VGND sg13cmos5l_decap_8
X_07380_ _08738_/A _11446_/Q _07380_/B VPWR VGND sg13cmos5l_nand2_1
XFILLER_50_659 VPWR VGND sg13cmos5l_fill_1
XFILLER_34_188 VPWR VGND sg13cmos5l_decap_8
X_06331_ _06332_/A _10658_/A _06420_/B _06329_/Y VPWR VGND sg13cmos5l_o21ai_1
X_06262_ _06264_/B _06262_/A _06321_/B VPWR VGND sg13cmos5l_nor2_1
X_09050_ _09050_/Y _09068_/A _09068_/D VPWR VGND sg13cmos5l_xnor2_1
X_08001_ _08001_/Y _08001_/A _08011_/B VPWR VGND sg13cmos5l_nor2_1
X_06193_ _06585_/A _06194_/A _07077_/A VPWR VGND sg13cmos5l_nand2_1
XFILLER_104_639 VPWR VGND sg13cmos5l_decap_8
XFILLER_103_105 VPWR VGND sg13cmos5l_decap_8
X_09952_ _09952_/Y _10949_/Q _09957_/B VPWR VGND sg13cmos5l_nand2_1
X_08903_ _08903_/Y _08921_/A _08896_/B _08922_/A VPWR VGND sg13cmos5l_o21ai_1
X_09883_ _09884_/B _10305_/A _09970_/B _09882_/Y VPWR VGND sg13cmos5l_o21ai_1
X_08834_ _08834_/Y _08834_/A _08846_/B VPWR VGND sg13cmos5l_nand2_1
X_08765_ _11421_/D _08765_/A VPWR VGND sg13cmos5l_inv_1
XFILLER_45_409 VPWR VGND sg13cmos5l_decap_8
XFILLER_39_940 VPWR VGND sg13cmos5l_fill_2
X_07716_ _07716_/Y _07716_/A _07718_/B VPWR VGND sg13cmos5l_nor2_1
XFILLER_72_217 VPWR VGND sg13cmos5l_decap_8
XFILLER_54_932 VPWR VGND sg13cmos5l_decap_8
XFILLER_54_910 VPWR VGND sg13cmos5l_decap_4
X_05977_ _05977_/Y _11325_/Q VPWR VGND sg13cmos5l_inv_1
X_10958__1024 _10958_/RESET_B VPWR VGND sg13cmos5l_tiehi
XFILLER_82_29 VPWR VGND sg13cmos5l_decap_8
X_08696_ _08930_/B _08921_/B VPWR VGND sg13cmos5l_inv_1
X_07647_ _10920_/D _07648_/B fanout51/X _07646_/Y VPWR VGND sg13cmos5l_a21oi_1
X_11753__914 _11753_/RESET_B VPWR VGND sg13cmos5l_tiehi
XFILLER_26_689 VPWR VGND sg13cmos5l_decap_8
X_07578_ _07578_/Y _07591_/A _08726_/B _07584_/B _07577_/Y VPWR VGND sg13cmos5l_a22oi_1
X_09317_ _09349_/B _09317_/A _09885_/B VPWR VGND sg13cmos5l_nand2_1
X_06529_ _06530_/B _06571_/A1 _11664_/Q _10874_/Q _06571_/B2 VPWR VGND sg13cmos5l_a22oi_1
XFILLER_51_1028 VPWR VGND sg13cmos5l_fill_1
XFILLER_51_1017 VPWR VGND sg13cmos5l_decap_8
X_11247__1654 _11247_/RESET_B VPWR VGND sg13cmos5l_tiehi
X_09248_ _09919_/A _09968_/A _10604_/B VPWR VGND sg13cmos5l_xnor2_1
X_09179_ _09179_/Y _09180_/A _10832_/Q VPWR VGND sg13cmos5l_nand2_1
Xclkbuf_4_10_0_clk clkbuf_4_10_0_clk/X clkbuf_0_clk/X VPWR VGND sg13cmos5l_buf_8
X_11210_ _11210_/Q _11646_/CLK _11210_/D _11210_/RESET_B VPWR VGND sg13cmos5l_dfrbpq_1
XFILLER_31_88 VPWR VGND sg13cmos5l_fill_2
X_11141_ _11141_/Q _11355_/CLK _11141_/D _11141_/RESET_B VPWR VGND sg13cmos5l_dfrbpq_1
Xoutput22 uio_out[11] _11683_/Q VPWR VGND sg13cmos5l_buf_1
Xoutput33 uo_out[0] _06530_/Y VPWR VGND sg13cmos5l_buf_1
XFILLER_1_744 VPWR VGND sg13cmos5l_decap_8
Xoutput44 uo_out[5] _06545_/Y VPWR VGND sg13cmos5l_buf_1
X_11072_ _11072_/Q clkload57/A _11072_/D _11072_/RESET_B VPWR VGND sg13cmos5l_dfrbpq_1
XFILLER_0_243 VPWR VGND sg13cmos5l_decap_8
X_10023_ _10024_/C _09933_/A _10018_/X _10022_/Y VPWR VGND sg13cmos5l_o21ai_1
XFILLER_89_895 VPWR VGND sg13cmos5l_fill_2
XFILLER_88_394 VPWR VGND sg13cmos5l_decap_4
XFILLER_102_182 VPWR VGND sg13cmos5l_decap_8
Xhold2470 _06853_/A _11617_/Q VPWR VGND sg13cmos5l_dlygate4sd3_1
XFILLER_48_269 VPWR VGND sg13cmos5l_decap_8
XFILLER_48_247 VPWR VGND sg13cmos5l_decap_8
Xhold2481 _10073_/A _11493_/Q VPWR VGND sg13cmos5l_dlygate4sd3_1
XFILLER_63_228 VPWR VGND sg13cmos5l_fill_1
XFILLER_63_217 VPWR VGND sg13cmos5l_decap_8
Xhold2492 hold2492/X _11674_/Q VPWR VGND sg13cmos5l_dlygate4sd3_1
XFILLER_17_623 VPWR VGND sg13cmos5l_decap_8
XFILLER_29_494 VPWR VGND sg13cmos5l_decap_8
XFILLER_44_442 VPWR VGND sg13cmos5l_decap_8
X_10925_ _10925_/Q clkload34/A _10925_/D _10925_/RESET_B VPWR VGND sg13cmos5l_dfrbpq_1
XFILLER_16_155 VPWR VGND sg13cmos5l_decap_8
XFILLER_72_795 VPWR VGND sg13cmos5l_decap_8
X_10856_ _10856_/Q _11715_/CLK _10856_/D _10856_/RESET_B VPWR VGND sg13cmos5l_dfrbpq_1
XFILLER_72_40 VPWR VGND sg13cmos5l_fill_1
XFILLER_16_199 VPWR VGND sg13cmos5l_decap_8
XFILLER_72_73 VPWR VGND sg13cmos5l_fill_2
XFILLER_31_136 VPWR VGND sg13cmos5l_fill_1
X_10787_ _10787_/Y _10787_/A _10791_/B VPWR VGND sg13cmos5l_nand2_1
XFILLER_40_670 VPWR VGND sg13cmos5l_decap_4
XFILLER_8_321 VPWR VGND sg13cmos5l_decap_8
XFILLER_9_833 VPWR VGND sg13cmos5l_fill_2
XFILLER_13_873 VPWR VGND sg13cmos5l_fill_2
X_11379__1519 _11379_/RESET_B VPWR VGND sg13cmos5l_tiehi
XFILLER_40_692 VPWR VGND sg13cmos5l_decap_4
XFILLER_8_343 VPWR VGND sg13cmos5l_fill_1
XFILLER_9_855 VPWR VGND sg13cmos5l_fill_2
XFILLER_9_899 VPWR VGND sg13cmos5l_decap_8
X_11408_ _11408_/Q _11535_/CLK _11408_/D _11408_/RESET_B VPWR VGND sg13cmos5l_dfrbpq_1
XFILLER_99_604 VPWR VGND sg13cmos5l_fill_1
XFILLER_99_659 VPWR VGND sg13cmos5l_fill_1
XFILLER_98_147 VPWR VGND sg13cmos5l_decap_8
X_11339_ _11339_/Q _11339_/CLK _11339_/D _11339_/RESET_B VPWR VGND sg13cmos5l_dfrbpq_1
XFILLER_4_582 VPWR VGND sg13cmos5l_decap_8
XFILLER_97_70 VPWR VGND sg13cmos5l_decap_8
XFILLER_67_501 VPWR VGND sg13cmos5l_fill_1
XFILLER_100_119 VPWR VGND sg13cmos5l_decap_8
XFILLER_95_832 VPWR VGND sg13cmos5l_fill_2
XFILLER_94_320 VPWR VGND sg13cmos5l_decap_8
X_06880_ _06880_/Y _05892_/Y _06784_/Y _06879_/Y VPWR VGND sg13cmos5l_o21ai_1
X_05900_ _05900_/Y _09938_/A VPWR VGND sg13cmos5l_inv_1
XFILLER_82_526 VPWR VGND sg13cmos5l_decap_8
XFILLER_67_578 VPWR VGND sg13cmos5l_decap_8
XFILLER_54_206 VPWR VGND sg13cmos5l_decap_8
XFILLER_48_781 VPWR VGND sg13cmos5l_decap_8
X_11325__1576 _11325_/RESET_B VPWR VGND sg13cmos5l_tiehi
X_08550_ _11359_/D fanout74/X _08559_/B _08549_/Y VPWR VGND sg13cmos5l_a21oi_1
XFILLER_36_943 VPWR VGND sg13cmos5l_decap_8
XFILLER_36_987 VPWR VGND sg13cmos5l_decap_4
X_08481_ _11325_/D fanout79/X _08488_/B _08480_/Y VPWR VGND sg13cmos5l_o21ai_1
X_07501_ _07501_/Y _10331_/A _07492_/Y _07493_/A VPWR VGND sg13cmos5l_a21oi_1
X_07432_ _10889_/D _07431_/B _07430_/Y _07431_/Y VPWR VGND sg13cmos5l_a21oi_1
X_09102_ _09118_/D _09102_/A _09102_/B VPWR VGND sg13cmos5l_and2_1
X_07363_ _07363_/Y _07361_/Y _08727_/A _07375_/B1 VPWR VGND sg13cmos5l_a21oi_1
XFILLER_22_169 VPWR VGND sg13cmos5l_fill_2
X_07294_ _07294_/Y _07407_/B _07292_/Y _07293_/Y VPWR VGND sg13cmos5l_a21oi_1
X_06314_ _06314_/Y _10424_/B _10298_/A VPWR VGND sg13cmos5l_nand2b_1
XFILLER_31_692 VPWR VGND sg13cmos5l_decap_8
X_06245_ _10672_/A _11517_/Q _09268_/A VPWR VGND sg13cmos5l_xnor2_1
X_09033_ _09069_/B _09043_/A _09036_/C VPWR VGND sg13cmos5l_xnor2_1
X_10802__939 _10802_/RESET_B VPWR VGND sg13cmos5l_tiehi
XFILLER_105_904 VPWR VGND sg13cmos5l_decap_8
X_06176_ _06353_/B _06633_/A _06177_/B VPWR VGND sg13cmos5l_and2_1
XFILLER_89_103 VPWR VGND sg13cmos5l_fill_1
XFILLER_104_447 VPWR VGND sg13cmos5l_decap_8
XFILLER_89_114 VPWR VGND sg13cmos5l_decap_4
XFILLER_104_458 VPWR VGND sg13cmos5l_fill_1
X_09935_ _09935_/Y _05982_/Y _10012_/B _10015_/B1 _09934_/Y VPWR VGND sg13cmos5l_a22oi_1
Xfanout834 _10630_/B _10503_/A VPWR VGND sg13cmos5l_buf_1
X_11736__1208 _11736_/RESET_B VPWR VGND sg13cmos5l_tiehi
Xfanout823 _06117_/A _10326_/A VPWR VGND sg13cmos5l_buf_1
Xfanout812 _09052_/A _09154_/A1 VPWR VGND sg13cmos5l_buf_1
Xfanout801 _07472_/D hold2921/X VPWR VGND sg13cmos5l_buf_1
X_10890__1092 _10890_/RESET_B VPWR VGND sg13cmos5l_tiehi
XFILLER_86_832 VPWR VGND sg13cmos5l_fill_1
X_09866_ _09866_/Y _10978_/Q _09984_/B _09990_/S1 VPWR VGND sg13cmos5l_a21oi_1
X_08817_ _08852_/D _08817_/A _08817_/B _08817_/C _08817_/D VPWR VGND sg13cmos5l_nand4_1
XFILLER_93_28 VPWR VGND sg13cmos5l_decap_8
X_09797_ _09797_/Y _11295_/Q _10019_/B VPWR VGND sg13cmos5l_nor2_1
XFILLER_85_386 VPWR VGND sg13cmos5l_fill_2
XFILLER_46_729 VPWR VGND sg13cmos5l_decap_8
XFILLER_45_206 VPWR VGND sg13cmos5l_fill_2
XFILLER_27_910 VPWR VGND sg13cmos5l_fill_2
XFILLER_73_548 VPWR VGND sg13cmos5l_decap_8
X_08748_ _08748_/Y hold2548/X _09093_/B _09077_/B _09106_/B1 VPWR VGND sg13cmos5l_a22oi_1
XFILLER_54_740 VPWR VGND sg13cmos5l_fill_1
X_08679_ _08890_/A _07326_/B _07499_/B _07296_/Y VPWR VGND sg13cmos5l_o21ai_1
XFILLER_81_581 VPWR VGND sg13cmos5l_decap_8
XFILLER_81_570 VPWR VGND sg13cmos5l_fill_2
X_10710_ _10730_/A _10731_/A _10710_/B VPWR VGND sg13cmos5l_nand2_1
XFILLER_53_283 VPWR VGND sg13cmos5l_fill_1
X_11690_ _11690_/Q clkload25/A _11690_/D _11690_/RESET_B VPWR VGND sg13cmos5l_dfrbpq_1
XFILLER_41_445 VPWR VGND sg13cmos5l_decap_8
XFILLER_14_659 VPWR VGND sg13cmos5l_decap_4
X_10641_ _10642_/B _10641_/A _10641_/B VPWR VGND sg13cmos5l_nand2_1
XFILLER_41_478 VPWR VGND sg13cmos5l_decap_8
X_10572_ _10573_/C _10552_/Y _10567_/B _10569_/B _10497_/Y _10570_/Y VPWR VGND sg13cmos5l_a221oi_1
XFILLER_22_681 VPWR VGND sg13cmos5l_decap_8
XFILLER_42_98 VPWR VGND sg13cmos5l_fill_1
XFILLER_21_191 VPWR VGND sg13cmos5l_decap_8
XFILLER_5_335 VPWR VGND sg13cmos5l_fill_2
XFILLER_101_0 VPWR VGND sg13cmos5l_decap_8
X_11124_ _11124_/Q _11347_/CLK _11124_/D _11124_/RESET_B VPWR VGND sg13cmos5l_dfrbpq_1
XFILLER_1_552 VPWR VGND sg13cmos5l_fill_2
XFILLER_104_992 VPWR VGND sg13cmos5l_decap_8
XFILLER_95_139 VPWR VGND sg13cmos5l_decap_8
X_11418__1454 _11418_/RESET_B VPWR VGND sg13cmos5l_tiehi
X_11055_ _11055_/Q clkload44/A _11055_/D _11055_/RESET_B VPWR VGND sg13cmos5l_dfrbpq_1
XFILLER_103_480 VPWR VGND sg13cmos5l_decap_4
X_10006_ _10006_/Y _10006_/A _10006_/B _10006_/C VPWR VGND sg13cmos5l_nand3_1
XFILLER_76_320 VPWR VGND sg13cmos5l_fill_1
X_11469__1245 _11469_/RESET_B VPWR VGND sg13cmos5l_tiehi
XFILLER_97_1028 VPWR VGND sg13cmos5l_fill_1
XFILLER_97_1017 VPWR VGND sg13cmos5l_decap_8
XFILLER_92_813 VPWR VGND sg13cmos5l_fill_1
XFILLER_91_378 VPWR VGND sg13cmos5l_decap_4
XFILLER_83_50 VPWR VGND sg13cmos5l_decap_8
XFILLER_17_442 VPWR VGND sg13cmos5l_decap_8
XFILLER_18_976 VPWR VGND sg13cmos5l_fill_1
XFILLER_72_592 VPWR VGND sg13cmos5l_decap_8
XFILLER_60_732 VPWR VGND sg13cmos5l_decap_4
X_10908_ _10908_/Q _11356_/CLK _10908_/D _10908_/RESET_B VPWR VGND sg13cmos5l_dfrbpq_1
XFILLER_17_475 VPWR VGND sg13cmos5l_fill_1
XFILLER_32_401 VPWR VGND sg13cmos5l_fill_1
XFILLER_33_935 VPWR VGND sg13cmos5l_fill_1
XFILLER_60_743 VPWR VGND sg13cmos5l_fill_2
XFILLER_20_607 VPWR VGND sg13cmos5l_decap_8
X_10839_ _10839_/Q _11713_/CLK _10839_/D _10839_/RESET_B VPWR VGND sg13cmos5l_dfrbpq_1
XFILLER_60_798 VPWR VGND sg13cmos5l_fill_1
X_06030_ _06030_/Y _06030_/A _06030_/B _07067_/A VPWR VGND sg13cmos5l_nor3_1
XFILLER_5_891 VPWR VGND sg13cmos5l_fill_1
X_07981_ _11080_/D fanout51/X _07982_/B _07980_/Y VPWR VGND sg13cmos5l_o21ai_1
XFILLER_87_607 VPWR VGND sg13cmos5l_fill_2
XFILLER_59_309 VPWR VGND sg13cmos5l_fill_1
Xfanout119 _08466_/B _08441_/Y VPWR VGND sg13cmos5l_buf_1
Xfanout108 _08073_/A1 _07516_/Y VPWR VGND sg13cmos5l_buf_1
XFILLER_101_417 VPWR VGND sg13cmos5l_decap_4
X_06932_ _11641_/D _06065_/B _10776_/B _06931_/Y VPWR VGND sg13cmos5l_a21o_1
X_09720_ _09727_/B _09745_/A _09720_/B VPWR VGND sg13cmos5l_nor2_1
XFILLER_67_342 VPWR VGND sg13cmos5l_fill_2
X_10852__1138 _10852_/RESET_B VPWR VGND sg13cmos5l_tiehi
XFILLER_95_684 VPWR VGND sg13cmos5l_fill_1
XFILLER_94_161 VPWR VGND sg13cmos5l_fill_1
X_06863_ _06863_/Y _06863_/A _10791_/B VPWR VGND sg13cmos5l_nand2_1
XFILLER_55_526 VPWR VGND sg13cmos5l_decap_8
X_09651_ _09651_/Y _09649_/Y _09651_/B VPWR VGND sg13cmos5l_nand2b_1
XFILLER_103_49 VPWR VGND sg13cmos5l_decap_8
X_08602_ _08602_/Y _11275_/Q _10019_/B _08601_/Y VPWR VGND sg13cmos5l_o21ai_1
XFILLER_82_323 VPWR VGND sg13cmos5l_fill_2
X_06794_ _06832_/A _06825_/A _06804_/B VPWR VGND sg13cmos5l_nand2b_1
XFILLER_27_228 VPWR VGND sg13cmos5l_decap_4
X_09582_ _09582_/Y _09721_/A _09668_/B _09506_/A VPWR VGND sg13cmos5l_o21ai_1
XFILLER_82_378 VPWR VGND sg13cmos5l_decap_8
XFILLER_36_773 VPWR VGND sg13cmos5l_fill_2
X_08533_ _08533_/Y _08533_/A _08533_/B VPWR VGND sg13cmos5l_nor2_1
XFILLER_36_784 VPWR VGND sg13cmos5l_decap_8
XFILLER_24_924 VPWR VGND sg13cmos5l_fill_1
XFILLER_50_231 VPWR VGND sg13cmos5l_decap_8
X_08464_ _08464_/Y _08464_/A _08464_/B VPWR VGND sg13cmos5l_nand2_1
X_07415_ _07415_/Y _11548_/Q _08762_/A VPWR VGND sg13cmos5l_nand2_1
X_08395_ _08395_/Y _08395_/A _08403_/B VPWR VGND sg13cmos5l_nor2_1
X_07346_ _07346_/Y _10298_/A _07376_/A2 _07345_/Y VPWR VGND sg13cmos5l_a21oi_1
X_09016_ _09034_/A _09043_/A _09036_/B VPWR VGND sg13cmos5l_and2_1
X_07277_ _07277_/Y _11525_/Q _08667_/S VPWR VGND sg13cmos5l_nand2_1
XFILLER_88_28 VPWR VGND sg13cmos5l_decap_8
X_06228_ _06719_/B _10423_/B _09613_/A VPWR VGND sg13cmos5l_nor2_1
XFILLER_5_7 VPWR VGND sg13cmos5l_decap_8
X_06159_ _06159_/Y _06673_/A VPWR VGND sg13cmos5l_inv_1
X_11657__1307 _11657_/RESET_B VPWR VGND sg13cmos5l_tiehi
XFILLER_104_277 VPWR VGND sg13cmos5l_fill_1
XFILLER_104_266 VPWR VGND sg13cmos5l_decap_8
Xfanout631 _06523_/A _10696_/A VPWR VGND sg13cmos5l_buf_1
XFILLER_77_106 VPWR VGND sg13cmos5l_fill_1
X_09918_ _09920_/B _09919_/B _09919_/C _09919_/A VPWR VGND sg13cmos5l_o21ai_1
Xfanout620 _07093_/B _05995_/Y VPWR VGND sg13cmos5l_buf_1
Xfanout642 _06574_/B2 _06564_/B2 VPWR VGND sg13cmos5l_buf_1
Xfanout675 _10713_/A fanout682/X VPWR VGND sg13cmos5l_buf_1
Xfanout664 _10353_/A _11755_/Q VPWR VGND sg13cmos5l_buf_1
Xfanout653 _06085_/A fanout661/X VPWR VGND sg13cmos5l_buf_1
XFILLER_101_995 VPWR VGND sg13cmos5l_decap_8
XFILLER_86_673 VPWR VGND sg13cmos5l_fill_1
Xfanout686 _07007_/A _07072_/B VPWR VGND sg13cmos5l_buf_1
XFILLER_58_353 VPWR VGND sg13cmos5l_decap_8
Xfanout697 _06820_/C _11696_/Q VPWR VGND sg13cmos5l_buf_1
X_11759__920 _11759_/RESET_B VPWR VGND sg13cmos5l_tiehi
X_09849_ _09849_/Y _05980_/Y _09841_/B _09848_/Y VPWR VGND sg13cmos5l_a21oi_1
XFILLER_58_386 VPWR VGND sg13cmos5l_decap_8
XFILLER_57_1001 VPWR VGND sg13cmos5l_fill_1
XFILLER_73_389 VPWR VGND sg13cmos5l_decap_8
XFILLER_15_924 VPWR VGND sg13cmos5l_fill_1
XFILLER_27_784 VPWR VGND sg13cmos5l_decap_8
XFILLER_27_795 VPWR VGND sg13cmos5l_fill_1
X_11742_ _11742_/Q clkload23/A _11742_/D _11742_/RESET_B VPWR VGND sg13cmos5l_dfrbpq_1
XFILLER_54_592 VPWR VGND sg13cmos5l_fill_1
XFILLER_42_765 VPWR VGND sg13cmos5l_fill_1
X_11673_ _11673_/Q clkload13/A _11673_/D _11673_/RESET_B VPWR VGND sg13cmos5l_dfrbpq_1
XFILLER_30_927 VPWR VGND sg13cmos5l_fill_1
X_10624_ _10624_/Y hold2843/X _10656_/B _10623_/Y _05935_/A _10662_/A VPWR VGND sg13cmos5l_a221oi_1
X_10824__961 _10824_/RESET_B VPWR VGND sg13cmos5l_tiehi
X_10555_ _10555_/Y _10566_/A _10553_/Y _10554_/Y VPWR VGND sg13cmos5l_o21ai_1
X_10486_ _10488_/B _10682_/A _10486_/B _10486_/C VPWR VGND sg13cmos5l_nand3_1
XFILLER_5_143 VPWR VGND sg13cmos5l_fill_1
XFILLER_64_1005 VPWR VGND sg13cmos5l_fill_1
X_11107_ _11107_/Q clkload46/A _11107_/D _11107_/RESET_B VPWR VGND sg13cmos5l_dfrbpq_1
XFILLER_49_342 VPWR VGND sg13cmos5l_fill_1
X_11038_ _11038_/Q clkload58/A _11038_/D _11038_/RESET_B VPWR VGND sg13cmos5l_dfrbpq_1
XFILLER_77_662 VPWR VGND sg13cmos5l_fill_2
XFILLER_49_375 VPWR VGND sg13cmos5l_decap_8
XFILLER_49_386 VPWR VGND sg13cmos5l_fill_2
XFILLER_92_654 VPWR VGND sg13cmos5l_fill_2
XFILLER_65_879 VPWR VGND sg13cmos5l_decap_8
XFILLER_18_762 VPWR VGND sg13cmos5l_fill_1
XFILLER_18_784 VPWR VGND sg13cmos5l_decap_4
XFILLER_33_710 VPWR VGND sg13cmos5l_decap_8
X_08180_ _11177_/D fanout49/X _08179_/B _08179_/Y VPWR VGND sg13cmos5l_a21oi_1
X_07200_ _07200_/Y _07200_/A _07200_/B VPWR VGND sg13cmos5l_nand2_1
X_07131_ _07131_/Y hold2855/X _07132_/A2 _07145_/B1 VPWR VGND sg13cmos5l_o21ai_1
XFILLER_64_0 VPWR VGND sg13cmos5l_fill_1
X_07062_ _07062_/X _07061_/Y hold2587/X _07062_/S VPWR VGND sg13cmos5l_mux2_1
X_06013_ _06017_/A _07007_/A _06013_/B VPWR VGND sg13cmos5l_nand2_1
XFILLER_101_203 VPWR VGND sg13cmos5l_decap_8
XFILLER_88_938 VPWR VGND sg13cmos5l_fill_2
X_07964_ _07964_/Y _07964_/A _07974_/B VPWR VGND sg13cmos5l_nand2_1
X_07895_ _07895_/Y _07895_/A _07911_/B VPWR VGND sg13cmos5l_nor2_1
X_06915_ _06931_/B _11686_/D _10772_/A VPWR VGND sg13cmos5l_nand2b_1
XFILLER_67_150 VPWR VGND sg13cmos5l_decap_4
X_09703_ _09704_/B _09239_/C _09703_/B VPWR VGND sg13cmos5l_nand2b_1
X_06846_ _06846_/Y _06814_/Y _06845_/Y _06843_/Y VPWR VGND sg13cmos5l_o21ai_1
X_09634_ _09634_/X _11257_/Q _11225_/Q _11193_/Q _11161_/Q _09659_/S0 _09848_/B1 VPWR
+ VGND sg13cmos5l_mux4_1
XFILLER_82_142 VPWR VGND sg13cmos5l_fill_2
X_06777_ _06778_/B _06407_/B _06401_/D _06776_/Y VPWR VGND sg13cmos5l_a21oi_1
XFILLER_64_890 VPWR VGND sg13cmos5l_decap_8
X_11402__1486 _11402_/RESET_B VPWR VGND sg13cmos5l_tiehi
XFILLER_15_209 VPWR VGND sg13cmos5l_decap_8
X_09565_ _09565_/X _09565_/A _09565_/B VPWR VGND sg13cmos5l_and2_1
X_09496_ _09496_/X _11124_/Q _11092_/Q _11060_/Q _11028_/Q _09491_/S _09573_/A1 VPWR
+ VGND sg13cmos5l_mux4_1
X_08516_ _11342_/D _08516_/A1 _08533_/B _08515_/Y VPWR VGND sg13cmos5l_a21oi_1
XFILLER_23_220 VPWR VGND sg13cmos5l_fill_2
X_08447_ _11308_/D _08512_/A1 _08464_/B _08446_/Y VPWR VGND sg13cmos5l_o21ai_1
XFILLER_23_264 VPWR VGND sg13cmos5l_fill_2
X_10808__945 _10808_/RESET_B VPWR VGND sg13cmos5l_tiehi
XFILLER_51_595 VPWR VGND sg13cmos5l_fill_2
X_08378_ _11274_/D _08508_/A1 _08429_/B _08377_/Y VPWR VGND sg13cmos5l_a21oi_1
X_11105__1796 _11105_/RESET_B VPWR VGND sg13cmos5l_tiehi
X_07329_ _07329_/Y _07329_/A _07359_/B VPWR VGND sg13cmos5l_nor2_1
X_10340_ _10340_/Y hold2836/X _10166_/B _10323_/Y VPWR VGND sg13cmos5l_o21ai_1
X_10271_ _10273_/B _10297_/A _10269_/Y _10267_/Y VPWR VGND sg13cmos5l_o21ai_1
X_11284__1617 _11284_/RESET_B VPWR VGND sg13cmos5l_tiehi
X_11320__1581 _11320_/RESET_B VPWR VGND sg13cmos5l_tiehi
XFILLER_105_586 VPWR VGND sg13cmos5l_decap_8
Xfanout450 _10041_/B fanout451/X VPWR VGND sg13cmos5l_buf_1
XFILLER_24_1000 VPWR VGND sg13cmos5l_fill_2
XFILLER_93_418 VPWR VGND sg13cmos5l_fill_1
Xfanout472 _10021_/A2 fanout481/X VPWR VGND sg13cmos5l_buf_1
XFILLER_47_802 VPWR VGND sg13cmos5l_decap_8
Xfanout461 _09552_/B _09417_/B VPWR VGND sg13cmos5l_buf_1
Xfanout483 _06744_/A1 _06759_/A1 VPWR VGND sg13cmos5l_buf_1
XFILLER_74_610 VPWR VGND sg13cmos5l_decap_8
XFILLER_47_857 VPWR VGND sg13cmos5l_decap_8
Xfanout494 _09456_/B _09536_/B VPWR VGND sg13cmos5l_buf_1
XFILLER_104_70 VPWR VGND sg13cmos5l_decap_8
XFILLER_47_868 VPWR VGND sg13cmos5l_fill_1
XFILLER_46_345 VPWR VGND sg13cmos5l_fill_2
XFILLER_19_559 VPWR VGND sg13cmos5l_decap_8
XFILLER_61_326 VPWR VGND sg13cmos5l_decap_8
XFILLER_55_890 VPWR VGND sg13cmos5l_decap_4
XFILLER_46_378 VPWR VGND sg13cmos5l_fill_2
X_11725_ _11725_/Q clkload23/A _11725_/D _11725_/RESET_B VPWR VGND sg13cmos5l_dfrbpq_1
XFILLER_14_297 VPWR VGND sg13cmos5l_fill_2
XFILLER_80_84 VPWR VGND sg13cmos5l_fill_2
XFILLER_80_73 VPWR VGND sg13cmos5l_fill_1
XFILLER_31_1004 VPWR VGND sg13cmos5l_decap_4
Xfanout90 _09751_/A _09807_/A VPWR VGND sg13cmos5l_buf_1
X_11656_ _11656_/Q clkload12/A _11656_/D _11656_/RESET_B VPWR VGND sg13cmos5l_dfrbpq_1
X_11587_ _11587_/Q clkload24/A _11587_/D _11587_/RESET_B VPWR VGND sg13cmos5l_dfrbpq_1
X_10607_ _10608_/B _10577_/Y _10633_/B _10606_/Y VPWR VGND sg13cmos5l_a21oi_1
XFILLER_7_953 VPWR VGND sg13cmos5l_fill_1
X_10538_ _10539_/B _10538_/A _10538_/B VPWR VGND sg13cmos5l_xnor2_1
XFILLER_7_986 VPWR VGND sg13cmos5l_decap_8
XFILLER_97_702 VPWR VGND sg13cmos5l_fill_2
X_10469_ _10469_/Y _11560_/Q _10725_/A _10469_/C VPWR VGND sg13cmos5l_nor3_1
XFILLER_9_1005 VPWR VGND sg13cmos5l_decap_8
XFILLER_97_768 VPWR VGND sg13cmos5l_fill_1
XFILLER_77_481 VPWR VGND sg13cmos5l_fill_2
X_06700_ _06700_/Y _06709_/B _06709_/C VPWR VGND sg13cmos5l_nor2_1
XFILLER_53_805 VPWR VGND sg13cmos5l_decap_8
X_07680_ _07680_/Y _07680_/A _07702_/B VPWR VGND sg13cmos5l_nor2_1
XFILLER_25_507 VPWR VGND sg13cmos5l_decap_8
XFILLER_53_838 VPWR VGND sg13cmos5l_decap_8
XFILLER_53_827 VPWR VGND sg13cmos5l_fill_2
X_06631_ _06632_/B _06645_/B _06352_/Y _06631_/S VPWR VGND sg13cmos5l_mux2_1
XFILLER_80_668 VPWR VGND sg13cmos5l_fill_1
XFILLER_64_197 VPWR VGND sg13cmos5l_fill_1
XFILLER_52_359 VPWR VGND sg13cmos5l_decap_4
X_06562_ _06563_/B _06562_/A1 _11675_/Q _10869_/Q _06564_/B2 VPWR VGND sg13cmos5l_a22oi_1
X_09350_ _09350_/Y _09433_/A _09347_/Y _09349_/Y VPWR VGND sg13cmos5l_o21ai_1
XFILLER_100_28 VPWR VGND sg13cmos5l_decap_8
X_11362__1539 _11362_/RESET_B VPWR VGND sg13cmos5l_tiehi
X_09281_ _09283_/C _09281_/A _09281_/B _09281_/C VPWR VGND sg13cmos5l_nor3_1
X_08301_ _08301_/Y _08301_/A _08301_/B VPWR VGND sg13cmos5l_nor2_1
X_08232_ _08232_/Y _08232_/A _08242_/B VPWR VGND sg13cmos5l_nand2_1
XFILLER_60_370 VPWR VGND sg13cmos5l_fill_1
X_06493_ _06493_/Y _10893_/Q _09544_/S _09553_/B1 VPWR VGND sg13cmos5l_a21oi_1
XFILLER_20_245 VPWR VGND sg13cmos5l_fill_1
X_11077__848 _11077_/RESET_B VPWR VGND sg13cmos5l_tiehi
X_08163_ _08163_/Y _08163_/A _08163_/B VPWR VGND sg13cmos5l_nor2_1
X_08094_ _08094_/Y _08094_/A _08106_/B VPWR VGND sg13cmos5l_nand2_1
X_07114_ _11722_/D _05884_/Y _07126_/A2 _07113_/Y VPWR VGND sg13cmos5l_a21oi_1
X_07045_ _07045_/X hold2523/X _08626_/A1 _07044_/Y VPWR VGND sg13cmos5l_a21o_1
XFILLER_0_617 VPWR VGND sg13cmos5l_fill_1
XFILLER_88_757 VPWR VGND sg13cmos5l_fill_2
Xhold2822 _11513_/D _10142_/Y VPWR VGND sg13cmos5l_dlygate4sd3_1
Xhold2811 _06506_/A _11371_/Q VPWR VGND sg13cmos5l_dlygate4sd3_1
Xhold2800 _11521_/D _10190_/Y VPWR VGND sg13cmos5l_dlygate4sd3_1
X_08996_ _08996_/Y _09018_/A _08996_/B VPWR VGND sg13cmos5l_xnor2_1
Xhold2866 _11550_/D _10685_/Y VPWR VGND sg13cmos5l_dlygate4sd3_1
Xhold2844 _11546_/D _10631_/Y VPWR VGND sg13cmos5l_dlygate4sd3_1
Xhold2855 hold2855/X _11731_/Q VPWR VGND sg13cmos5l_dlygate4sd3_1
Xhold2833 _05965_/A _10841_/Q VPWR VGND sg13cmos5l_dlygate4sd3_1
X_07947_ _11063_/D _08339_/A1 _07946_/B _07946_/Y VPWR VGND sg13cmos5l_o21ai_1
Xhold2899 hold2899/X _11480_/Q VPWR VGND sg13cmos5l_dlygate4sd3_1
XFILLER_56_632 VPWR VGND sg13cmos5l_decap_8
Xhold2877 hold2877/X _11388_/Q VPWR VGND sg13cmos5l_dlygate4sd3_1
Xhold2888 _06100_/A _10877_/Q VPWR VGND sg13cmos5l_dlygate4sd3_1
XFILLER_56_643 VPWR VGND sg13cmos5l_fill_2
XFILLER_44_816 VPWR VGND sg13cmos5l_fill_1
X_07878_ _11029_/D _08073_/A1 _07877_/B _07877_/Y VPWR VGND sg13cmos5l_a21oi_1
X_06829_ _06829_/Y _06782_/B _06835_/B _06828_/Y VPWR VGND sg13cmos5l_o21ai_1
XFILLER_28_389 VPWR VGND sg13cmos5l_fill_2
X_09617_ _09618_/B _09745_/A _09610_/X _09944_/A VPWR VGND sg13cmos5l_o21ai_1
XFILLER_70_145 VPWR VGND sg13cmos5l_decap_8
X_09548_ _09548_/Y _09707_/S1 _09544_/X _09547_/Y VPWR VGND sg13cmos5l_o21ai_1
XFILLER_24_562 VPWR VGND sg13cmos5l_decap_8
X_11338__1563 _11338_/RESET_B VPWR VGND sg13cmos5l_tiehi
XFILLER_52_893 VPWR VGND sg13cmos5l_fill_1
XFILLER_12_735 VPWR VGND sg13cmos5l_decap_8
X_09479_ _09479_/Y _09537_/A _09558_/B VPWR VGND sg13cmos5l_nor2_1
XFILLER_34_77 VPWR VGND sg13cmos5l_decap_8
X_11510_ _11510_/Q clkload37/A _11510_/D _11510_/RESET_B VPWR VGND sg13cmos5l_dfrbpq_1
XFILLER_8_728 VPWR VGND sg13cmos5l_fill_2
XFILLER_12_779 VPWR VGND sg13cmos5l_fill_2
X_11441_ _11441_/Q clkload43/A _11441_/D _11441_/RESET_B VPWR VGND sg13cmos5l_dfrbpq_1
XFILLER_11_278 VPWR VGND sg13cmos5l_fill_2
X_11372_ _11372_/Q clkload28/A _11372_/D _11372_/RESET_B VPWR VGND sg13cmos5l_dfrbpq_1
XFILLER_7_249 VPWR VGND sg13cmos5l_decap_4
X_10323_ _10323_/Y _11560_/Q _10323_/B VPWR VGND sg13cmos5l_nand2_1
XFILLER_106_840 VPWR VGND sg13cmos5l_decap_8
XFILLER_3_433 VPWR VGND sg13cmos5l_decap_4
X_10254_ _10254_/X _10254_/A _10254_/B VPWR VGND sg13cmos5l_and2_1
X_10185_ _10187_/B _11394_/Q _10831_/Q VPWR VGND sg13cmos5l_xor2_1
XFILLER_79_779 VPWR VGND sg13cmos5l_fill_2
Xfanout280 _08358_/B _08340_/B VPWR VGND sg13cmos5l_buf_1
Xfanout291 _08088_/B _08096_/B VPWR VGND sg13cmos5l_buf_1
XFILLER_90_900 VPWR VGND sg13cmos5l_fill_2
XFILLER_75_996 VPWR VGND sg13cmos5l_decap_4
XFILLER_46_175 VPWR VGND sg13cmos5l_decap_8
XFILLER_90_977 VPWR VGND sg13cmos5l_fill_1
XFILLER_46_197 VPWR VGND sg13cmos5l_fill_1
XFILLER_43_871 VPWR VGND sg13cmos5l_fill_1
XFILLER_61_189 VPWR VGND sg13cmos5l_decap_4
X_11708_ _11708_/Q clkload31/A _11708_/D _11708_/RESET_B VPWR VGND sg13cmos5l_dfrbpq_1
XFILLER_30_554 VPWR VGND sg13cmos5l_fill_2
X_11639_ _11639_/Q clkload27/A _11639_/D _11639_/RESET_B VPWR VGND sg13cmos5l_dfrbpq_1
X_11652__1312 _11652_/RESET_B VPWR VGND sg13cmos5l_tiehi
XFILLER_30_587 VPWR VGND sg13cmos5l_fill_2
XFILLER_6_271 VPWR VGND sg13cmos5l_decap_8
Xhold2118 _08029_/A _11104_/Q VPWR VGND sg13cmos5l_dlygate4sd3_1
Xhold2107 _07658_/A _10923_/Q VPWR VGND sg13cmos5l_dlygate4sd3_1
X_11685__1279 _11685_/RESET_B VPWR VGND sg13cmos5l_tiehi
XFILLER_69_223 VPWR VGND sg13cmos5l_fill_1
X_08850_ _08851_/B _08861_/B _08839_/B _08835_/Y VPWR VGND sg13cmos5l_o21ai_1
Xhold2129 _08033_/A _11106_/Q VPWR VGND sg13cmos5l_dlygate4sd3_1
XFILLER_57_407 VPWR VGND sg13cmos5l_fill_1
X_07801_ _10992_/D _08063_/A1 _07808_/B _07800_/Y VPWR VGND sg13cmos5l_o21ai_1
XFILLER_29_109 VPWR VGND sg13cmos5l_fill_2
XFILLER_66_941 VPWR VGND sg13cmos5l_fill_1
XFILLER_66_930 VPWR VGND sg13cmos5l_decap_8
X_08781_ _08781_/Y _11635_/Q _08817_/A VPWR VGND sg13cmos5l_nand2_1
X_05993_ _05996_/A _11554_/Q _11553_/Q _08621_/B VPWR VGND sg13cmos5l_nor3_1
XFILLER_38_621 VPWR VGND sg13cmos5l_fill_1
XFILLER_38_610 VPWR VGND sg13cmos5l_fill_2
XFILLER_84_248 VPWR VGND sg13cmos5l_fill_1
XFILLER_66_963 VPWR VGND sg13cmos5l_decap_8
X_07732_ _07732_/Y _07732_/A _07750_/B VPWR VGND sg13cmos5l_nor2_1
XFILLER_66_985 VPWR VGND sg13cmos5l_decap_4
XFILLER_37_153 VPWR VGND sg13cmos5l_decap_4
X_07663_ _10925_/D _08384_/A1 _07682_/B _07662_/Y VPWR VGND sg13cmos5l_a21oi_1
XFILLER_81_955 VPWR VGND sg13cmos5l_decap_8
XFILLER_80_432 VPWR VGND sg13cmos5l_fill_2
XFILLER_25_348 VPWR VGND sg13cmos5l_fill_1
X_09402_ _09403_/C _09402_/A _09536_/B VPWR VGND sg13cmos5l_nand2_1
X_06614_ _06614_/Y _06614_/A _06614_/B VPWR VGND sg13cmos5l_nor2_1
X_07594_ _10912_/D _07607_/B fanout73/X _07588_/Y VPWR VGND sg13cmos5l_a21oi_1
XFILLER_81_988 VPWR VGND sg13cmos5l_decap_8
XFILLER_52_145 VPWR VGND sg13cmos5l_decap_8
X_09333_ _09333_/Y _09333_/A _09460_/A VPWR VGND sg13cmos5l_nand2_1
XFILLER_25_359 VPWR VGND sg13cmos5l_decap_4
X_11605__1378 _11605_/RESET_B VPWR VGND sg13cmos5l_tiehi
XFILLER_80_498 VPWR VGND sg13cmos5l_decap_4
XFILLER_40_318 VPWR VGND sg13cmos5l_decap_8
X_06545_ _06545_/Y _06545_/A _06545_/B VPWR VGND sg13cmos5l_nand2_1
XFILLER_33_381 VPWR VGND sg13cmos5l_decap_4
X_06476_ _06476_/Y _06476_/A _06476_/B VPWR VGND sg13cmos5l_nor2_1
X_09264_ _09976_/B _09264_/A _10857_/Q VPWR VGND sg13cmos5l_xor2_1
XFILLER_21_543 VPWR VGND sg13cmos5l_decap_4
X_08215_ _11194_/D fanout96/X _08228_/B _08214_/Y VPWR VGND sg13cmos5l_o21ai_1
X_09195_ _09195_/Y _09177_/Y _09194_/Y _09176_/Y VPWR VGND sg13cmos5l_o21ai_1
XFILLER_101_1002 VPWR VGND sg13cmos5l_decap_8
X_08146_ _11160_/D _08471_/A1 _08145_/B _08145_/Y VPWR VGND sg13cmos5l_a21oi_1
XFILLER_106_147 VPWR VGND sg13cmos5l_decap_8
XFILLER_105_7 VPWR VGND sg13cmos5l_decap_8
XFILLER_84_1019 VPWR VGND sg13cmos5l_fill_1
X_08077_ _11127_/D _08339_/A1 _08076_/B _08076_/Y VPWR VGND sg13cmos5l_o21ai_1
XFILLER_1_904 VPWR VGND sg13cmos5l_decap_8
X_07028_ _07028_/X _11492_/Q _10469_/C VPWR VGND sg13cmos5l_and2_1
XFILLER_96_28 VPWR VGND sg13cmos5l_decap_8
XFILLER_102_342 VPWR VGND sg13cmos5l_decap_4
Xhold2630 _07186_/B _11379_/Q VPWR VGND sg13cmos5l_dlygate4sd3_1
XFILLER_48_407 VPWR VGND sg13cmos5l_fill_1
Xhold2652 _06905_/A _11704_/Q VPWR VGND sg13cmos5l_dlygate4sd3_1
Xhold2674 _11373_/D _08587_/Y VPWR VGND sg13cmos5l_dlygate4sd3_1
Xhold2663 hold2663/X _11700_/Q VPWR VGND sg13cmos5l_dlygate4sd3_1
Xhold2641 _11680_/D _07069_/Y VPWR VGND sg13cmos5l_dlygate4sd3_1
X_08979_ _08979_/Y _08979_/A _09004_/B VPWR VGND sg13cmos5l_nand2_1
XFILLER_29_77 VPWR VGND sg13cmos5l_fill_2
Xhold1940 _08502_/A _11336_/Q VPWR VGND sg13cmos5l_dlygate4sd3_1
Xhold1951 _11605_/D _06816_/Y VPWR VGND sg13cmos5l_dlygate4sd3_1
Xhold2696 _11518_/D _10158_/Y VPWR VGND sg13cmos5l_dlygate4sd3_1
Xhold2685 hold2685/X _11701_/Q VPWR VGND sg13cmos5l_dlygate4sd3_1
Xhold1962 _07794_/A _10989_/Q VPWR VGND sg13cmos5l_dlygate4sd3_1
XFILLER_21_1014 VPWR VGND sg13cmos5l_decap_4
XFILLER_29_654 VPWR VGND sg13cmos5l_decap_8
XFILLER_84_782 VPWR VGND sg13cmos5l_fill_2
X_10941_ _10941_/Q clkload41/A _10941_/D _10941_/RESET_B VPWR VGND sg13cmos5l_dfrbpq_1
Xhold1995 _08208_/A _11191_/Q VPWR VGND sg13cmos5l_dlygate4sd3_1
Xhold1984 _07958_/A _11069_/Q VPWR VGND sg13cmos5l_dlygate4sd3_1
Xhold1973 _08086_/A _11132_/Q VPWR VGND sg13cmos5l_dlygate4sd3_1
XFILLER_16_315 VPWR VGND sg13cmos5l_fill_2
XFILLER_28_142 VPWR VGND sg13cmos5l_decap_8
XFILLER_29_687 VPWR VGND sg13cmos5l_decap_8
XFILLER_83_292 VPWR VGND sg13cmos5l_fill_1
XFILLER_72_966 VPWR VGND sg13cmos5l_decap_4
XFILLER_72_999 VPWR VGND sg13cmos5l_fill_2
XFILLER_45_98 VPWR VGND sg13cmos5l_fill_2
XFILLER_44_679 VPWR VGND sg13cmos5l_decap_4
X_10872_ _10872_/Q clkload12/A _10872_/D _10872_/RESET_B VPWR VGND sg13cmos5l_dfrbpq_1
XFILLER_71_498 VPWR VGND sg13cmos5l_decap_4
XFILLER_71_487 VPWR VGND sg13cmos5l_fill_2
XFILLER_52_690 VPWR VGND sg13cmos5l_decap_8
XFILLER_61_86 VPWR VGND sg13cmos5l_decap_4
X_11424_ _11424_/Q clkload28/A _11424_/D _11424_/RESET_B VPWR VGND sg13cmos5l_dfrbpq_1
XANTENNA_8 _07376_/Y VPWR VGND sg13cmos5l_antennanp
X_11355_ _11355_/Q _11355_/CLK _11355_/D _11355_/RESET_B VPWR VGND sg13cmos5l_dfrbpq_1
XFILLER_4_742 VPWR VGND sg13cmos5l_fill_1
XFILLER_4_731 VPWR VGND sg13cmos5l_decap_8
X_10306_ _10523_/A _10504_/A _10504_/B _10291_/Y VPWR VGND sg13cmos5l_a21o_1
X_11286_ _11286_/Q clkload33/A _11286_/D _11286_/RESET_B VPWR VGND sg13cmos5l_dfrbpq_1
X_10237_ _10237_/Y _10173_/B _10236_/Y _10168_/B VPWR VGND sg13cmos5l_o21ai_1
XFILLER_67_738 VPWR VGND sg13cmos5l_fill_1
XFILLER_66_226 VPWR VGND sg13cmos5l_fill_2
XFILLER_66_204 VPWR VGND sg13cmos5l_fill_1
X_10168_ _10168_/Y _10167_/Y _10168_/B VPWR VGND sg13cmos5l_nand2b_1
XFILLER_39_429 VPWR VGND sg13cmos5l_decap_8
XFILLER_0_992 VPWR VGND sg13cmos5l_decap_8
X_10099_ _10099_/Y _10330_/B _09610_/X _10098_/Y VPWR VGND sg13cmos5l_a21oi_1
X_11067__858 _11067_/RESET_B VPWR VGND sg13cmos5l_tiehi
XFILLER_47_473 VPWR VGND sg13cmos5l_fill_2
XFILLER_63_955 VPWR VGND sg13cmos5l_decap_8
XFILLER_90_774 VPWR VGND sg13cmos5l_decap_4
XFILLER_63_988 VPWR VGND sg13cmos5l_fill_2
XFILLER_62_465 VPWR VGND sg13cmos5l_decap_8
XFILLER_37_1021 VPWR VGND sg13cmos5l_decap_8
X_06330_ _06420_/B _11515_/Q _06330_/B VPWR VGND sg13cmos5l_nand2b_1
X_06261_ _06261_/Y _11512_/Q _09938_/A VPWR VGND sg13cmos5l_nand2_1
X_08000_ _11089_/D _08522_/A1 _08031_/B _07999_/Y VPWR VGND sg13cmos5l_a21oi_1
X_06192_ _06620_/A _06351_/B _06192_/B VPWR VGND sg13cmos5l_nand2_1
X_09951_ _09951_/Y _10981_/Q _09955_/B _09991_/B1 VPWR VGND sg13cmos5l_a21oi_1
X_08902_ _08902_/Y _08916_/B1 _08898_/Y _08901_/Y VPWR VGND sg13cmos5l_a21oi_1
XFILLER_106_49 VPWR VGND sg13cmos5l_decap_8
X_09882_ _09882_/Y _09882_/A _09968_/B VPWR VGND sg13cmos5l_nand2_1
XFILLER_58_738 VPWR VGND sg13cmos5l_decap_8
XFILLER_57_226 VPWR VGND sg13cmos5l_decap_4
X_08833_ _11429_/D hold2642/X _08846_/B _08832_/Y VPWR VGND sg13cmos5l_a21o_1
X_08764_ _08765_/A hold2804/X _08772_/A2 _09127_/B _08772_/B2 VPWR VGND sg13cmos5l_a22oi_1
XFILLER_57_259 VPWR VGND sg13cmos5l_fill_1
X_05976_ _05976_/Y _05976_/A VPWR VGND sg13cmos5l_inv_1
X_07715_ _10951_/D fanout53/X _07714_/B _07714_/Y VPWR VGND sg13cmos5l_a21oi_1
XFILLER_66_771 VPWR VGND sg13cmos5l_decap_4
XFILLER_38_462 VPWR VGND sg13cmos5l_fill_1
XFILLER_26_602 VPWR VGND sg13cmos5l_decap_8
XFILLER_65_281 VPWR VGND sg13cmos5l_fill_1
X_08695_ _08921_/B _08695_/A _08695_/B VPWR VGND sg13cmos5l_nand2_1
XFILLER_26_646 VPWR VGND sg13cmos5l_fill_2
X_07646_ _07646_/Y _07646_/A _07648_/B VPWR VGND sg13cmos5l_nor2_1
XFILLER_13_307 VPWR VGND sg13cmos5l_decap_4
XFILLER_26_668 VPWR VGND sg13cmos5l_decap_8
X_07577_ _07577_/Y _07577_/A _07577_/B VPWR VGND sg13cmos5l_nor2_1
XFILLER_41_649 VPWR VGND sg13cmos5l_decap_8
XFILLER_25_178 VPWR VGND sg13cmos5l_decap_4
X_09316_ _09316_/Y _09316_/A _09316_/B VPWR VGND sg13cmos5l_nand2_1
X_06528_ _06530_/A _06531_/A _11648_/Q VPWR VGND sg13cmos5l_nand2_1
X_09247_ _09948_/B _09968_/A _10604_/B VPWR VGND sg13cmos5l_nand2_1
X_06459_ _06459_/Y _10494_/B1 _11632_/Q _06458_/X VPWR VGND sg13cmos5l_a21oi_1
XFILLER_21_384 VPWR VGND sg13cmos5l_fill_1
X_09178_ _09178_/X _09354_/A _10833_/Q VPWR VGND sg13cmos5l_and2_1
X_08129_ _08129_/Y _08129_/A _08135_/B VPWR VGND sg13cmos5l_nor2_1
X_11140_ _11140_/Q _11364_/CLK _11140_/D _11140_/RESET_B VPWR VGND sg13cmos5l_dfrbpq_1
Xoutput23 uio_out[12] _12768_/X VPWR VGND sg13cmos5l_buf_1
Xoutput34 uo_out[10] _06560_/Y VPWR VGND sg13cmos5l_buf_1
X_11142__1759 _11142_/RESET_B VPWR VGND sg13cmos5l_tiehi
Xoutput45 uo_out[6] _06548_/Y VPWR VGND sg13cmos5l_buf_1
X_11071_ _11071_/Q clkload57/A _11071_/D _11071_/RESET_B VPWR VGND sg13cmos5l_dfrbpq_1
XFILLER_88_351 VPWR VGND sg13cmos5l_decap_4
XFILLER_102_161 VPWR VGND sg13cmos5l_decap_8
X_10022_ _10022_/Y _10019_/Y _10021_/Y _10049_/A1 VPWR VGND sg13cmos5l_o21ai_1
Xhold2471 _11617_/D _06854_/Y VPWR VGND sg13cmos5l_dlygate4sd3_1
XFILLER_76_557 VPWR VGND sg13cmos5l_decap_4
XFILLER_64_708 VPWR VGND sg13cmos5l_fill_1
Xhold2460 _08255_/A _11214_/Q VPWR VGND sg13cmos5l_dlygate4sd3_1
XFILLER_0_299 VPWR VGND sg13cmos5l_fill_1
Xhold2482 _11493_/D _10076_/Y VPWR VGND sg13cmos5l_dlygate4sd3_1
XFILLER_63_207 VPWR VGND sg13cmos5l_fill_1
XFILLER_45_900 VPWR VGND sg13cmos5l_fill_1
Xhold2493 _11674_/D _07048_/X VPWR VGND sg13cmos5l_dlygate4sd3_1
XFILLER_72_752 VPWR VGND sg13cmos5l_fill_1
XFILLER_44_465 VPWR VGND sg13cmos5l_fill_2
XFILLER_16_134 VPWR VGND sg13cmos5l_fill_2
X_10924_ _10924_/Q _11352_/CLK _10924_/D _10924_/RESET_B VPWR VGND sg13cmos5l_dfrbpq_1
X_10855_ _10855_/Q _11715_/CLK _10855_/D _10855_/RESET_B VPWR VGND sg13cmos5l_dfrbpq_1
XFILLER_60_936 VPWR VGND sg13cmos5l_decap_4
XFILLER_44_498 VPWR VGND sg13cmos5l_fill_2
XFILLER_32_616 VPWR VGND sg13cmos5l_fill_1
XFILLER_32_627 VPWR VGND sg13cmos5l_fill_1
XFILLER_31_148 VPWR VGND sg13cmos5l_fill_1
X_10786_ _10786_/Y _06832_/A _10783_/Y _10785_/Y VPWR VGND sg13cmos5l_o21ai_1
XFILLER_8_311 VPWR VGND sg13cmos5l_fill_2
XFILLER_13_896 VPWR VGND sg13cmos5l_fill_1
XFILLER_75_8 VPWR VGND sg13cmos5l_fill_2
X_11387__1511 _11387_/RESET_B VPWR VGND sg13cmos5l_tiehi
X_11407_ _11407_/Q _11535_/CLK _11407_/D _11407_/RESET_B VPWR VGND sg13cmos5l_dfrbpq_1
X_11338_ _11338_/Q clkload32/A _11338_/D _11338_/RESET_B VPWR VGND sg13cmos5l_dfrbpq_1
XFILLER_99_638 VPWR VGND sg13cmos5l_decap_4
XFILLER_98_126 VPWR VGND sg13cmos5l_decap_8
X_11118__1783 _11118_/RESET_B VPWR VGND sg13cmos5l_tiehi
X_11269_ _11269_/Q clkload54/A _11269_/D _11269_/RESET_B VPWR VGND sg13cmos5l_dfrbpq_1
XFILLER_39_215 VPWR VGND sg13cmos5l_fill_2
XFILLER_95_844 VPWR VGND sg13cmos5l_decap_4
XFILLER_94_343 VPWR VGND sg13cmos5l_fill_2
XFILLER_39_248 VPWR VGND sg13cmos5l_decap_8
XFILLER_94_365 VPWR VGND sg13cmos5l_fill_1
XFILLER_94_354 VPWR VGND sg13cmos5l_fill_2
XFILLER_36_922 VPWR VGND sg13cmos5l_decap_8
X_11297__1604 _11297_/RESET_B VPWR VGND sg13cmos5l_tiehi
XFILLER_94_398 VPWR VGND sg13cmos5l_decap_8
X_07500_ _07521_/D _11401_/Q _11400_/Q _10229_/A _07500_/D VPWR VGND sg13cmos5l_nand4_1
X_08480_ _08480_/Y _08480_/A _08488_/B VPWR VGND sg13cmos5l_nand2_1
XFILLER_51_947 VPWR VGND sg13cmos5l_fill_1
XFILLER_35_487 VPWR VGND sg13cmos5l_fill_2
XFILLER_22_104 VPWR VGND sg13cmos5l_fill_2
XFILLER_23_627 VPWR VGND sg13cmos5l_fill_1
X_07431_ _07431_/Y _07431_/A _07431_/B VPWR VGND sg13cmos5l_nor2_1
XFILLER_94_0 VPWR VGND sg13cmos5l_decap_8
X_07362_ _08727_/A _11443_/Q _07362_/B VPWR VGND sg13cmos5l_nand2_1
X_09101_ _09104_/B _09102_/A _09118_/C _09102_/B VPWR VGND sg13cmos5l_a21oi_1
X_06313_ _06727_/A _06313_/A VPWR VGND sg13cmos5l_inv_1
X_07293_ _07293_/Y _07293_/A _07407_/B VPWR VGND sg13cmos5l_nor2_1
X_06244_ _06244_/Y _11517_/Q _09268_/A VPWR VGND sg13cmos5l_nor2_1
X_09032_ _09032_/Y _09032_/A _09055_/B VPWR VGND sg13cmos5l_nand2_1
X_06175_ _06177_/B _06175_/A _09198_/A VPWR VGND sg13cmos5l_or2_1
XFILLER_2_509 VPWR VGND sg13cmos5l_decap_8
X_09934_ _09934_/Y _11364_/Q _09934_/B VPWR VGND sg13cmos5l_nand2_1
Xfanout813 _05939_/A _09154_/A1 VPWR VGND sg13cmos5l_buf_1
Xfanout824 _07155_/B1 _10687_/A VPWR VGND sg13cmos5l_buf_1
Xfanout802 _09043_/A _09056_/A VPWR VGND sg13cmos5l_buf_1
XFILLER_100_610 VPWR VGND sg13cmos5l_fill_1
Xfanout835 _10503_/A input1/X VPWR VGND sg13cmos5l_buf_1
X_09865_ _09865_/Y _11010_/Q _09986_/B VPWR VGND sg13cmos5l_nand2_1
XFILLER_100_632 VPWR VGND sg13cmos5l_decap_8
X_08816_ _08816_/Y _08816_/A _08816_/B VPWR VGND sg13cmos5l_xnor2_1
X_09796_ _09796_/X _11263_/Q _11231_/Q _11199_/Q _11167_/Q _10007_/B _10021_/B1 VPWR
+ VGND sg13cmos5l_mux4_1
X_10907__1075 _10907_/RESET_B VPWR VGND sg13cmos5l_tiehi
X_08747_ _09066_/A _09077_/B VPWR VGND sg13cmos5l_inv_1
X_05959_ _05959_/Y _10930_/Q VPWR VGND sg13cmos5l_inv_1
XFILLER_42_903 VPWR VGND sg13cmos5l_decap_8
X_08678_ _11400_/D _08678_/A VPWR VGND sg13cmos5l_inv_1
XFILLER_26_443 VPWR VGND sg13cmos5l_fill_2
XFILLER_26_454 VPWR VGND sg13cmos5l_decap_8
X_07629_ _07629_/Y _07629_/A _07629_/B VPWR VGND sg13cmos5l_nor2_1
XFILLER_14_616 VPWR VGND sg13cmos5l_decap_8
X_10640_ _10640_/Y _10640_/A _10640_/B VPWR VGND sg13cmos5l_nor2_1
X_10571_ _10573_/B _11415_/Q _10852_/Q _10550_/X VPWR VGND sg13cmos5l_o21ai_1
X_11680__1284 _11680_/RESET_B VPWR VGND sg13cmos5l_tiehi
X_11375__1526 _11375_/RESET_B VPWR VGND sg13cmos5l_tiehi
X_11057__868 _11057_/RESET_B VPWR VGND sg13cmos5l_tiehi
X_11123_ _11123_/Q clkload9/A _11123_/D _11123_/RESET_B VPWR VGND sg13cmos5l_dfrbpq_1
XFILLER_104_971 VPWR VGND sg13cmos5l_decap_8
XFILLER_77_822 VPWR VGND sg13cmos5l_decap_4
X_11054_ _11054_/Q clkload16/A _11054_/D _11054_/RESET_B VPWR VGND sg13cmos5l_dfrbpq_1
X_10005_ _10006_/C _10005_/A _10005_/B _10005_/C VPWR VGND sg13cmos5l_nand3_1
XFILLER_67_52 VPWR VGND sg13cmos5l_decap_4
Xhold2290 _08421_/A _11296_/Q VPWR VGND sg13cmos5l_dlygate4sd3_1
X_11600__1383 _11600_/RESET_B VPWR VGND sg13cmos5l_tiehi
XFILLER_77_899 VPWR VGND sg13cmos5l_fill_2
X_11495__1193 _11495_/RESET_B VPWR VGND sg13cmos5l_tiehi
XFILLER_18_966 VPWR VGND sg13cmos5l_fill_2
X_11615__1361 _11615_/RESET_B VPWR VGND sg13cmos5l_tiehi
XFILLER_83_84 VPWR VGND sg13cmos5l_decap_8
X_10907_ _10907_/Q _11355_/CLK _10907_/D _10907_/RESET_B VPWR VGND sg13cmos5l_dfrbpq_1
XFILLER_60_711 VPWR VGND sg13cmos5l_decap_8
XFILLER_45_796 VPWR VGND sg13cmos5l_decap_8
XFILLER_18_999 VPWR VGND sg13cmos5l_fill_2
XFILLER_33_925 VPWR VGND sg13cmos5l_fill_1
XFILLER_33_958 VPWR VGND sg13cmos5l_decap_8
XFILLER_33_969 VPWR VGND sg13cmos5l_decap_8
X_10838_ _10838_/Q _11713_/CLK _10838_/D _10838_/RESET_B VPWR VGND sg13cmos5l_dfrbpq_1
X_10769_ _10769_/X hold2479/X _10770_/S _07205_/Y VPWR VGND sg13cmos5l_a21o_1
XFILLER_5_881 VPWR VGND sg13cmos5l_fill_2
X_07980_ _07980_/Y _07980_/A _07982_/B VPWR VGND sg13cmos5l_nand2_1
XFILLER_87_619 VPWR VGND sg13cmos5l_decap_4
Xfanout109 _10443_/B1 _10321_/Y VPWR VGND sg13cmos5l_buf_1
XFILLER_4_391 VPWR VGND sg13cmos5l_fill_1
X_06931_ _06931_/Y _10776_/B _06931_/B _11690_/D _06935_/C VPWR VGND sg13cmos5l_nor4_1
XFILLER_95_641 VPWR VGND sg13cmos5l_decap_8
XFILLER_79_181 VPWR VGND sg13cmos5l_fill_2
XFILLER_68_866 VPWR VGND sg13cmos5l_decap_8
X_09650_ _09651_/B _09649_/A _09649_/B _09755_/A VPWR VGND sg13cmos5l_a21oi_1
X_08601_ _08601_/Y _11307_/Q _10020_/B VPWR VGND sg13cmos5l_nand2b_1
XFILLER_83_825 VPWR VGND sg13cmos5l_decap_8
X_06862_ _11621_/D _06841_/A _06848_/C _06861_/Y VPWR VGND sg13cmos5l_o21ai_1
XFILLER_27_207 VPWR VGND sg13cmos5l_decap_8
XFILLER_103_28 VPWR VGND sg13cmos5l_decap_8
X_06793_ _06804_/B _06820_/B _06820_/C VPWR VGND sg13cmos5l_nor2b_1
X_09581_ _09587_/C _09745_/A _09581_/B VPWR VGND sg13cmos5l_nor2_1
XFILLER_70_519 VPWR VGND sg13cmos5l_decap_8
X_08532_ _11350_/D _08532_/A1 _08533_/B _08531_/Y VPWR VGND sg13cmos5l_a21oi_1
XFILLER_51_700 VPWR VGND sg13cmos5l_decap_8
X_08463_ _11316_/D _08528_/A1 _08462_/B _08462_/Y VPWR VGND sg13cmos5l_o21ai_1
XFILLER_51_744 VPWR VGND sg13cmos5l_fill_1
XFILLER_51_733 VPWR VGND sg13cmos5l_decap_8
XFILLER_50_210 VPWR VGND sg13cmos5l_fill_2
XFILLER_24_958 VPWR VGND sg13cmos5l_decap_4
X_07414_ _10886_/D _07431_/B _07412_/Y _07413_/Y VPWR VGND sg13cmos5l_a21oi_1
X_08394_ _11282_/D _08524_/A1 _08403_/B _08393_/Y VPWR VGND sg13cmos5l_a21oi_1
X_07345_ _07345_/Y _07343_/Y _08713_/A _07376_/A2 VPWR VGND sg13cmos5l_a21oi_1
Xclkbuf_leaf_30_clk clkload49/A clkload5/A VPWR VGND sg13cmos5l_buf_8
X_07276_ _07276_/Y _07365_/B _07274_/Y _07275_/Y VPWR VGND sg13cmos5l_a21oi_1
XFILLER_31_490 VPWR VGND sg13cmos5l_fill_1
X_09015_ _09015_/Y _09015_/A _09055_/B VPWR VGND sg13cmos5l_nand2_1
X_06227_ _06721_/A _10427_/A _06377_/A VPWR VGND sg13cmos5l_and2_1
XFILLER_3_818 VPWR VGND sg13cmos5l_fill_2
XFILLER_105_724 VPWR VGND sg13cmos5l_decap_8
X_06158_ _06673_/A _06363_/A _06674_/A VPWR VGND sg13cmos5l_nor2_1
XFILLER_104_245 VPWR VGND sg13cmos5l_decap_8
X_06089_ _06089_/Y _06089_/A _11555_/D _06089_/C _09281_/A VPWR VGND sg13cmos5l_nor4_1
XFILLER_99_991 VPWR VGND sg13cmos5l_decap_8
Xfanout610 _08772_/B2 _08957_/B1 VPWR VGND sg13cmos5l_buf_1
X_09917_ _09919_/C _09917_/A _09256_/B VPWR VGND sg13cmos5l_nor2b_1
Xfanout621 _07088_/S _07100_/S VPWR VGND sg13cmos5l_buf_1
Xfanout632 _10494_/B1 _10644_/B1 VPWR VGND sg13cmos5l_buf_1
Xfanout665 _10537_/A _11755_/Q VPWR VGND sg13cmos5l_buf_1
Xfanout654 _10162_/A _09298_/A VPWR VGND sg13cmos5l_buf_1
Xfanout676 _10584_/A _10140_/A VPWR VGND sg13cmos5l_buf_1
Xfanout643 _06134_/A _06564_/B2 VPWR VGND sg13cmos5l_buf_1
XFILLER_101_974 VPWR VGND sg13cmos5l_decap_8
Xfanout698 _10691_/B _11643_/Q VPWR VGND sg13cmos5l_buf_1
Xfanout687 _10414_/A2 _07072_/B VPWR VGND sg13cmos5l_buf_1
X_09848_ _09848_/Y _11361_/Q _09840_/S _09848_/B1 VPWR VGND sg13cmos5l_a21oi_1
X_09779_ _09779_/Y _09944_/A _09779_/B _09779_/C VPWR VGND sg13cmos5l_nand3_1
XFILLER_46_549 VPWR VGND sg13cmos5l_decap_8
XFILLER_2_1011 VPWR VGND sg13cmos5l_decap_8
X_11698__1266 _11698_/RESET_B VPWR VGND sg13cmos5l_tiehi
XFILLER_37_99 VPWR VGND sg13cmos5l_decap_4
XFILLER_15_903 VPWR VGND sg13cmos5l_decap_8
XFILLER_27_752 VPWR VGND sg13cmos5l_decap_8
X_11741_ _11741_/Q clkload22/A _11741_/D _11741_/RESET_B VPWR VGND sg13cmos5l_dfrbpq_1
XFILLER_26_262 VPWR VGND sg13cmos5l_decap_8
XFILLER_53_21 VPWR VGND sg13cmos5l_decap_8
XFILLER_41_232 VPWR VGND sg13cmos5l_fill_1
XFILLER_14_424 VPWR VGND sg13cmos5l_decap_8
XFILLER_30_906 VPWR VGND sg13cmos5l_decap_8
XFILLER_41_265 VPWR VGND sg13cmos5l_fill_1
XFILLER_41_243 VPWR VGND sg13cmos5l_fill_2
X_11672_ _11672_/Q clkload12/A _11672_/D _11672_/RESET_B VPWR VGND sg13cmos5l_dfrbpq_1
X_10623_ _10623_/Y _10623_/A _10623_/B VPWR VGND sg13cmos5l_xnor2_1
XFILLER_41_287 VPWR VGND sg13cmos5l_fill_2
Xclkbuf_leaf_21_clk clkload32/A clkload2/A VPWR VGND sg13cmos5l_buf_8
X_10554_ _10554_/Y _10566_/A _10553_/Y _10449_/Y VPWR VGND sg13cmos5l_a21oi_1
XFILLER_6_601 VPWR VGND sg13cmos5l_fill_2
XFILLER_10_630 VPWR VGND sg13cmos5l_fill_1
X_10485_ _10486_/C _10462_/A _10495_/A2 _10483_/Y _10484_/Y VPWR VGND sg13cmos5l_a22oi_1
XFILLER_64_1028 VPWR VGND sg13cmos5l_fill_1
X_11106_ _11106_/Q clkload58/A _11106_/D _11106_/RESET_B VPWR VGND sg13cmos5l_dfrbpq_1
XFILLER_65_825 VPWR VGND sg13cmos5l_fill_1
XFILLER_49_354 VPWR VGND sg13cmos5l_decap_8
XFILLER_37_516 VPWR VGND sg13cmos5l_decap_8
XFILLER_37_505 VPWR VGND sg13cmos5l_fill_1
X_11037_ _11037_/Q clkload42/A _11037_/D _11037_/RESET_B VPWR VGND sg13cmos5l_dfrbpq_1
XFILLER_92_644 VPWR VGND sg13cmos5l_fill_2
XFILLER_73_891 VPWR VGND sg13cmos5l_decap_8
XFILLER_45_582 VPWR VGND sg13cmos5l_decap_8
XFILLER_33_733 VPWR VGND sg13cmos5l_decap_4
XFILLER_60_563 VPWR VGND sg13cmos5l_fill_1
X_11441__1408 _11441_/RESET_B VPWR VGND sg13cmos5l_tiehi
XFILLER_32_254 VPWR VGND sg13cmos5l_fill_2
XFILLER_33_788 VPWR VGND sg13cmos5l_decap_8
XFILLER_60_596 VPWR VGND sg13cmos5l_fill_1
XFILLER_20_449 VPWR VGND sg13cmos5l_decap_8
XFILLER_33_799 VPWR VGND sg13cmos5l_fill_1
X_07130_ _11730_/D _05875_/Y _07130_/A2 _07129_/Y VPWR VGND sg13cmos5l_a21oi_1
Xclkbuf_leaf_12_clk _11766_/CLK clkbuf_4_4_0_clk/X VPWR VGND sg13cmos5l_buf_8
XFILLER_9_461 VPWR VGND sg13cmos5l_decap_8
X_07061_ _07061_/Y _05894_/Y _10469_/C _07002_/Y VPWR VGND sg13cmos5l_o21ai_1
X_06012_ _06022_/B _06012_/A _09283_/A _06012_/C VPWR VGND sg13cmos5l_nand3_1
XFILLER_99_287 VPWR VGND sg13cmos5l_fill_1
X_07963_ _11071_/D fanout75/X _07976_/B _07962_/Y VPWR VGND sg13cmos5l_o21ai_1
XFILLER_68_641 VPWR VGND sg13cmos5l_decap_8
XFILLER_59_129 VPWR VGND sg13cmos5l_fill_1
XFILLER_101_259 VPWR VGND sg13cmos5l_decap_8
X_06914_ _11686_/D hold2689/X hold2560/X _06917_/B VPWR VGND sg13cmos5l_mux2_1
X_09702_ _09703_/B _09649_/A _09649_/B _09239_/D VPWR VGND sg13cmos5l_o21ai_1
X_07894_ _11037_/D fanout79/X _07893_/B _07893_/Y VPWR VGND sg13cmos5l_a21oi_1
X_06845_ _06845_/Y _11645_/Q _07202_/C _06874_/A VPWR VGND sg13cmos5l_nand3_1
XFILLER_56_825 VPWR VGND sg13cmos5l_decap_8
X_09633_ _09633_/Y _09633_/A _09633_/B _09633_/C VPWR VGND sg13cmos5l_nor3_1
XFILLER_56_869 VPWR VGND sg13cmos5l_fill_1
X_09564_ _09564_/Y _09454_/A _09672_/A _09543_/Y _09563_/Y VPWR VGND sg13cmos5l_a22oi_1
X_11047__878 _11047_/RESET_B VPWR VGND sg13cmos5l_tiehi
X_06776_ _06776_/Y _06257_/Y _06757_/B _06775_/Y VPWR VGND sg13cmos5l_o21ai_1
XFILLER_55_379 VPWR VGND sg13cmos5l_fill_1
X_08515_ _08515_/Y _08515_/A _08533_/B VPWR VGND sg13cmos5l_nor2_1
XFILLER_51_530 VPWR VGND sg13cmos5l_decap_4
X_09495_ _09495_/Y _09495_/A1 _09491_/X _09494_/Y VPWR VGND sg13cmos5l_o21ai_1
XFILLER_12_917 VPWR VGND sg13cmos5l_fill_2
X_08446_ _08446_/Y _08446_/A _08464_/B VPWR VGND sg13cmos5l_nand2_1
X_08377_ _08377_/Y _08377_/A _08429_/B VPWR VGND sg13cmos5l_nor2_1
XFILLER_23_13 VPWR VGND sg13cmos5l_fill_2
X_07328_ _07328_/Y _11470_/Q _07340_/A2 _07327_/Y VPWR VGND sg13cmos5l_a21oi_1
XFILLER_99_39 VPWR VGND sg13cmos5l_decap_8
X_07259_ _07259_/Y _11522_/Q _08671_/S VPWR VGND sg13cmos5l_nand2_1
X_10270_ _10297_/B _10270_/A _10270_/B VPWR VGND sg13cmos5l_xnor2_1
XFILLER_2_136 VPWR VGND sg13cmos5l_fill_2
XFILLER_105_565 VPWR VGND sg13cmos5l_decap_8
XFILLER_2_169 VPWR VGND sg13cmos5l_decap_4
Xfanout440 _09600_/B _09606_/B VPWR VGND sg13cmos5l_buf_1
XFILLER_24_1012 VPWR VGND sg13cmos5l_decap_8
Xfanout451 fanout451/X _06452_/Y VPWR VGND sg13cmos5l_buf_1
Xfanout473 _10034_/B _09894_/B VPWR VGND sg13cmos5l_buf_1
XFILLER_87_972 VPWR VGND sg13cmos5l_fill_1
Xfanout484 _06759_/A1 _06668_/A1 VPWR VGND sg13cmos5l_buf_1
Xfanout462 _09708_/S _09417_/B VPWR VGND sg13cmos5l_buf_1
XFILLER_86_482 VPWR VGND sg13cmos5l_decap_4
XFILLER_47_847 VPWR VGND sg13cmos5l_fill_2
Xfanout495 _09536_/B _09319_/C VPWR VGND sg13cmos5l_buf_1
XFILLER_62_817 VPWR VGND sg13cmos5l_fill_2
XFILLER_0_28 VPWR VGND sg13cmos5l_decap_8
XFILLER_64_64 VPWR VGND sg13cmos5l_decap_8
XFILLER_64_75 VPWR VGND sg13cmos5l_fill_2
XFILLER_15_744 VPWR VGND sg13cmos5l_decap_8
X_11724_ _11724_/Q clkload22/A _11724_/D _11724_/RESET_B VPWR VGND sg13cmos5l_dfrbpq_1
XFILLER_9_15 VPWR VGND sg13cmos5l_fill_1
XFILLER_70_1010 VPWR VGND sg13cmos5l_decap_8
XFILLER_42_596 VPWR VGND sg13cmos5l_decap_4
XFILLER_14_276 VPWR VGND sg13cmos5l_fill_2
X_11655_ _11655_/Q _11671_/CLK _11655_/D _11655_/RESET_B VPWR VGND sg13cmos5l_dfrbpq_1
Xfanout91 _09807_/A fanout95/X VPWR VGND sg13cmos5l_buf_1
Xfanout80 fanout80/X _07565_/Y VPWR VGND sg13cmos5l_buf_1
X_11586_ _11586_/Q clkload49/A _11586_/D _11586_/RESET_B VPWR VGND sg13cmos5l_dfrbpq_1
X_10606_ _10606_/Y _10592_/A _10590_/Y _10589_/Y VPWR VGND sg13cmos5l_o21ai_1
XFILLER_7_932 VPWR VGND sg13cmos5l_decap_8
XFILLER_10_460 VPWR VGND sg13cmos5l_fill_2
X_10537_ _10537_/Y _10537_/A _10537_/B _10553_/B _10537_/D VPWR VGND sg13cmos5l_nand4_1
XFILLER_7_965 VPWR VGND sg13cmos5l_decap_8
X_10468_ _10468_/Y _10323_/B _10442_/Y _10321_/Y VPWR VGND sg13cmos5l_o21ai_1
X_10866__1116 _10866_/RESET_B VPWR VGND sg13cmos5l_tiehi
X_10902__1080 _10902_/RESET_B VPWR VGND sg13cmos5l_tiehi
X_10399_ _10453_/B _10397_/Y _10419_/A VPWR VGND sg13cmos5l_nand2b_1
XFILLER_9_1028 VPWR VGND sg13cmos5l_fill_1
XFILLER_97_758 VPWR VGND sg13cmos5l_fill_1
XFILLER_78_983 VPWR VGND sg13cmos5l_fill_1
XFILLER_38_814 VPWR VGND sg13cmos5l_fill_1
Xclkbuf_leaf_1_clk clkload7/A clkbuf_4_0_0_clk/X VPWR VGND sg13cmos5l_buf_8
XFILLER_65_622 VPWR VGND sg13cmos5l_fill_1
X_11155__1746 _11155_/RESET_B VPWR VGND sg13cmos5l_tiehi
X_06630_ _10801_/D _06668_/A1 _06627_/Y _06629_/Y VPWR VGND sg13cmos5l_o21ai_1
XFILLER_80_614 VPWR VGND sg13cmos5l_decap_4
XFILLER_92_496 VPWR VGND sg13cmos5l_fill_1
XFILLER_64_187 VPWR VGND sg13cmos5l_fill_2
X_06561_ _06563_/A _06564_/A1 _11659_/Q _10885_/Q _06134_/B VPWR VGND sg13cmos5l_a22oi_1
X_08300_ _11236_/D fanout60/X _08299_/B _08299_/Y VPWR VGND sg13cmos5l_a21oi_1
X_09280_ _09281_/C _10709_/A _09303_/A _09303_/D VPWR VGND sg13cmos5l_nor3_1
XFILLER_61_861 VPWR VGND sg13cmos5l_decap_8
X_06492_ _06492_/Y _10925_/Q _06512_/B VPWR VGND sg13cmos5l_nand2_1
X_08231_ _11202_/D fanout63/X _08236_/B _08230_/Y VPWR VGND sg13cmos5l_o21ai_1
X_11370__1531 _11370_/RESET_B VPWR VGND sg13cmos5l_tiehi
XFILLER_33_596 VPWR VGND sg13cmos5l_fill_1
XFILLER_21_769 VPWR VGND sg13cmos5l_decap_4
X_08162_ _11168_/D fanout72/X _08171_/B _08161_/Y VPWR VGND sg13cmos5l_a21oi_1
X_08093_ _11135_/D fanout75/X _08106_/B _08092_/Y VPWR VGND sg13cmos5l_o21ai_1
X_07113_ _07113_/Y hold2645/X _07126_/A2 _07155_/B1 VPWR VGND sg13cmos5l_o21ai_1
XFILLER_106_329 VPWR VGND sg13cmos5l_decap_8
Xclkload50 clkload50/Y clkload50/A VPWR VGND sg13cmos5l_inv_1
X_07044_ _07044_/Y _06978_/Y _07043_/Y _07044_/B1 VPWR VGND sg13cmos5l_a21oi_1
XFILLER_0_629 VPWR VGND sg13cmos5l_decap_8
XFILLER_88_736 VPWR VGND sg13cmos5l_decap_4
Xhold2812 _10668_/A _11422_/Q VPWR VGND sg13cmos5l_dlygate4sd3_1
Xhold2801 _10679_/A _11423_/Q VPWR VGND sg13cmos5l_dlygate4sd3_1
Xhold2823 hold2823/X _11728_/Q VPWR VGND sg13cmos5l_dlygate4sd3_1
X_08995_ _09007_/B _09018_/A _08996_/B VPWR VGND sg13cmos5l_nand2b_1
Xhold2834 hold2834/X _11729_/Q VPWR VGND sg13cmos5l_dlygate4sd3_1
Xhold2845 hold2845/X _11736_/Q VPWR VGND sg13cmos5l_dlygate4sd3_1
X_07946_ _07946_/Y _07946_/A _07946_/B VPWR VGND sg13cmos5l_nand2_1
Xhold2856 hold2856/X _11500_/Q VPWR VGND sg13cmos5l_dlygate4sd3_1
XFILLER_96_791 VPWR VGND sg13cmos5l_decap_8
Xhold2867 hold2867/X _11459_/Q VPWR VGND sg13cmos5l_dlygate4sd3_1
Xhold2889 _06104_/D _06103_/Y VPWR VGND sg13cmos5l_dlygate4sd3_1
Xhold2878 hold2878/X _11472_/Q VPWR VGND sg13cmos5l_dlygate4sd3_1
XFILLER_84_975 VPWR VGND sg13cmos5l_fill_2
XFILLER_83_430 VPWR VGND sg13cmos5l_fill_2
XFILLER_55_143 VPWR VGND sg13cmos5l_decap_8
XFILLER_55_132 VPWR VGND sg13cmos5l_decap_4
XFILLER_18_68 VPWR VGND sg13cmos5l_fill_1
X_07877_ _07877_/Y _07877_/A _07877_/B VPWR VGND sg13cmos5l_nor2_1
X_06828_ _06828_/Y _06828_/A _10785_/B VPWR VGND sg13cmos5l_nand2_1
XFILLER_44_828 VPWR VGND sg13cmos5l_decap_8
XFILLER_37_880 VPWR VGND sg13cmos5l_decap_4
X_09616_ _09618_/A _09611_/Y _09612_/Y _09615_/Y VPWR VGND sg13cmos5l_o21ai_1
X_06759_ _10817_/D _06759_/A1 _06756_/Y _06758_/Y VPWR VGND sg13cmos5l_o21ai_1
XFILLER_36_390 VPWR VGND sg13cmos5l_decap_8
X_09547_ _09547_/Y _09545_/Y _09546_/Y _09846_/A1 VPWR VGND sg13cmos5l_a21oi_1
X_10944__1038 _10944_/RESET_B VPWR VGND sg13cmos5l_tiehi
X_11200__1701 _11200_/RESET_B VPWR VGND sg13cmos5l_tiehi
X_09478_ _09558_/B _11464_/Q _09536_/B VPWR VGND sg13cmos5l_nor2_1
X_08429_ _08429_/Y _08429_/A _08429_/B VPWR VGND sg13cmos5l_nor2_1
X_11440_ _11440_/Q clkload43/A _11440_/D _11440_/RESET_B VPWR VGND sg13cmos5l_dfrbpq_1
Xclkload0 clkload0/X clkload0/A VPWR VGND sg13cmos5l_buf_8
X_11371_ _11371_/Q clkload28/A _11371_/D _11371_/RESET_B VPWR VGND sg13cmos5l_dfrbpq_1
X_10322_ _10411_/A _11559_/Q _11560_/Q VPWR VGND sg13cmos5l_nor2b_1
X_11233__1668 _11233_/RESET_B VPWR VGND sg13cmos5l_tiehi
XFILLER_79_703 VPWR VGND sg13cmos5l_fill_2
X_10253_ _10254_/B _10479_/A _10250_/B _10250_/D VPWR VGND sg13cmos5l_a21o_1
XFILLER_4_979 VPWR VGND sg13cmos5l_decap_8
XFILLER_3_456 VPWR VGND sg13cmos5l_fill_1
XFILLER_106_896 VPWR VGND sg13cmos5l_decap_8
XFILLER_105_384 VPWR VGND sg13cmos5l_decap_8
XFILLER_79_736 VPWR VGND sg13cmos5l_fill_1
X_10184_ _10184_/X _11394_/Q _10831_/Q VPWR VGND sg13cmos5l_and2_1
XFILLER_3_489 VPWR VGND sg13cmos5l_decap_8
XFILLER_94_728 VPWR VGND sg13cmos5l_fill_2
Xfanout270 _07640_/B fanout271/X VPWR VGND sg13cmos5l_buf_1
Xfanout292 _08078_/B _08096_/B VPWR VGND sg13cmos5l_buf_1
Xfanout281 _08350_/B _08340_/B VPWR VGND sg13cmos5l_buf_1
XFILLER_101_590 VPWR VGND sg13cmos5l_fill_1
XFILLER_75_964 VPWR VGND sg13cmos5l_fill_1
XFILLER_75_942 VPWR VGND sg13cmos5l_fill_2
XFILLER_74_430 VPWR VGND sg13cmos5l_fill_2
XFILLER_47_655 VPWR VGND sg13cmos5l_fill_2
XFILLER_74_452 VPWR VGND sg13cmos5l_decap_4
XFILLER_62_647 VPWR VGND sg13cmos5l_decap_8
XFILLER_34_338 VPWR VGND sg13cmos5l_decap_8
XFILLER_98_7 VPWR VGND sg13cmos5l_decap_8
X_11707_ _11707_/Q clkload31/A _11707_/D _11707_/RESET_B VPWR VGND sg13cmos5l_dfrbpq_1
X_11638_ _11638_/Q clkload25/A _11638_/D _11638_/RESET_B VPWR VGND sg13cmos5l_dfrbpq_1
X_11569_ _11569_/Q clkload26/A _11569_/D _11569_/RESET_B VPWR VGND sg13cmos5l_dfrbpq_1
X_11209__1692 _11209_/RESET_B VPWR VGND sg13cmos5l_tiehi
X_11037__888 _11037_/RESET_B VPWR VGND sg13cmos5l_tiehi
Xhold2108 _08249_/A _11211_/Q VPWR VGND sg13cmos5l_dlygate4sd3_1
X_11693__1271 _11693_/RESET_B VPWR VGND sg13cmos5l_tiehi
XFILLER_3_990 VPWR VGND sg13cmos5l_decap_8
Xhold2119 _07640_/A _10919_/Q VPWR VGND sg13cmos5l_dlygate4sd3_1
XFILLER_58_909 VPWR VGND sg13cmos5l_fill_1
X_08780_ _08780_/Y _08780_/A VPWR VGND sg13cmos5l_inv_1
X_07800_ _07800_/Y _07800_/A _07808_/B VPWR VGND sg13cmos5l_nand2_1
XFILLER_97_599 VPWR VGND sg13cmos5l_fill_1
X_05992_ _08614_/A _08624_/A _08620_/A VPWR VGND sg13cmos5l_and2_1
X_07731_ _10958_/D _08451_/A1 _07746_/B _07730_/Y VPWR VGND sg13cmos5l_a21oi_1
XFILLER_38_633 VPWR VGND sg13cmos5l_fill_2
XFILLER_26_806 VPWR VGND sg13cmos5l_fill_2
XFILLER_53_614 VPWR VGND sg13cmos5l_decap_8
X_07662_ _07662_/Y _07662_/A _07682_/B VPWR VGND sg13cmos5l_nor2_1
XFILLER_1_60 VPWR VGND sg13cmos5l_fill_1
XFILLER_26_817 VPWR VGND sg13cmos5l_fill_2
X_07593_ _07593_/Y _07599_/A _07592_/X _07591_/Y VPWR VGND sg13cmos5l_o21ai_1
X_09401_ _09408_/B _09534_/A _09401_/B _09401_/C VPWR VGND sg13cmos5l_nor3_1
X_06613_ _06614_/B _06618_/B _06628_/B VPWR VGND sg13cmos5l_nor2_1
X_09332_ _09332_/Y _06484_/B _09316_/B _09331_/Y VPWR VGND sg13cmos5l_a21oi_1
X_06544_ _06545_/B _06571_/B2 _10879_/Q _10863_/Q _06574_/B2 VPWR VGND sg13cmos5l_a22oi_1
XFILLER_34_894 VPWR VGND sg13cmos5l_decap_4
X_09263_ _10005_/B _09264_/A _09263_/B VPWR VGND sg13cmos5l_nand2_1
XFILLER_21_533 VPWR VGND sg13cmos5l_fill_1
X_06475_ _06475_/X _11244_/Q _11212_/Q _11180_/Q _11148_/Q _09840_/S _09848_/B1 VPWR
+ VGND sg13cmos5l_mux4_1
X_08214_ _08214_/Y _08214_/A _08220_/B VPWR VGND sg13cmos5l_nand2_1
XFILLER_21_588 VPWR VGND sg13cmos5l_fill_2
X_09194_ _09194_/Y _09344_/A _09344_/B _09178_/X VPWR VGND sg13cmos5l_a21oi_1
X_08145_ _08145_/Y _08145_/A _08145_/B VPWR VGND sg13cmos5l_nor2_1
XFILLER_106_126 VPWR VGND sg13cmos5l_decap_8
X_08076_ _08076_/Y _08076_/A _08076_/B VPWR VGND sg13cmos5l_nand2_1
X_07027_ _07027_/Y _07026_/B _07025_/Y _07026_/Y VPWR VGND sg13cmos5l_o21ai_1
XFILLER_88_544 VPWR VGND sg13cmos5l_decap_8
XFILLER_102_332 VPWR VGND sg13cmos5l_decap_4
Xhold2631 _07188_/A _07186_/Y VPWR VGND sg13cmos5l_dlygate4sd3_1
Xhold2620 hold2620/X _12767_/A VPWR VGND sg13cmos5l_dlygate4sd3_1
XFILLER_75_216 VPWR VGND sg13cmos5l_fill_2
Xhold2653 _07230_/B _07229_/Y VPWR VGND sg13cmos5l_dlygate4sd3_1
Xhold2664 _11700_/D _06892_/X VPWR VGND sg13cmos5l_dlygate4sd3_1
XFILLER_57_920 VPWR VGND sg13cmos5l_decap_8
Xhold2642 hold2642/X _11429_/Q VPWR VGND sg13cmos5l_dlygate4sd3_1
X_08978_ _11440_/D _08976_/Y _08977_/Y _08959_/Y VPWR VGND sg13cmos5l_o21ai_1
Xhold1930 _07982_/A _11081_/Q VPWR VGND sg13cmos5l_dlygate4sd3_1
Xhold1952 _08106_/A _11142_/Q VPWR VGND sg13cmos5l_dlygate4sd3_1
Xhold2697 _06014_/B _11757_/Q VPWR VGND sg13cmos5l_dlygate4sd3_1
Xhold2675 _08611_/A _11553_/Q VPWR VGND sg13cmos5l_dlygate4sd3_1
Xhold2686 _11701_/D _06894_/X VPWR VGND sg13cmos5l_dlygate4sd3_1
XFILLER_56_430 VPWR VGND sg13cmos5l_fill_1
X_07929_ _11054_/D _08451_/A1 _07940_/B _07928_/Y VPWR VGND sg13cmos5l_o21ai_1
Xhold1941 _08220_/A _11197_/Q VPWR VGND sg13cmos5l_dlygate4sd3_1
Xhold1963 _08348_/A _11260_/Q VPWR VGND sg13cmos5l_dlygate4sd3_1
XFILLER_90_208 VPWR VGND sg13cmos5l_fill_2
Xhold1996 _08362_/A _11267_/Q VPWR VGND sg13cmos5l_dlygate4sd3_1
XFILLER_84_761 VPWR VGND sg13cmos5l_decap_8
XFILLER_56_452 VPWR VGND sg13cmos5l_fill_1
Xhold1985 _08330_/A _11251_/Q VPWR VGND sg13cmos5l_dlygate4sd3_1
Xhold1974 _07944_/A _11062_/Q VPWR VGND sg13cmos5l_dlygate4sd3_1
X_10940_ _10940_/Q _11356_/CLK _10940_/D _10940_/RESET_B VPWR VGND sg13cmos5l_dfrbpq_1
XFILLER_72_956 VPWR VGND sg13cmos5l_fill_1
XFILLER_16_327 VPWR VGND sg13cmos5l_fill_2
XFILLER_16_349 VPWR VGND sg13cmos5l_fill_2
XFILLER_71_444 VPWR VGND sg13cmos5l_fill_2
XFILLER_45_66 VPWR VGND sg13cmos5l_decap_4
XFILLER_43_157 VPWR VGND sg13cmos5l_decap_4
XFILLER_43_135 VPWR VGND sg13cmos5l_fill_2
X_10871_ _10871_/Q clkload12/A _10871_/D _10871_/RESET_B VPWR VGND sg13cmos5l_dfrbpq_1
XFILLER_24_371 VPWR VGND sg13cmos5l_decap_8
XFILLER_40_831 VPWR VGND sg13cmos5l_decap_8
XFILLER_12_522 VPWR VGND sg13cmos5l_fill_2
XFILLER_8_537 VPWR VGND sg13cmos5l_fill_1
XFILLER_8_526 VPWR VGND sg13cmos5l_fill_2
X_11423_ _11423_/Q clkload53/A _11423_/D _11423_/RESET_B VPWR VGND sg13cmos5l_dfrbpq_1
XFILLER_12_599 VPWR VGND sg13cmos5l_fill_2
XFILLER_6_49 VPWR VGND sg13cmos5l_fill_2
XANTENNA_9 _07430_/Y VPWR VGND sg13cmos5l_antennanp
X_11354_ _11354_/Q clkload42/A _11354_/D _11354_/RESET_B VPWR VGND sg13cmos5l_dfrbpq_1
X_10305_ _10504_/B _10305_/A _10305_/B VPWR VGND sg13cmos5l_xnor2_1
XFILLER_3_231 VPWR VGND sg13cmos5l_decap_4
X_11285_ _11285_/Q _11349_/CLK _11285_/D _11285_/RESET_B VPWR VGND sg13cmos5l_dfrbpq_1
XFILLER_106_693 VPWR VGND sg13cmos5l_decap_8
X_10236_ _10236_/Y _11731_/Q _10180_/B _10235_/Y VPWR VGND sg13cmos5l_o21ai_1
XFILLER_79_577 VPWR VGND sg13cmos5l_fill_1
XFILLER_39_408 VPWR VGND sg13cmos5l_decap_8
X_10167_ _10167_/Y hold2795/X _07066_/Y _10166_/X _10470_/A VPWR VGND sg13cmos5l_a22oi_1
XFILLER_48_920 VPWR VGND sg13cmos5l_fill_1
XFILLER_0_971 VPWR VGND sg13cmos5l_decap_8
XFILLER_75_750 VPWR VGND sg13cmos5l_fill_2
XFILLER_48_964 VPWR VGND sg13cmos5l_fill_2
XFILLER_48_953 VPWR VGND sg13cmos5l_decap_8
X_10098_ _10098_/Y _10330_/B _09218_/B _10131_/A2 VPWR VGND sg13cmos5l_o21ai_1
XFILLER_48_986 VPWR VGND sg13cmos5l_fill_2
XFILLER_74_271 VPWR VGND sg13cmos5l_decap_4
XFILLER_62_433 VPWR VGND sg13cmos5l_decap_4
XFILLER_62_411 VPWR VGND sg13cmos5l_fill_2
XFILLER_47_496 VPWR VGND sg13cmos5l_fill_1
XFILLER_90_753 VPWR VGND sg13cmos5l_fill_1
XFILLER_50_606 VPWR VGND sg13cmos5l_fill_2
XFILLER_35_658 VPWR VGND sg13cmos5l_decap_4
XFILLER_43_680 VPWR VGND sg13cmos5l_decap_8
XFILLER_16_894 VPWR VGND sg13cmos5l_decap_8
XFILLER_22_319 VPWR VGND sg13cmos5l_decap_8
XFILLER_31_864 VPWR VGND sg13cmos5l_decap_8
X_06260_ _06264_/A _11512_/Q _09938_/A VPWR VGND sg13cmos5l_and2_1
X_06191_ _06192_/B _07032_/A _06191_/B VPWR VGND sg13cmos5l_nand2_1
XFILLER_104_619 VPWR VGND sg13cmos5l_decap_8
X_09950_ _09950_/Y _11013_/Q _09957_/B VPWR VGND sg13cmos5l_nand2_1
X_08901_ _08901_/Y _08916_/B1 _08900_/Y _08921_/A VPWR VGND sg13cmos5l_o21ai_1
XFILLER_106_28 VPWR VGND sg13cmos5l_decap_8
X_09881_ _09881_/Y _09902_/A _09876_/X _09880_/Y VPWR VGND sg13cmos5l_o21ai_1
X_08832_ _08832_/Y _08832_/A1 _08830_/Y _08831_/Y VPWR VGND sg13cmos5l_a21oi_1
XFILLER_97_396 VPWR VGND sg13cmos5l_fill_2
X_08763_ _09127_/B _08763_/A _08763_/B VPWR VGND sg13cmos5l_nand2_1
XFILLER_39_942 VPWR VGND sg13cmos5l_fill_1
X_05975_ _05975_/Y _11324_/Q VPWR VGND sg13cmos5l_inv_1
X_07714_ _07714_/Y _07714_/A _07714_/B VPWR VGND sg13cmos5l_nor2_1
XFILLER_54_901 VPWR VGND sg13cmos5l_decap_4
XFILLER_66_794 VPWR VGND sg13cmos5l_fill_2
XFILLER_38_485 VPWR VGND sg13cmos5l_fill_2
XFILLER_25_102 VPWR VGND sg13cmos5l_fill_1
X_08694_ _08695_/B _08694_/A _08694_/B VPWR VGND sg13cmos5l_nand2_1
XFILLER_81_753 VPWR VGND sg13cmos5l_decap_8
X_07645_ _07645_/Y _07599_/A _08766_/B _07649_/B _07644_/Y VPWR VGND sg13cmos5l_a22oi_1
XFILLER_54_978 VPWR VGND sg13cmos5l_decap_8
X_07576_ _07577_/B _10513_/A _07575_/C _11412_/Q VPWR VGND sg13cmos5l_a21oi_1
XFILLER_41_628 VPWR VGND sg13cmos5l_decap_8
X_09315_ _11456_/D _09317_/A _09314_/A _09308_/Y _09314_/Y VPWR VGND sg13cmos5l_a22oi_1
X_06527_ _11372_/D _06527_/A VPWR VGND sg13cmos5l_inv_1
XFILLER_15_58 VPWR VGND sg13cmos5l_fill_1
X_10861__1121 _10861_/RESET_B VPWR VGND sg13cmos5l_tiehi
X_09246_ _09948_/A _09246_/A _10856_/Q VPWR VGND sg13cmos5l_xnor2_1
X_06458_ _06458_/X _10140_/A _11635_/Q VPWR VGND sg13cmos5l_and2_1
XFILLER_22_897 VPWR VGND sg13cmos5l_decap_4
XFILLER_31_13 VPWR VGND sg13cmos5l_fill_2
X_06389_ _06390_/B _06389_/A _10581_/B _06389_/C VPWR VGND sg13cmos5l_nand3_1
XFILLER_5_518 VPWR VGND sg13cmos5l_decap_4
X_09177_ _09177_/Y _09405_/A _09177_/B VPWR VGND sg13cmos5l_xnor2_1
X_08128_ _11151_/D _08518_/A1 _08145_/B _08127_/Y VPWR VGND sg13cmos5l_a21oi_1
Xoutput24 uio_out[13] _06132_/X VPWR VGND sg13cmos5l_buf_1
X_08059_ _11118_/D _08516_/A1 _08074_/B _08058_/Y VPWR VGND sg13cmos5l_o21ai_1
X_10894__1088 _10894_/RESET_B VPWR VGND sg13cmos5l_tiehi
X_11070_ _11070_/Q clkload58/A _11070_/D _11070_/RESET_B VPWR VGND sg13cmos5l_dfrbpq_1
X_11150__1751 _11150_/RESET_B VPWR VGND sg13cmos5l_tiehi
Xoutput46 uo_out[7] _06551_/Y VPWR VGND sg13cmos5l_buf_1
Xoutput35 uo_out[11] _06563_/Y VPWR VGND sg13cmos5l_buf_1
X_10021_ _10021_/Y _08565_/A _10021_/A2 _10021_/B1 _10020_/Y VPWR VGND sg13cmos5l_a22oi_1
XFILLER_49_706 VPWR VGND sg13cmos5l_decap_8
XFILLER_102_140 VPWR VGND sg13cmos5l_decap_8
XFILLER_76_503 VPWR VGND sg13cmos5l_fill_2
XFILLER_49_717 VPWR VGND sg13cmos5l_fill_2
XFILLER_48_205 VPWR VGND sg13cmos5l_fill_1
Xhold2461 _06946_/D _11606_/Q VPWR VGND sg13cmos5l_dlygate4sd3_1
Xhold2450 _10739_/B _10738_/Y VPWR VGND sg13cmos5l_dlygate4sd3_1
Xhold2472 _08651_/A _11424_/Q VPWR VGND sg13cmos5l_dlygate4sd3_1
XFILLER_91_528 VPWR VGND sg13cmos5l_decap_8
Xhold2483 _06072_/A _11624_/Q VPWR VGND sg13cmos5l_dlygate4sd3_1
Xhold2494 hold2494/X _11580_/Q VPWR VGND sg13cmos5l_dlygate4sd3_1
XFILLER_72_731 VPWR VGND sg13cmos5l_fill_2
XFILLER_56_271 VPWR VGND sg13cmos5l_decap_4
XFILLER_16_102 VPWR VGND sg13cmos5l_fill_2
XFILLER_29_474 VPWR VGND sg13cmos5l_decap_4
X_10923_ _10923_/Q clkload32/A _10923_/D _10923_/RESET_B VPWR VGND sg13cmos5l_dfrbpq_1
X_10854_ _10854_/Q _11715_/CLK _10854_/D _10854_/RESET_B VPWR VGND sg13cmos5l_dfrbpq_1
XFILLER_44_488 VPWR VGND sg13cmos5l_fill_2
XFILLER_31_105 VPWR VGND sg13cmos5l_fill_2
XFILLER_72_75 VPWR VGND sg13cmos5l_fill_1
X_11027__898 _11027_/RESET_B VPWR VGND sg13cmos5l_tiehi
XFILLER_13_842 VPWR VGND sg13cmos5l_decap_8
XFILLER_13_853 VPWR VGND sg13cmos5l_fill_2
XFILLER_25_691 VPWR VGND sg13cmos5l_fill_2
X_10785_ _10785_/Y _10785_/A _10785_/B VPWR VGND sg13cmos5l_nand2_1
XFILLER_13_875 VPWR VGND sg13cmos5l_fill_1
XFILLER_9_868 VPWR VGND sg13cmos5l_decap_8
X_11406_ _11406_/Q _11535_/CLK _11406_/D _11406_/RESET_B VPWR VGND sg13cmos5l_dfrbpq_1
XFILLER_8_389 VPWR VGND sg13cmos5l_fill_2
X_11337_ _11337_/Q clkload51/A _11337_/D _11337_/RESET_B VPWR VGND sg13cmos5l_dfrbpq_1
X_11073__852 _11073_/RESET_B VPWR VGND sg13cmos5l_tiehi
XFILLER_98_105 VPWR VGND sg13cmos5l_decap_8
XFILLER_106_490 VPWR VGND sg13cmos5l_decap_8
X_11268_ _11268_/Q _11339_/CLK _11268_/D _11268_/RESET_B VPWR VGND sg13cmos5l_dfrbpq_1
X_11199_ _11199_/Q clkload50/A _11199_/D _11199_/RESET_B VPWR VGND sg13cmos5l_dfrbpq_1
XFILLER_97_94 VPWR VGND sg13cmos5l_fill_2
X_10219_ _10232_/A _11398_/Q _10835_/Q VPWR VGND sg13cmos5l_and2_1
X_11584__1451 _11584_/RESET_B VPWR VGND sg13cmos5l_tiehi
XFILLER_79_396 VPWR VGND sg13cmos5l_decap_8
XFILLER_36_967 VPWR VGND sg13cmos5l_decap_8
X_11080__845 _11080_/RESET_B VPWR VGND sg13cmos5l_tiehi
X_07430_ _07430_/Y _09270_/A _07430_/A2 _07429_/Y VPWR VGND sg13cmos5l_a21oi_1
XFILLER_63_797 VPWR VGND sg13cmos5l_fill_2
XFILLER_62_252 VPWR VGND sg13cmos5l_decap_4
XFILLER_35_477 VPWR VGND sg13cmos5l_fill_1
X_07361_ _07361_/Y _11539_/Q _08721_/A VPWR VGND sg13cmos5l_nand2_1
X_11192__1709 _11192_/RESET_B VPWR VGND sg13cmos5l_tiehi
XFILLER_87_0 VPWR VGND sg13cmos5l_decap_8
X_09100_ _09105_/B _09120_/A _09098_/Y _09099_/Y VPWR VGND sg13cmos5l_a21oi_1
X_06312_ _06313_/A _06721_/A _06311_/Y _06310_/Y VPWR VGND sg13cmos5l_o21ai_1
X_09031_ _11444_/D _09029_/Y _09030_/Y _09015_/Y VPWR VGND sg13cmos5l_o21ai_1
X_07292_ _07292_/Y _09198_/A _07304_/A2 _07291_/Y VPWR VGND sg13cmos5l_a21oi_1
X_06243_ _06436_/A _11517_/Q _09268_/A VPWR VGND sg13cmos5l_nand2_1
XFILLER_11_1014 VPWR VGND sg13cmos5l_decap_8
X_06174_ _06633_/A _06174_/A _09198_/A VPWR VGND sg13cmos5l_nand2_1
XFILLER_105_939 VPWR VGND sg13cmos5l_decap_8
XFILLER_104_416 VPWR VGND sg13cmos5l_decap_8
X_09933_ _09933_/Y _09933_/A _09933_/B VPWR VGND sg13cmos5l_nor2_1
Xfanout814 _09154_/A1 _10793_/Q VPWR VGND sg13cmos5l_buf_1
Xfanout825 _07163_/B1 _10687_/A VPWR VGND sg13cmos5l_buf_1
Xfanout803 _09056_/A _08645_/A1 VPWR VGND sg13cmos5l_buf_1
X_09864_ _09889_/B _10032_/A _09917_/A _09864_/C VPWR VGND sg13cmos5l_nor3_1
X_08815_ _08816_/B _08805_/A _08805_/B _08802_/Y VPWR VGND sg13cmos5l_o21ai_1
X_10879__1103 _10879_/RESET_B VPWR VGND sg13cmos5l_tiehi
XFILLER_100_666 VPWR VGND sg13cmos5l_fill_2
X_09795_ _09802_/B _10044_/A _09795_/B _09795_/C VPWR VGND sg13cmos5l_nor3_1
XFILLER_45_208 VPWR VGND sg13cmos5l_fill_1
XFILLER_27_912 VPWR VGND sg13cmos5l_fill_1
X_08746_ _09077_/B _08746_/A _08746_/B VPWR VGND sg13cmos5l_nand2_1
XFILLER_54_731 VPWR VGND sg13cmos5l_decap_8
X_05958_ _05958_/Y _11313_/Q VPWR VGND sg13cmos5l_inv_1
X_05889_ _05889_/Y input9/X VPWR VGND sg13cmos5l_inv_1
X_08677_ _08678_/A hold2777/X _08846_/B _08849_/B _08856_/B1 VPWR VGND sg13cmos5l_a22oi_1
X_07628_ _10917_/D _07629_/B fanout57/X _07627_/Y VPWR VGND sg13cmos5l_a21oi_1
XFILLER_53_252 VPWR VGND sg13cmos5l_fill_2
XFILLER_53_296 VPWR VGND sg13cmos5l_decap_4
X_11168__1733 _11168_/RESET_B VPWR VGND sg13cmos5l_tiehi
XFILLER_42_34 VPWR VGND sg13cmos5l_decap_4
X_07559_ _07559_/Y _07577_/A _08712_/B _07556_/Y _07558_/Y VPWR VGND sg13cmos5l_a22oi_1
X_10570_ _10570_/Y _10570_/A _10570_/B _10570_/C VPWR VGND sg13cmos5l_nor3_1
XFILLER_22_672 VPWR VGND sg13cmos5l_fill_1
X_09229_ _09229_/Y _10267_/D _10848_/Q VPWR VGND sg13cmos5l_nor2_1
XFILLER_6_827 VPWR VGND sg13cmos5l_decap_8
XFILLER_6_805 VPWR VGND sg13cmos5l_decap_4
XFILLER_5_348 VPWR VGND sg13cmos5l_decap_8
XFILLER_104_950 VPWR VGND sg13cmos5l_decap_8
X_11122_ _11122_/Q clkload8/A _11122_/D _11122_/RESET_B VPWR VGND sg13cmos5l_dfrbpq_1
XFILLER_3_28 VPWR VGND sg13cmos5l_fill_2
X_11053_ _11053_/Q clkload33/A _11053_/D _11053_/RESET_B VPWR VGND sg13cmos5l_dfrbpq_1
XFILLER_1_554 VPWR VGND sg13cmos5l_fill_1
XFILLER_103_493 VPWR VGND sg13cmos5l_decap_4
XFILLER_88_193 VPWR VGND sg13cmos5l_fill_1
X_10004_ _10006_/B _10005_/B _10005_/C _10005_/A VPWR VGND sg13cmos5l_a21o_1
XFILLER_49_547 VPWR VGND sg13cmos5l_fill_1
XFILLER_49_536 VPWR VGND sg13cmos5l_fill_1
XFILLER_49_525 VPWR VGND sg13cmos5l_decap_8
XFILLER_1_598 VPWR VGND sg13cmos5l_decap_8
Xhold2280 _08411_/A _11291_/Q VPWR VGND sg13cmos5l_dlygate4sd3_1
Xhold2291 _07269_/A _10862_/Q VPWR VGND sg13cmos5l_dlygate4sd3_1
XFILLER_64_528 VPWR VGND sg13cmos5l_decap_8
XFILLER_57_591 VPWR VGND sg13cmos5l_decap_8
XFILLER_17_411 VPWR VGND sg13cmos5l_decap_4
XFILLER_29_282 VPWR VGND sg13cmos5l_fill_2
XFILLER_83_41 VPWR VGND sg13cmos5l_fill_1
XFILLER_83_30 VPWR VGND sg13cmos5l_decap_8
X_10906_ _10906_/Q clkload41/A _10906_/D _10906_/RESET_B VPWR VGND sg13cmos5l_dfrbpq_1
XFILLER_17_499 VPWR VGND sg13cmos5l_fill_2
X_10837_ _10837_/Q clkload30/A _10837_/D _10837_/RESET_B VPWR VGND sg13cmos5l_dfrbpq_1
X_10768_ _10768_/X hold2498/X _10770_/S _07201_/X VPWR VGND sg13cmos5l_a21o_1
XFILLER_40_480 VPWR VGND sg13cmos5l_decap_8
XFILLER_12_171 VPWR VGND sg13cmos5l_fill_2
XFILLER_40_491 VPWR VGND sg13cmos5l_fill_1
X_10699_ _10700_/A _06084_/A _10704_/C _10697_/Y _10698_/Y VPWR VGND sg13cmos5l_a22oi_1
X_10957__1025 _10957_/RESET_B VPWR VGND sg13cmos5l_tiehi
XFILLER_59_4 VPWR VGND sg13cmos5l_decap_4
XFILLER_87_609 VPWR VGND sg13cmos5l_fill_1
X_06930_ _06935_/C _11688_/D _11689_/D VPWR VGND sg13cmos5l_nand2b_1
XFILLER_68_856 VPWR VGND sg13cmos5l_decap_4
X_08600_ _08600_/Y _11339_/Q _08588_/B _09932_/S1 VPWR VGND sg13cmos5l_a21oi_1
XFILLER_95_675 VPWR VGND sg13cmos5l_fill_2
XFILLER_94_152 VPWR VGND sg13cmos5l_decap_8
X_06861_ _06861_/Y _06861_/A _06861_/B VPWR VGND sg13cmos5l_nand2_1
XFILLER_67_344 VPWR VGND sg13cmos5l_fill_1
X_11732__1216 _11732_/RESET_B VPWR VGND sg13cmos5l_tiehi
X_11246__1655 _11246_/RESET_B VPWR VGND sg13cmos5l_tiehi
X_06792_ _06792_/Y _10723_/A _10763_/S VPWR VGND sg13cmos5l_nand2_1
X_09580_ _09581_/B _09395_/A _09575_/X _09579_/Y VPWR VGND sg13cmos5l_o21ai_1
XFILLER_36_764 VPWR VGND sg13cmos5l_decap_4
X_08531_ _08531_/Y _08531_/A _08543_/B VPWR VGND sg13cmos5l_nor2_1
XFILLER_91_870 VPWR VGND sg13cmos5l_fill_1
XFILLER_63_561 VPWR VGND sg13cmos5l_decap_4
XFILLER_35_274 VPWR VGND sg13cmos5l_decap_4
X_08462_ _08462_/Y _08462_/A _08462_/B VPWR VGND sg13cmos5l_nand2_1
XFILLER_23_414 VPWR VGND sg13cmos5l_decap_8
XFILLER_23_425 VPWR VGND sg13cmos5l_fill_2
XFILLER_24_948 VPWR VGND sg13cmos5l_fill_1
X_07413_ _07413_/Y _07413_/A _07431_/B VPWR VGND sg13cmos5l_nor2_1
X_08393_ _08393_/Y _08393_/A _08403_/B VPWR VGND sg13cmos5l_nor2_1
XFILLER_23_469 VPWR VGND sg13cmos5l_decap_8
X_07344_ _08713_/A _08959_/A _07362_/B VPWR VGND sg13cmos5l_nand2_1
X_07275_ _07275_/Y _07275_/A _07365_/B VPWR VGND sg13cmos5l_nor2_1
X_09014_ _11443_/D _09012_/Y _09013_/Y _09004_/Y VPWR VGND sg13cmos5l_o21ai_1
X_06226_ _06377_/A _10434_/B _09641_/A VPWR VGND sg13cmos5l_or2_1
XFILLER_105_703 VPWR VGND sg13cmos5l_decap_8
XFILLER_2_307 VPWR VGND sg13cmos5l_decap_8
X_06157_ _06674_/A _11500_/Q _09480_/A VPWR VGND sg13cmos5l_nor2_1
XFILLER_105_769 VPWR VGND sg13cmos5l_fill_1
XFILLER_105_758 VPWR VGND sg13cmos5l_decap_8
XFILLER_104_224 VPWR VGND sg13cmos5l_decap_8
X_06088_ _09281_/A _10691_/C _06525_/A VPWR VGND sg13cmos5l_nand2_1
XFILLER_99_970 VPWR VGND sg13cmos5l_decap_8
Xfanout633 _10644_/B1 _10696_/A VPWR VGND sg13cmos5l_buf_1
Xfanout622 _07091_/S _07098_/B VPWR VGND sg13cmos5l_buf_1
X_09916_ _11481_/D _05900_/Y _09915_/A _09893_/Y _09915_/Y VPWR VGND sg13cmos5l_a22oi_1
Xfanout611 _08957_/B1 _06023_/X VPWR VGND sg13cmos5l_buf_1
Xfanout600 _08831_/B1 _08856_/B1 VPWR VGND sg13cmos5l_buf_1
XFILLER_86_642 VPWR VGND sg13cmos5l_fill_2
Xfanout666 _10654_/A _11755_/Q VPWR VGND sg13cmos5l_buf_1
Xfanout655 _09303_/A _09298_/A VPWR VGND sg13cmos5l_buf_1
XFILLER_59_845 VPWR VGND sg13cmos5l_decap_8
XFILLER_59_834 VPWR VGND sg13cmos5l_fill_2
Xfanout644 _06564_/B2 _11764_/Q VPWR VGND sg13cmos5l_buf_1
XFILLER_101_953 VPWR VGND sg13cmos5l_decap_8
X_10828__1186 _10828_/RESET_B VPWR VGND sg13cmos5l_tiehi
XFILLER_86_653 VPWR VGND sg13cmos5l_decap_8
Xfanout688 _07072_/B _11750_/Q VPWR VGND sg13cmos5l_buf_1
Xfanout677 _10614_/B2 _10140_/A VPWR VGND sg13cmos5l_buf_1
Xfanout699 _06639_/A _06662_/A VPWR VGND sg13cmos5l_buf_1
X_09847_ _09847_/X _11265_/Q _11233_/Q _11201_/Q _11169_/Q _09708_/S _09848_/B1 VPWR
+ VGND sg13cmos5l_mux4_1
XFILLER_85_185 VPWR VGND sg13cmos5l_fill_1
X_11414__1462 _11414_/RESET_B VPWR VGND sg13cmos5l_tiehi
X_09778_ _09779_/C _10536_/A _09805_/A2 _09857_/A _09777_/Y VPWR VGND sg13cmos5l_a22oi_1
X_08729_ _11412_/D _08729_/A VPWR VGND sg13cmos5l_inv_1
X_11560__1437 _11560_/RESET_B VPWR VGND sg13cmos5l_tiehi
X_11740_ _11740_/Q clkload14/A _11740_/D _11740_/RESET_B VPWR VGND sg13cmos5l_dfrbpq_1
X_11447__1396 _11447_/RESET_B VPWR VGND sg13cmos5l_tiehi
X_11063__862 _11063_/RESET_B VPWR VGND sg13cmos5l_tiehi
XFILLER_42_789 VPWR VGND sg13cmos5l_fill_1
XFILLER_42_778 VPWR VGND sg13cmos5l_decap_8
XFILLER_14_469 VPWR VGND sg13cmos5l_fill_1
X_11671_ _11671_/Q _11671_/CLK _11671_/D _11671_/RESET_B VPWR VGND sg13cmos5l_dfrbpq_1
XFILLER_23_970 VPWR VGND sg13cmos5l_fill_1
X_10622_ _10643_/A _10622_/A _10622_/B _10622_/C _10623_/B VPWR VGND sg13cmos5l_or4_1
X_11498__1187 _11498_/RESET_B VPWR VGND sg13cmos5l_tiehi
X_10553_ _10553_/Y _10552_/Y _10553_/B VPWR VGND sg13cmos5l_nand2b_1
X_11618__1355 _11618_/RESET_B VPWR VGND sg13cmos5l_tiehi
X_10484_ _10484_/Y _10525_/A _10465_/B _10494_/B1 VPWR VGND sg13cmos5l_a21oi_1
XFILLER_5_134 VPWR VGND sg13cmos5l_fill_2
X_11324__1577 _11324_/RESET_B VPWR VGND sg13cmos5l_tiehi
XFILLER_64_1018 VPWR VGND sg13cmos5l_fill_1
X_11070__855 _11070_/RESET_B VPWR VGND sg13cmos5l_tiehi
X_11105_ _11105_/Q _11361_/CLK _11105_/D _11105_/RESET_B VPWR VGND sg13cmos5l_dfrbpq_1
XFILLER_2_863 VPWR VGND sg13cmos5l_fill_2
XFILLER_96_439 VPWR VGND sg13cmos5l_fill_1
XFILLER_89_480 VPWR VGND sg13cmos5l_fill_2
XFILLER_49_333 VPWR VGND sg13cmos5l_decap_8
XFILLER_77_664 VPWR VGND sg13cmos5l_fill_1
XFILLER_77_653 VPWR VGND sg13cmos5l_decap_4
XFILLER_65_804 VPWR VGND sg13cmos5l_decap_8
X_11036_ _11036_/Q _11356_/CLK _11036_/D _11036_/RESET_B VPWR VGND sg13cmos5l_dfrbpq_1
XFILLER_92_634 VPWR VGND sg13cmos5l_fill_2
XFILLER_37_539 VPWR VGND sg13cmos5l_decap_4
XFILLER_18_720 VPWR VGND sg13cmos5l_fill_1
XFILLER_92_656 VPWR VGND sg13cmos5l_fill_1
XFILLER_64_358 VPWR VGND sg13cmos5l_decap_4
XFILLER_18_753 VPWR VGND sg13cmos5l_decap_8
XFILLER_92_678 VPWR VGND sg13cmos5l_fill_1
XFILLER_72_391 VPWR VGND sg13cmos5l_decap_8
XFILLER_60_520 VPWR VGND sg13cmos5l_fill_1
XFILLER_33_756 VPWR VGND sg13cmos5l_decap_4
XFILLER_60_575 VPWR VGND sg13cmos5l_decap_8
XFILLER_9_440 VPWR VGND sg13cmos5l_decap_8
X_07060_ _11678_/D hold2500/X _07060_/A2 _07059_/Y VPWR VGND sg13cmos5l_a21o_1
X_06011_ _06012_/C _11758_/Q _06044_/A _06010_/Y VPWR VGND sg13cmos5l_a21oi_1
XFILLER_88_907 VPWR VGND sg13cmos5l_decap_4
XFILLER_4_60 VPWR VGND sg13cmos5l_fill_1
XFILLER_101_238 VPWR VGND sg13cmos5l_fill_1
XFILLER_101_227 VPWR VGND sg13cmos5l_fill_2
XFILLER_99_299 VPWR VGND sg13cmos5l_decap_4
X_07962_ _07962_/Y _07962_/A _07976_/B VPWR VGND sg13cmos5l_nand2_1
X_09701_ _11473_/D _05910_/Y _09807_/A _09676_/Y _09700_/Y VPWR VGND sg13cmos5l_a22oi_1
XFILLER_96_951 VPWR VGND sg13cmos5l_decap_4
XFILLER_95_450 VPWR VGND sg13cmos5l_fill_1
X_06913_ _10772_/A _06913_/A _06913_/B VPWR VGND sg13cmos5l_nor2_1
XFILLER_68_675 VPWR VGND sg13cmos5l_decap_8
X_07893_ _07893_/Y _07893_/A _07893_/B VPWR VGND sg13cmos5l_nor2_1
XFILLER_83_634 VPWR VGND sg13cmos5l_fill_1
X_06844_ _06844_/Y _11645_/Q _07190_/C VPWR VGND sg13cmos5l_nand2_1
X_09632_ _09633_/C _09628_/Y _09629_/Y _09630_/Y _09631_/Y _06474_/A VPWR VGND sg13cmos5l_a221oi_1
XFILLER_28_517 VPWR VGND sg13cmos5l_decap_8
XFILLER_83_667 VPWR VGND sg13cmos5l_decap_4
X_09563_ _09563_/Y _09672_/A _09563_/B _09563_/C VPWR VGND sg13cmos5l_nor3_1
X_06775_ _06775_/Y _11513_/Q _10614_/A1 _06775_/B1 VPWR VGND sg13cmos5l_o21ai_1
X_08514_ _11341_/D _08514_/A1 _08533_/B _08513_/Y VPWR VGND sg13cmos5l_a21oi_1
X_09494_ _09494_/Y _09492_/Y _09493_/Y _09572_/B1 VPWR VGND sg13cmos5l_a21oi_1
XFILLER_23_200 VPWR VGND sg13cmos5l_decap_8
XFILLER_23_222 VPWR VGND sg13cmos5l_fill_1
X_08445_ _11307_/D _08510_/A1 _08494_/B _08444_/Y VPWR VGND sg13cmos5l_o21ai_1
XFILLER_12_907 VPWR VGND sg13cmos5l_decap_4
XFILLER_24_756 VPWR VGND sg13cmos5l_decap_8
X_08376_ _08376_/Y _08376_/A _08376_/B _08376_/C VPWR VGND sg13cmos5l_nor3_1
XFILLER_51_597 VPWR VGND sg13cmos5l_fill_1
XFILLER_51_575 VPWR VGND sg13cmos5l_decap_4
XFILLER_23_36 VPWR VGND sg13cmos5l_decap_4
X_07327_ _07327_/Y _07325_/Y _08700_/A _07340_/A2 VPWR VGND sg13cmos5l_a21oi_1
XFILLER_99_18 VPWR VGND sg13cmos5l_decap_8
X_07258_ _07258_/Y _07347_/B _07256_/Y _07257_/Y VPWR VGND sg13cmos5l_a21oi_1
X_10997__985 _10997_/RESET_B VPWR VGND sg13cmos5l_tiehi
X_07189_ _07189_/X _11710_/Q _07190_/C VPWR VGND sg13cmos5l_and2_1
X_06209_ _06211_/B _06209_/A _09885_/A VPWR VGND sg13cmos5l_nand2_1
XFILLER_2_104 VPWR VGND sg13cmos5l_decap_8
XFILLER_105_544 VPWR VGND sg13cmos5l_decap_8
XFILLER_79_907 VPWR VGND sg13cmos5l_fill_2
XFILLER_2_126 VPWR VGND sg13cmos5l_decap_4
Xfanout430 _09982_/B1 _10015_/B1 VPWR VGND sg13cmos5l_buf_1
X_11586__1443 _11586_/RESET_B VPWR VGND sg13cmos5l_tiehi
XFILLER_48_11 VPWR VGND sg13cmos5l_fill_1
Xfanout441 _09606_/B _09419_/B VPWR VGND sg13cmos5l_buf_1
XFILLER_24_1002 VPWR VGND sg13cmos5l_fill_1
Xfanout474 _09894_/B fanout481/X VPWR VGND sg13cmos5l_buf_1
Xfanout452 _09440_/B _09551_/S0 VPWR VGND sg13cmos5l_buf_1
Xfanout463 _09417_/B fanout482/X VPWR VGND sg13cmos5l_buf_1
XFILLER_87_984 VPWR VGND sg13cmos5l_decap_8
XFILLER_74_634 VPWR VGND sg13cmos5l_fill_2
Xfanout485 _06668_/A1 _06401_/X VPWR VGND sg13cmos5l_buf_1
XFILLER_59_697 VPWR VGND sg13cmos5l_fill_1
XFILLER_58_163 VPWR VGND sg13cmos5l_decap_8
XFILLER_46_303 VPWR VGND sg13cmos5l_decap_4
XFILLER_19_517 VPWR VGND sg13cmos5l_decap_4
XFILLER_19_539 VPWR VGND sg13cmos5l_fill_1
Xfanout496 _09721_/B _09747_/B VPWR VGND sg13cmos5l_buf_1
XFILLER_74_645 VPWR VGND sg13cmos5l_decap_8
XFILLER_58_196 VPWR VGND sg13cmos5l_fill_2
XFILLER_46_347 VPWR VGND sg13cmos5l_fill_1
XFILLER_27_572 VPWR VGND sg13cmos5l_decap_4
XFILLER_14_211 VPWR VGND sg13cmos5l_fill_1
X_11723_ _11723_/Q clkload21/A _11723_/D _11723_/RESET_B VPWR VGND sg13cmos5l_dfrbpq_1
XFILLER_15_767 VPWR VGND sg13cmos5l_decap_8
XFILLER_80_20 VPWR VGND sg13cmos5l_decap_8
XFILLER_70_1000 VPWR VGND sg13cmos5l_decap_4
X_11654_ _11654_/Q clkload11/A _11654_/D _11654_/RESET_B VPWR VGND sg13cmos5l_dfrbpq_1
XFILLER_30_715 VPWR VGND sg13cmos5l_decap_8
XFILLER_30_737 VPWR VGND sg13cmos5l_decap_8
Xfanout92 _10055_/A _09314_/A VPWR VGND sg13cmos5l_buf_1
X_10605_ _10632_/A _11418_/Q _10605_/B VPWR VGND sg13cmos5l_xnor2_1
Xfanout70 _10525_/A _10583_/B VPWR VGND sg13cmos5l_buf_1
Xfanout81 fanout81/X _07565_/Y VPWR VGND sg13cmos5l_buf_1
X_11585_ _11585_/Q _11594_/CLK _11585_/D _11585_/RESET_B VPWR VGND sg13cmos5l_dfrbpq_1
XFILLER_80_86 VPWR VGND sg13cmos5l_fill_1
XFILLER_31_1028 VPWR VGND sg13cmos5l_fill_1
X_10536_ _10537_/D _10536_/A _10849_/Q _10536_/C VPWR VGND sg13cmos5l_nand3_1
X_10467_ _10467_/Y hold2878/X _10495_/A2 _10465_/Y _10466_/Y _10508_/B1 VPWR VGND
+ sg13cmos5l_a221oi_1
X_10398_ _10419_/A _11405_/Q _10842_/Q VPWR VGND sg13cmos5l_nand2_1
XFILLER_78_973 VPWR VGND sg13cmos5l_fill_1
XFILLER_78_962 VPWR VGND sg13cmos5l_decap_8
X_11019_ _11019_/Q clkload32/A _11019_/D _11019_/RESET_B VPWR VGND sg13cmos5l_dfrbpq_1
XFILLER_93_910 VPWR VGND sg13cmos5l_fill_1
XFILLER_77_483 VPWR VGND sg13cmos5l_fill_1
XFILLER_49_163 VPWR VGND sg13cmos5l_fill_2
XFILLER_93_998 VPWR VGND sg13cmos5l_fill_1
XFILLER_65_689 VPWR VGND sg13cmos5l_fill_2
XFILLER_18_561 VPWR VGND sg13cmos5l_decap_8
XFILLER_80_659 VPWR VGND sg13cmos5l_decap_8
XFILLER_52_328 VPWR VGND sg13cmos5l_decap_8
XFILLER_46_881 VPWR VGND sg13cmos5l_fill_1
XFILLER_45_380 VPWR VGND sg13cmos5l_fill_2
X_06560_ _06560_/Y _06560_/A _06560_/B VPWR VGND sg13cmos5l_nand2_1
XFILLER_33_531 VPWR VGND sg13cmos5l_fill_1
X_06491_ _06491_/X _10989_/Q _10957_/Q _09544_/S VPWR VGND sg13cmos5l_mux2_1
XFILLER_33_542 VPWR VGND sg13cmos5l_decap_8
XFILLER_33_553 VPWR VGND sg13cmos5l_fill_1
X_08230_ _08230_/Y _08230_/A _08236_/B VPWR VGND sg13cmos5l_nand2_1
XFILLER_61_884 VPWR VGND sg13cmos5l_decap_8
XFILLER_60_383 VPWR VGND sg13cmos5l_decap_8
XFILLER_60_361 VPWR VGND sg13cmos5l_decap_8
X_11656__1308 _11656_/RESET_B VPWR VGND sg13cmos5l_tiehi
XFILLER_60_394 VPWR VGND sg13cmos5l_fill_1
XFILLER_20_236 VPWR VGND sg13cmos5l_decap_8
X_08161_ _08161_/Y _08161_/A _08171_/B VPWR VGND sg13cmos5l_nor2_1
X_08092_ _08092_/Y _08092_/A _08106_/B VPWR VGND sg13cmos5l_nand2_1
X_11749__910 _11749_/RESET_B VPWR VGND sg13cmos5l_tiehi
X_07112_ _11721_/D _05885_/Y _07130_/A2 _07111_/Y VPWR VGND sg13cmos5l_a21oi_1
XFILLER_106_308 VPWR VGND sg13cmos5l_decap_8
Xclkload51 clkload51/Y clkload51/A VPWR VGND sg13cmos5l_inv_2
X_07043_ _07043_/Y _11512_/Q _10165_/B VPWR VGND sg13cmos5l_nand2_1
Xclkload40 clkload40/Y clkload40/A VPWR VGND sg13cmos5l_inv_1
XFILLER_88_715 VPWR VGND sg13cmos5l_fill_2
XFILLER_0_608 VPWR VGND sg13cmos5l_decap_8
Xhold2802 hold2802/X _11724_/Q VPWR VGND sg13cmos5l_dlygate4sd3_1
X_08994_ _08996_/B _08983_/B _09019_/B _09019_/A VPWR VGND sg13cmos5l_a21oi_1
Xhold2813 _09645_/A _11407_/Q VPWR VGND sg13cmos5l_dlygate4sd3_1
X_11053__872 _11053_/RESET_B VPWR VGND sg13cmos5l_tiehi
Xhold2846 _10470_/A _11732_/Q VPWR VGND sg13cmos5l_dlygate4sd3_1
Xhold2824 _11523_/D _10208_/Y VPWR VGND sg13cmos5l_dlygate4sd3_1
Xhold2835 _09319_/A _11461_/Q VPWR VGND sg13cmos5l_dlygate4sd3_1
X_07945_ _11062_/D _08075_/A1 _07966_/B _07944_/Y VPWR VGND sg13cmos5l_o21ai_1
Xhold2857 _11500_/D _10097_/X VPWR VGND sg13cmos5l_dlygate4sd3_1
Xhold2879 _10117_/B _10849_/Q VPWR VGND sg13cmos5l_dlygate4sd3_1
X_10814__951 _10814_/RESET_B VPWR VGND sg13cmos5l_tiehi
Xhold2868 _09611_/A _11469_/Q VPWR VGND sg13cmos5l_dlygate4sd3_1
XFILLER_84_954 VPWR VGND sg13cmos5l_decap_8
XFILLER_56_656 VPWR VGND sg13cmos5l_decap_8
XFILLER_44_807 VPWR VGND sg13cmos5l_fill_1
X_07876_ _11028_/D _08071_/A1 _07875_/B _07875_/Y VPWR VGND sg13cmos5l_a21oi_1
XFILLER_18_58 VPWR VGND sg13cmos5l_decap_4
X_09615_ _09615_/Y hold2769/X _09725_/B _09614_/Y _09775_/A VPWR VGND sg13cmos5l_a22oi_1
X_06827_ _06827_/Y _06818_/Y _06825_/Y _06826_/Y VPWR VGND sg13cmos5l_o21ai_1
XFILLER_71_615 VPWR VGND sg13cmos5l_decap_8
X_06758_ _06758_/Y _06211_/B _06758_/A2 _06758_/B1 _06756_/A _06757_/Y VPWR VGND sg13cmos5l_a221oi_1
X_09546_ _09546_/Y _10902_/Q _09544_/S _09842_/B1 VPWR VGND sg13cmos5l_a21oi_1
XFILLER_52_840 VPWR VGND sg13cmos5l_fill_1
X_09477_ _09477_/Y _09395_/A _09472_/X _09476_/Y VPWR VGND sg13cmos5l_o21ai_1
X_10952__1030 _10952_/RESET_B VPWR VGND sg13cmos5l_tiehi
X_08428_ _11299_/D fanout61/X _08439_/B _08427_/Y VPWR VGND sg13cmos5l_a21oi_1
XFILLER_51_372 VPWR VGND sg13cmos5l_decap_8
X_06689_ _06690_/B _06679_/A _06686_/X _06687_/Y _06688_/Y VPWR VGND sg13cmos5l_a22oi_1
XFILLER_24_597 VPWR VGND sg13cmos5l_decap_8
X_11060__865 _11060_/RESET_B VPWR VGND sg13cmos5l_tiehi
Xclkload1 clkload1/X clkload1/A VPWR VGND sg13cmos5l_buf_8
XFILLER_11_258 VPWR VGND sg13cmos5l_decap_8
X_08359_ _11265_/D fanout68/X _08358_/B _08358_/Y VPWR VGND sg13cmos5l_o21ai_1
X_11370_ _11370_/Q clkload28/A _11370_/D _11370_/RESET_B VPWR VGND sg13cmos5l_dfrbpq_1
X_10321_ _10321_/Y _11560_/Q _10707_/C _10240_/B VPWR VGND sg13cmos5l_o21ai_1
X_11241__1660 _11241_/RESET_B VPWR VGND sg13cmos5l_tiehi
XFILLER_106_875 VPWR VGND sg13cmos5l_decap_8
XFILLER_105_363 VPWR VGND sg13cmos5l_decap_8
X_10252_ _10261_/A _10270_/A _10252_/B _10252_/C VPWR VGND sg13cmos5l_nand3_1
XFILLER_3_468 VPWR VGND sg13cmos5l_decap_8
XFILLER_79_748 VPWR VGND sg13cmos5l_decap_4
X_10183_ _10183_/Y hold2689/X _07067_/X _10166_/X hold2799/X VPWR VGND sg13cmos5l_a22oi_1
XFILLER_78_258 VPWR VGND sg13cmos5l_fill_1
XFILLER_59_98 VPWR VGND sg13cmos5l_fill_2
Xfanout271 fanout271/X _07440_/Y VPWR VGND sg13cmos5l_buf_1
Xfanout282 _08340_/B _08348_/B VPWR VGND sg13cmos5l_buf_1
Xfanout260 _08453_/A1 _07474_/Y VPWR VGND sg13cmos5l_buf_1
XFILLER_86_280 VPWR VGND sg13cmos5l_decap_4
XFILLER_75_64 VPWR VGND sg13cmos5l_fill_1
XFILLER_47_634 VPWR VGND sg13cmos5l_decap_8
XFILLER_19_336 VPWR VGND sg13cmos5l_decap_8
XFILLER_19_347 VPWR VGND sg13cmos5l_fill_1
Xfanout293 _08096_/B _08108_/B VPWR VGND sg13cmos5l_buf_1
XFILLER_75_97 VPWR VGND sg13cmos5l_fill_1
XFILLER_47_689 VPWR VGND sg13cmos5l_fill_2
XFILLER_47_678 VPWR VGND sg13cmos5l_decap_8
XFILLER_35_807 VPWR VGND sg13cmos5l_decap_8
XFILLER_61_158 VPWR VGND sg13cmos5l_fill_2
XFILLER_61_147 VPWR VGND sg13cmos5l_decap_8
XFILLER_43_851 VPWR VGND sg13cmos5l_fill_1
XFILLER_91_63 VPWR VGND sg13cmos5l_fill_1
XFILLER_70_681 VPWR VGND sg13cmos5l_fill_1
X_11706_ _11706_/Q clkload31/A _11706_/D _11706_/RESET_B VPWR VGND sg13cmos5l_dfrbpq_1
XFILLER_42_394 VPWR VGND sg13cmos5l_decap_8
X_11637_ _11637_/Q clkload28/A _11637_/D _11637_/RESET_B VPWR VGND sg13cmos5l_dfrbpq_1
XFILLER_30_567 VPWR VGND sg13cmos5l_fill_2
X_11568_ _11568_/Q clkload26/A _11568_/D _11568_/RESET_B VPWR VGND sg13cmos5l_dfrbpq_1
X_10519_ _10535_/B _10568_/A _10499_/B _10570_/B VPWR VGND sg13cmos5l_o21ai_1
XFILLER_7_774 VPWR VGND sg13cmos5l_decap_8
XFILLER_7_763 VPWR VGND sg13cmos5l_decap_8
X_11499_ _11499_/Q clkload16/A _11499_/D _11499_/RESET_B VPWR VGND sg13cmos5l_dfrbpq_1
XFILLER_41_4 VPWR VGND sg13cmos5l_decap_8
XFILLER_97_512 VPWR VGND sg13cmos5l_fill_2
Xhold2109 _07873_/A _11027_/Q VPWR VGND sg13cmos5l_dlygate4sd3_1
XFILLER_69_258 VPWR VGND sg13cmos5l_fill_1
X_05991_ _10826_/D _06038_/C _10719_/B VPWR VGND sg13cmos5l_nand2b_1
X_07730_ _07730_/Y _07730_/A _07746_/B VPWR VGND sg13cmos5l_nor2_1
X_11104__1797 _11104_/RESET_B VPWR VGND sg13cmos5l_tiehi
XFILLER_93_740 VPWR VGND sg13cmos5l_fill_2
XFILLER_84_239 VPWR VGND sg13cmos5l_decap_4
XFILLER_78_792 VPWR VGND sg13cmos5l_decap_4
XFILLER_77_291 VPWR VGND sg13cmos5l_fill_2
XFILLER_65_442 VPWR VGND sg13cmos5l_decap_4
XFILLER_38_645 VPWR VGND sg13cmos5l_decap_8
X_11562__1429 _11562_/RESET_B VPWR VGND sg13cmos5l_tiehi
X_07661_ _10924_/D _08512_/A1 _07684_/B _07660_/Y VPWR VGND sg13cmos5l_a21oi_1
X_10987__995 _10987_/RESET_B VPWR VGND sg13cmos5l_tiehi
XFILLER_92_283 VPWR VGND sg13cmos5l_decap_8
XFILLER_80_434 VPWR VGND sg13cmos5l_fill_1
XFILLER_77_1028 VPWR VGND sg13cmos5l_fill_1
XFILLER_65_486 VPWR VGND sg13cmos5l_fill_2
X_07592_ _07592_/X _11414_/Q _07597_/C VPWR VGND sg13cmos5l_xor2_1
X_09400_ _09401_/C _09392_/Y _09393_/X _09399_/Y VPWR VGND sg13cmos5l_o21ai_1
XFILLER_25_339 VPWR VGND sg13cmos5l_decap_8
X_06612_ _06612_/Y _06612_/A _06612_/B VPWR VGND sg13cmos5l_xnor2_1
XFILLER_53_659 VPWR VGND sg13cmos5l_fill_1
X_09331_ _09331_/Y _09345_/A _09325_/Y _09330_/Y VPWR VGND sg13cmos5l_o21ai_1
X_11283__1618 _11283_/RESET_B VPWR VGND sg13cmos5l_tiehi
X_06543_ _06545_/A _06571_/A1 _11669_/Q _11653_/Q _06531_/A VPWR VGND sg13cmos5l_a22oi_1
X_06474_ _06474_/Y _06474_/A _10044_/A VPWR VGND sg13cmos5l_nand2_1
X_09262_ _10005_/A _09262_/A _10858_/Q VPWR VGND sg13cmos5l_xnor2_1
XFILLER_14_1012 VPWR VGND sg13cmos5l_decap_8
X_08213_ _11193_/D fanout98/X _08228_/B _08212_/Y VPWR VGND sg13cmos5l_o21ai_1
XFILLER_21_567 VPWR VGND sg13cmos5l_fill_2
X_09193_ _09193_/Y _09344_/A _09344_/B VPWR VGND sg13cmos5l_nand2_1
X_08144_ _11159_/D _08339_/A1 _08143_/B _08143_/Y VPWR VGND sg13cmos5l_a21oi_1
XFILLER_106_105 VPWR VGND sg13cmos5l_decap_8
X_08075_ _11126_/D _08075_/A1 _08102_/B _08074_/Y VPWR VGND sg13cmos5l_o21ai_1
X_10994__988 _10994_/RESET_B VPWR VGND sg13cmos5l_tiehi
X_07026_ _07026_/Y _07026_/A _07026_/B VPWR VGND sg13cmos5l_nand2_1
XFILLER_102_311 VPWR VGND sg13cmos5l_decap_4
XFILLER_1_939 VPWR VGND sg13cmos5l_decap_8
XFILLER_103_856 VPWR VGND sg13cmos5l_decap_8
XFILLER_76_718 VPWR VGND sg13cmos5l_decap_8
Xhold2610 _07389_/A _10882_/Q VPWR VGND sg13cmos5l_dlygate4sd3_1
Xhold2621 _11647_/D _06957_/X VPWR VGND sg13cmos5l_dlygate4sd3_1
XFILLER_103_889 VPWR VGND sg13cmos5l_decap_4
Xhold2654 _06939_/A _11644_/Q VPWR VGND sg13cmos5l_dlygate4sd3_1
Xhold2632 _10834_/D _07188_/Y VPWR VGND sg13cmos5l_dlygate4sd3_1
Xhold2643 _08607_/B _11374_/Q VPWR VGND sg13cmos5l_dlygate4sd3_1
Xhold2665 _05945_/A _11385_/Q VPWR VGND sg13cmos5l_dlygate4sd3_1
X_08977_ _08977_/Y _09030_/A1 _08973_/A _09013_/B1 VPWR VGND sg13cmos5l_o21ai_1
Xhold1920 _07810_/A _10997_/Q VPWR VGND sg13cmos5l_dlygate4sd3_1
Xhold1942 _07968_/A _11074_/Q VPWR VGND sg13cmos5l_dlygate4sd3_1
XFILLER_75_228 VPWR VGND sg13cmos5l_fill_2
Xhold2698 _06054_/B _06053_/Y VPWR VGND sg13cmos5l_dlygate4sd3_1
Xhold2676 _11553_/D _10705_/Y VPWR VGND sg13cmos5l_dlygate4sd3_1
Xhold2687 hold2687/X _11699_/Q VPWR VGND sg13cmos5l_dlygate4sd3_1
Xhold1953 _08216_/A _11195_/Q VPWR VGND sg13cmos5l_dlygate4sd3_1
X_07928_ _07928_/Y _07928_/A _07940_/B VPWR VGND sg13cmos5l_nand2_1
Xhold1931 _08334_/A _11253_/Q VPWR VGND sg13cmos5l_dlygate4sd3_1
XFILLER_28_111 VPWR VGND sg13cmos5l_decap_4
Xhold1975 _08222_/A _11198_/Q VPWR VGND sg13cmos5l_dlygate4sd3_1
Xhold1964 _07974_/A _11077_/Q VPWR VGND sg13cmos5l_dlygate4sd3_1
Xhold1986 _08979_/A _11441_/Q VPWR VGND sg13cmos5l_dlygate4sd3_1
Xhold1997 _08462_/A _11316_/Q VPWR VGND sg13cmos5l_dlygate4sd3_1
X_07859_ _07859_/Y _07859_/A _07877_/B VPWR VGND sg13cmos5l_nor2_1
XFILLER_72_946 VPWR VGND sg13cmos5l_fill_2
XFILLER_16_317 VPWR VGND sg13cmos5l_fill_1
X_10870_ _10870_/Q clkload11/A _10870_/D _10870_/RESET_B VPWR VGND sg13cmos5l_dfrbpq_1
XFILLER_71_456 VPWR VGND sg13cmos5l_decap_4
X_09529_ _09529_/Y _11317_/Q _09529_/B VPWR VGND sg13cmos5l_nand2b_1
X_11538__1497 _11538_/RESET_B VPWR VGND sg13cmos5l_tiehi
XFILLER_71_478 VPWR VGND sg13cmos5l_fill_1
X_11259__1642 _11259_/RESET_B VPWR VGND sg13cmos5l_tiehi
XFILLER_101_84 VPWR VGND sg13cmos5l_decap_8
XFILLER_51_191 VPWR VGND sg13cmos5l_decap_8
X_11530__1123 _11530_/RESET_B VPWR VGND sg13cmos5l_tiehi
X_11422_ _11422_/Q clkload52/A _11422_/D _11422_/RESET_B VPWR VGND sg13cmos5l_dfrbpq_1
XFILLER_6_28 VPWR VGND sg13cmos5l_decap_8
X_11353_ _11353_/Q clkload40/A _11353_/D _11353_/RESET_B VPWR VGND sg13cmos5l_dfrbpq_1
X_10304_ _10504_/A _10491_/A _10302_/Y _10303_/A VPWR VGND sg13cmos5l_a21o_1
X_11284_ _11284_/Q clkload16/A _11284_/D _11284_/RESET_B VPWR VGND sg13cmos5l_dfrbpq_1
XFILLER_106_672 VPWR VGND sg13cmos5l_decap_8
X_10235_ _10235_/Y _11747_/Q _10235_/B VPWR VGND sg13cmos5l_nand2b_1
XFILLER_3_287 VPWR VGND sg13cmos5l_decap_8
XFILLER_3_265 VPWR VGND sg13cmos5l_decap_8
XFILLER_105_182 VPWR VGND sg13cmos5l_decap_8
XFILLER_79_567 VPWR VGND sg13cmos5l_fill_1
XFILLER_79_556 VPWR VGND sg13cmos5l_decap_8
XFILLER_10_92 VPWR VGND sg13cmos5l_fill_1
XFILLER_0_950 VPWR VGND sg13cmos5l_decap_8
XFILLER_86_74 VPWR VGND sg13cmos5l_fill_2
X_10166_ _10166_/X _10166_/A _10166_/B VPWR VGND sg13cmos5l_and2_1
XFILLER_86_96 VPWR VGND sg13cmos5l_fill_2
XFILLER_13_8 VPWR VGND sg13cmos5l_decap_4
X_10097_ _10097_/X hold2856/X _10115_/A2 _10096_/Y VPWR VGND sg13cmos5l_a21o_1
XFILLER_81_209 VPWR VGND sg13cmos5l_fill_1
XFILLER_19_144 VPWR VGND sg13cmos5l_decap_4
XFILLER_90_732 VPWR VGND sg13cmos5l_decap_4
XFILLER_63_946 VPWR VGND sg13cmos5l_decap_4
XFILLER_47_475 VPWR VGND sg13cmos5l_fill_1
XFILLER_34_158 VPWR VGND sg13cmos5l_decap_8
X_10999_ _10999_/Q _11347_/CLK _10999_/D _10999_/RESET_B VPWR VGND sg13cmos5l_dfrbpq_1
X_11043__882 _11043_/RESET_B VPWR VGND sg13cmos5l_tiehi
XFILLER_30_320 VPWR VGND sg13cmos5l_decap_4
XFILLER_30_364 VPWR VGND sg13cmos5l_decap_4
XFILLER_31_887 VPWR VGND sg13cmos5l_fill_1
X_06190_ _06190_/Y _06351_/B VPWR VGND sg13cmos5l_inv_1
XFILLER_103_119 VPWR VGND sg13cmos5l_decap_8
X_09880_ _09880_/Y _09994_/A1 _09879_/Y _09875_/Y VPWR VGND sg13cmos5l_a21oi_1
X_11588__1435 _11588_/RESET_B VPWR VGND sg13cmos5l_tiehi
X_08900_ _08900_/Y _08930_/A _08930_/D VPWR VGND sg13cmos5l_xnor2_1
X_08831_ _08831_/Y _08832_/A1 _08827_/B _08831_/B1 VPWR VGND sg13cmos5l_o21ai_1
XFILLER_32_0 VPWR VGND sg13cmos5l_fill_2
X_11050__875 _11050_/RESET_B VPWR VGND sg13cmos5l_tiehi
X_11337__1564 _11337_/RESET_B VPWR VGND sg13cmos5l_tiehi
XFILLER_39_910 VPWR VGND sg13cmos5l_fill_1
X_08762_ _08763_/B _08762_/A _08762_/B VPWR VGND sg13cmos5l_nand2_1
X_05974_ _05974_/Y _09234_/B VPWR VGND sg13cmos5l_inv_1
XFILLER_39_954 VPWR VGND sg13cmos5l_decap_8
X_07713_ _10950_/D fanout56/X _07712_/B _07712_/Y VPWR VGND sg13cmos5l_a21oi_1
X_08693_ _11404_/D _08693_/A VPWR VGND sg13cmos5l_inv_1
XFILLER_39_965 VPWR VGND sg13cmos5l_fill_1
XFILLER_38_453 VPWR VGND sg13cmos5l_decap_8
X_07644_ _07644_/Y _05863_/Y _07636_/Y _07638_/A VPWR VGND sg13cmos5l_a21oi_1
XFILLER_54_968 VPWR VGND sg13cmos5l_fill_1
XFILLER_81_798 VPWR VGND sg13cmos5l_decap_4
X_07575_ _07584_/B _11412_/Q _10513_/A _07575_/C VPWR VGND sg13cmos5l_nand3_1
XFILLER_15_37 VPWR VGND sg13cmos5l_fill_1
X_06526_ _06526_/Y hold2796/X _10693_/C _06525_/Y VPWR VGND sg13cmos5l_o21ai_1
X_09314_ _09314_/Y _09314_/A _09314_/B _09314_/C VPWR VGND sg13cmos5l_nor3_1
XFILLER_40_139 VPWR VGND sg13cmos5l_fill_2
XFILLER_22_854 VPWR VGND sg13cmos5l_fill_2
X_09245_ _09862_/B _09649_/A _09237_/B _09244_/X VPWR VGND sg13cmos5l_o21ai_1
XFILLER_21_331 VPWR VGND sg13cmos5l_fill_1
X_06457_ _06457_/Y _10956_/Q _06468_/B _09688_/S1 VPWR VGND sg13cmos5l_a21oi_1
XFILLER_31_25 VPWR VGND sg13cmos5l_fill_2
X_06388_ _06388_/Y _11513_/Q _10614_/A1 _06772_/S VPWR VGND sg13cmos5l_a21oi_1
X_09176_ _09176_/Y _09405_/A _10834_/Q VPWR VGND sg13cmos5l_nand2_1
X_08127_ _08127_/Y _08127_/A _08145_/B VPWR VGND sg13cmos5l_nor2_1
Xoutput25 uio_out[14] _06134_/C VPWR VGND sg13cmos5l_buf_1
X_08058_ _08058_/Y _08058_/A _08074_/B VPWR VGND sg13cmos5l_nand2_1
XFILLER_0_202 VPWR VGND sg13cmos5l_decap_8
X_07009_ _07009_/Y _10426_/B1 _07036_/B _07008_/Y VPWR VGND sg13cmos5l_a21oi_1
Xoutput47 uo_out[8] _06554_/Y VPWR VGND sg13cmos5l_buf_1
Xoutput36 uo_out[12] _06566_/Y VPWR VGND sg13cmos5l_buf_1
X_10020_ _10020_/Y _11335_/Q _10020_/B VPWR VGND sg13cmos5l_nand2b_1
XFILLER_1_758 VPWR VGND sg13cmos5l_decap_4
Xhold2440 _07766_/A _10976_/Q VPWR VGND sg13cmos5l_dlygate4sd3_1
XFILLER_88_364 VPWR VGND sg13cmos5l_fill_1
XFILLER_102_196 VPWR VGND sg13cmos5l_decap_8
Xhold2462 _11606_/D _06819_/Y VPWR VGND sg13cmos5l_dlygate4sd3_1
Xhold2473 _11424_/D _08777_/X VPWR VGND sg13cmos5l_dlygate4sd3_1
Xhold2451 _08801_/A _11427_/Q VPWR VGND sg13cmos5l_dlygate4sd3_1
Xhold2484 _11624_/D _06876_/X VPWR VGND sg13cmos5l_dlygate4sd3_1
XFILLER_91_518 VPWR VGND sg13cmos5l_fill_1
Xhold2495 _11580_/D _10764_/X VPWR VGND sg13cmos5l_dlygate4sd3_1
X_11651__1313 _11651_/RESET_B VPWR VGND sg13cmos5l_tiehi
X_10922_ _10922_/Q _11622_/CLK _10922_/D _10922_/RESET_B VPWR VGND sg13cmos5l_dfrbpq_1
XFILLER_57_784 VPWR VGND sg13cmos5l_decap_4
XFILLER_45_946 VPWR VGND sg13cmos5l_fill_2
XFILLER_16_114 VPWR VGND sg13cmos5l_fill_1
XFILLER_17_637 VPWR VGND sg13cmos5l_fill_2
XFILLER_72_765 VPWR VGND sg13cmos5l_fill_2
XFILLER_44_434 VPWR VGND sg13cmos5l_decap_4
XFILLER_16_136 VPWR VGND sg13cmos5l_fill_1
XFILLER_17_648 VPWR VGND sg13cmos5l_decap_4
X_10853_ _10853_/Q _11715_/CLK _10853_/D _10853_/RESET_B VPWR VGND sg13cmos5l_dfrbpq_1
XFILLER_13_810 VPWR VGND sg13cmos5l_decap_4
XFILLER_16_169 VPWR VGND sg13cmos5l_fill_2
XFILLER_32_607 VPWR VGND sg13cmos5l_decap_8
X_10784_ _10784_/Y _06875_/A _10783_/Y _10782_/Y VPWR VGND sg13cmos5l_o21ai_1
XFILLER_71_297 VPWR VGND sg13cmos5l_fill_2
XFILLER_72_98 VPWR VGND sg13cmos5l_fill_1
XFILLER_8_335 VPWR VGND sg13cmos5l_fill_2
XFILLER_9_847 VPWR VGND sg13cmos5l_fill_2
X_11405_ _11405_/Q _11535_/CLK _11405_/D _11405_/RESET_B VPWR VGND sg13cmos5l_dfrbpq_1
X_11336_ _11336_/Q clkload56/A _11336_/D _11336_/RESET_B VPWR VGND sg13cmos5l_dfrbpq_1
XFILLER_67_1027 VPWR VGND sg13cmos5l_fill_2
XFILLER_4_563 VPWR VGND sg13cmos5l_fill_2
X_11267_ _11267_/Q clkload45/A _11267_/D _11267_/RESET_B VPWR VGND sg13cmos5l_dfrbpq_1
XFILLER_79_320 VPWR VGND sg13cmos5l_fill_1
XFILLER_4_596 VPWR VGND sg13cmos5l_fill_1
XFILLER_97_84 VPWR VGND sg13cmos5l_decap_8
X_11604__1379 _11604_/RESET_B VPWR VGND sg13cmos5l_tiehi
X_11198_ _11198_/Q clkload52/A _11198_/D _11198_/RESET_B VPWR VGND sg13cmos5l_dfrbpq_1
XFILLER_79_364 VPWR VGND sg13cmos5l_decap_8
X_10218_ _11524_/D _10226_/C1 _10215_/Y _10216_/Y _10217_/Y _08648_/A VPWR VGND sg13cmos5l_a221oi_1
XFILLER_94_334 VPWR VGND sg13cmos5l_decap_4
X_10149_ _10149_/Y _11516_/Q _10149_/B VPWR VGND sg13cmos5l_nand2_1
XFILLER_67_526 VPWR VGND sg13cmos5l_fill_2
XFILLER_94_345 VPWR VGND sg13cmos5l_fill_1
XFILLER_63_710 VPWR VGND sg13cmos5l_fill_2
XFILLER_48_795 VPWR VGND sg13cmos5l_fill_1
XFILLER_35_412 VPWR VGND sg13cmos5l_decap_4
XFILLER_62_242 VPWR VGND sg13cmos5l_fill_1
XFILLER_62_220 VPWR VGND sg13cmos5l_decap_8
XFILLER_36_957 VPWR VGND sg13cmos5l_fill_2
X_10984__998 _10984_/RESET_B VPWR VGND sg13cmos5l_tiehi
XFILLER_90_595 VPWR VGND sg13cmos5l_fill_2
X_07360_ _10877_/D _07359_/B _07358_/Y _07359_/Y VPWR VGND sg13cmos5l_a21oi_1
X_06311_ _06311_/Y _10423_/B _10295_/A VPWR VGND sg13cmos5l_nand2_1
XFILLER_31_640 VPWR VGND sg13cmos5l_fill_2
XFILLER_31_662 VPWR VGND sg13cmos5l_decap_8
X_09030_ _09030_/Y _09030_/A1 _09036_/B _09064_/B1 VPWR VGND sg13cmos5l_o21ai_1
X_07291_ _07291_/Y _07289_/Y _07290_/Y _07304_/A2 VPWR VGND sg13cmos5l_a21oi_1
X_06242_ _06443_/A _06242_/A VPWR VGND sg13cmos5l_inv_1
XFILLER_8_880 VPWR VGND sg13cmos5l_fill_2
X_06173_ _06642_/A _06173_/A _06173_/B VPWR VGND sg13cmos5l_nor2_1
XFILLER_105_918 VPWR VGND sg13cmos5l_decap_8
X_09932_ _09933_/B _11268_/Q _11236_/Q _11204_/Q _11172_/Q _09934_/B _09932_/S1 VPWR
+ VGND sg13cmos5l_mux4_1
XFILLER_98_640 VPWR VGND sg13cmos5l_fill_2
Xfanout804 _09109_/A _08645_/A1 VPWR VGND sg13cmos5l_buf_1
Xfanout815 _06953_/A _08648_/A VPWR VGND sg13cmos5l_buf_1
XFILLER_85_301 VPWR VGND sg13cmos5l_decap_8
Xfanout826 _06091_/A _10687_/A VPWR VGND sg13cmos5l_buf_1
X_09863_ _09864_/C _09862_/A _09862_/B _09862_/C VPWR VGND sg13cmos5l_a21oi_1
X_09794_ _09795_/C _09790_/Y _09791_/Y _09792_/Y _09793_/Y _10043_/C1 VPWR VGND sg13cmos5l_a221oi_1
XFILLER_58_526 VPWR VGND sg13cmos5l_decap_4
X_08814_ _08814_/Y _08816_/A VPWR VGND sg13cmos5l_inv_1
X_08745_ _08746_/B _08750_/A _08745_/B VPWR VGND sg13cmos5l_nand2_1
XFILLER_39_762 VPWR VGND sg13cmos5l_decap_8
XFILLER_66_570 VPWR VGND sg13cmos5l_decap_8
X_05957_ _05957_/Y _10833_/Q VPWR VGND sg13cmos5l_inv_1
XFILLER_38_261 VPWR VGND sg13cmos5l_fill_1
X_05888_ _05888_/Y input10/X VPWR VGND sg13cmos5l_inv_1
X_08676_ _08853_/A _08849_/B VPWR VGND sg13cmos5l_inv_1
XFILLER_38_294 VPWR VGND sg13cmos5l_decap_8
X_07627_ _07627_/Y _07627_/A _07629_/B VPWR VGND sg13cmos5l_nor2_1
XFILLER_53_242 VPWR VGND sg13cmos5l_decap_4
XFILLER_13_106 VPWR VGND sg13cmos5l_decap_8
XFILLER_26_489 VPWR VGND sg13cmos5l_decap_8
X_07558_ _07558_/Y _07577_/A _07558_/B VPWR VGND sg13cmos5l_nor2_1
XFILLER_13_139 VPWR VGND sg13cmos5l_fill_2
X_06509_ _11371_/D _06509_/A _06509_/B VPWR VGND sg13cmos5l_nand2_1
XFILLER_50_982 VPWR VGND sg13cmos5l_fill_1
X_07489_ _10897_/D _07566_/B _08522_/A1 _07488_/Y VPWR VGND sg13cmos5l_a21oi_1
XFILLER_21_172 VPWR VGND sg13cmos5l_fill_1
X_09228_ _09649_/A _09215_/B _09223_/Y _09227_/Y VPWR VGND sg13cmos5l_a21oi_1
X_09159_ _09159_/Y _11479_/Q _10852_/Q VPWR VGND sg13cmos5l_nor2_1
X_11121_ _11121_/Q _11265_/CLK _11121_/D _11121_/RESET_B VPWR VGND sg13cmos5l_dfrbpq_1
XFILLER_89_640 VPWR VGND sg13cmos5l_decap_8
XFILLER_67_32 VPWR VGND sg13cmos5l_fill_2
X_11052_ _11052_/Q _11352_/CLK _11052_/D _11052_/RESET_B VPWR VGND sg13cmos5l_dfrbpq_1
XFILLER_77_857 VPWR VGND sg13cmos5l_decap_4
X_10003_ _11484_/D _09882_/A _10055_/A _09978_/Y _10002_/Y VPWR VGND sg13cmos5l_a22oi_1
X_11033__892 _11033_/RESET_B VPWR VGND sg13cmos5l_tiehi
XFILLER_64_507 VPWR VGND sg13cmos5l_decap_8
XFILLER_49_559 VPWR VGND sg13cmos5l_decap_4
Xhold2281 _09004_/A _11443_/Q VPWR VGND sg13cmos5l_dlygate4sd3_1
Xhold2270 hold2270/X _07311_/Y VPWR VGND sg13cmos5l_dlygate4sd3_1
XFILLER_92_838 VPWR VGND sg13cmos5l_fill_2
XFILLER_76_378 VPWR VGND sg13cmos5l_decap_8
XFILLER_17_401 VPWR VGND sg13cmos5l_fill_1
Xhold2292 _10862_/D _07270_/Y VPWR VGND sg13cmos5l_dlygate4sd3_1
XFILLER_91_359 VPWR VGND sg13cmos5l_fill_2
XFILLER_72_540 VPWR VGND sg13cmos5l_fill_2
XFILLER_44_231 VPWR VGND sg13cmos5l_decap_8
XFILLER_18_968 VPWR VGND sg13cmos5l_fill_1
XFILLER_33_905 VPWR VGND sg13cmos5l_fill_2
XFILLER_17_456 VPWR VGND sg13cmos5l_decap_4
X_10905_ _10905_/Q clkload41/A _10905_/D _10905_/RESET_B VPWR VGND sg13cmos5l_dfrbpq_1
X_10836_ _10836_/Q _11713_/CLK _10836_/D _10836_/RESET_B VPWR VGND sg13cmos5l_dfrbpq_1
XFILLER_26_990 VPWR VGND sg13cmos5l_decap_8
XFILLER_60_768 VPWR VGND sg13cmos5l_fill_1
X_10767_ _10767_/X hold2513/X _10763_/S _07197_/X VPWR VGND sg13cmos5l_a21o_1
XFILLER_80_8 VPWR VGND sg13cmos5l_fill_2
XFILLER_9_622 VPWR VGND sg13cmos5l_decap_8
XFILLER_12_161 VPWR VGND sg13cmos5l_decap_4
X_11040__885 _11040_/RESET_B VPWR VGND sg13cmos5l_tiehi
X_10698_ _10698_/Y _10698_/A _10704_/C VPWR VGND sg13cmos5l_nor2_1
XFILLER_99_437 VPWR VGND sg13cmos5l_fill_1
XFILLER_4_382 VPWR VGND sg13cmos5l_decap_8
X_11319_ _11319_/Q clkload15/A _11319_/D _11319_/RESET_B VPWR VGND sg13cmos5l_dfrbpq_1
XFILLER_80_1013 VPWR VGND sg13cmos5l_decap_8
XFILLER_68_813 VPWR VGND sg13cmos5l_fill_1
X_06860_ _11620_/D _06840_/A _06851_/Y _06859_/Y VPWR VGND sg13cmos5l_o21ai_1
XFILLER_79_183 VPWR VGND sg13cmos5l_fill_1
XFILLER_79_161 VPWR VGND sg13cmos5l_decap_4
XFILLER_68_835 VPWR VGND sg13cmos5l_decap_8
X_06791_ _11597_/D _06875_/A _06790_/Y _06786_/Y VPWR VGND sg13cmos5l_o21ai_1
XFILLER_83_849 VPWR VGND sg13cmos5l_decap_8
XFILLER_36_743 VPWR VGND sg13cmos5l_decap_8
X_08530_ _11349_/D _08530_/A1 _08529_/B _08529_/Y VPWR VGND sg13cmos5l_a21oi_1
XFILLER_36_798 VPWR VGND sg13cmos5l_decap_8
X_08461_ _11315_/D _08526_/A1 _08468_/B _08460_/Y VPWR VGND sg13cmos5l_o21ai_1
X_07412_ _07412_/Y _09264_/A _07430_/A2 _07411_/Y VPWR VGND sg13cmos5l_a21oi_1
X_08392_ _11281_/D _08457_/A1 _08401_/B _08391_/Y VPWR VGND sg13cmos5l_a21oi_1
X_07343_ _07343_/Y _11536_/Q _08721_/A VPWR VGND sg13cmos5l_nand2_1
XFILLER_10_109 VPWR VGND sg13cmos5l_fill_1
X_07274_ _07274_/Y _09405_/A _06956_/B _07273_/Y VPWR VGND sg13cmos5l_a21oi_1
X_09013_ _09013_/Y _09030_/A1 _09036_/A _09013_/B1 VPWR VGND sg13cmos5l_o21ai_1
X_06225_ _10427_/A _10434_/B _09641_/A VPWR VGND sg13cmos5l_nand2_1
XFILLER_104_203 VPWR VGND sg13cmos5l_decap_8
X_06156_ _06363_/A _11500_/Q _09480_/A VPWR VGND sg13cmos5l_and2_1
X_06087_ _06525_/A _06087_/A _09644_/A VPWR VGND sg13cmos5l_nand2_1
XFILLER_99_960 VPWR VGND sg13cmos5l_fill_1
Xfanout612 _09303_/D _09731_/A VPWR VGND sg13cmos5l_buf_1
X_09915_ _09915_/Y _09915_/A _09915_/B _09915_/C _09915_/D VPWR VGND sg13cmos5l_nor4_1
Xfanout623 _07098_/B _07100_/S VPWR VGND sg13cmos5l_buf_1
XFILLER_59_813 VPWR VGND sg13cmos5l_decap_8
Xfanout601 _08856_/B1 _06078_/A VPWR VGND sg13cmos5l_buf_1
Xfanout656 _09298_/A fanout661/X VPWR VGND sg13cmos5l_buf_1
Xfanout634 _10696_/A _05935_/Y VPWR VGND sg13cmos5l_buf_1
XFILLER_59_824 VPWR VGND sg13cmos5l_fill_2
X_09846_ _09846_/Y _09846_/A1 _09845_/X _09633_/A VPWR VGND sg13cmos5l_a21oi_1
Xfanout645 _06571_/A1 _06562_/A1 VPWR VGND sg13cmos5l_buf_1
Xfanout667 _10070_/A _06505_/A VPWR VGND sg13cmos5l_buf_1
XFILLER_100_431 VPWR VGND sg13cmos5l_fill_1
Xfanout678 _10140_/A fanout682/X VPWR VGND sg13cmos5l_buf_1
Xfanout689 _07006_/B _06982_/B1 VPWR VGND sg13cmos5l_buf_1
XFILLER_100_486 VPWR VGND sg13cmos5l_fill_2
X_11386__1512 _11386_/RESET_B VPWR VGND sg13cmos5l_tiehi
X_09777_ _09777_/Y _10307_/A _09747_/B _09722_/A VPWR VGND sg13cmos5l_a21oi_1
X_06989_ _06989_/X hold2511/X _08626_/A1 _06988_/Y VPWR VGND sg13cmos5l_a21o_1
X_08728_ _08729_/A hold2807/X _08739_/A2 _09036_/A _08739_/B2 VPWR VGND sg13cmos5l_a22oi_1
XFILLER_26_231 VPWR VGND sg13cmos5l_decap_8
XFILLER_27_732 VPWR VGND sg13cmos5l_decap_4
X_08659_ _08660_/A _10191_/A _08811_/B _08817_/B _08831_/B1 VPWR VGND sg13cmos5l_a22oi_1
XFILLER_26_242 VPWR VGND sg13cmos5l_fill_1
XFILLER_81_392 VPWR VGND sg13cmos5l_decap_8
XFILLER_42_735 VPWR VGND sg13cmos5l_decap_8
XFILLER_41_212 VPWR VGND sg13cmos5l_decap_4
XFILLER_53_67 VPWR VGND sg13cmos5l_decap_8
XFILLER_41_245 VPWR VGND sg13cmos5l_fill_1
X_11117__1784 _11117_/RESET_B VPWR VGND sg13cmos5l_tiehi
X_11670_ _11670_/Q clkload7/A _11670_/D _11670_/RESET_B VPWR VGND sg13cmos5l_dfrbpq_1
X_10621_ _10623_/B _10621_/A VPWR VGND sg13cmos5l_inv_1
XFILLER_41_289 VPWR VGND sg13cmos5l_fill_1
X_10552_ _10552_/Y _07584_/A _09164_/B _10537_/D VPWR VGND sg13cmos5l_o21ai_1
XFILLER_10_643 VPWR VGND sg13cmos5l_fill_2
X_11296__1605 _11296_/RESET_B VPWR VGND sg13cmos5l_tiehi
X_11766__927 _11766_/RESET_B VPWR VGND sg13cmos5l_tiehi
X_10483_ _10483_/Y _10539_/A _10483_/B VPWR VGND sg13cmos5l_nand2_1
XFILLER_97_908 VPWR VGND sg13cmos5l_decap_8
X_11104_ _11104_/Q clkload57/A _11104_/D _11104_/RESET_B VPWR VGND sg13cmos5l_dfrbpq_1
XFILLER_104_792 VPWR VGND sg13cmos5l_decap_8
XFILLER_78_97 VPWR VGND sg13cmos5l_fill_2
X_11035_ _11035_/Q clkload54/A _11035_/D _11035_/RESET_B VPWR VGND sg13cmos5l_dfrbpq_1
XFILLER_2_897 VPWR VGND sg13cmos5l_fill_1
XFILLER_65_816 VPWR VGND sg13cmos5l_decap_8
XFILLER_94_63 VPWR VGND sg13cmos5l_decap_8
XFILLER_92_602 VPWR VGND sg13cmos5l_decap_8
XFILLER_77_676 VPWR VGND sg13cmos5l_decap_4
XFILLER_76_175 VPWR VGND sg13cmos5l_decap_8
XFILLER_65_849 VPWR VGND sg13cmos5l_decap_8
XFILLER_92_668 VPWR VGND sg13cmos5l_fill_1
XFILLER_91_123 VPWR VGND sg13cmos5l_decap_8
XFILLER_18_732 VPWR VGND sg13cmos5l_fill_2
XFILLER_60_510 VPWR VGND sg13cmos5l_fill_1
XFILLER_33_724 VPWR VGND sg13cmos5l_fill_1
XFILLER_32_234 VPWR VGND sg13cmos5l_decap_4
X_10819_ _10819_/Q clkload47/A _10819_/D _10819_/RESET_B VPWR VGND sg13cmos5l_dfrbpq_1
XFILLER_9_430 VPWR VGND sg13cmos5l_decap_4
XFILLER_9_452 VPWR VGND sg13cmos5l_decap_4
XFILLER_9_485 VPWR VGND sg13cmos5l_fill_2
X_06010_ _06010_/Y _10707_/A _09303_/D _10728_/B VPWR VGND sg13cmos5l_o21ai_1
X_10906__1076 _10906_/RESET_B VPWR VGND sg13cmos5l_tiehi
XFILLER_99_201 VPWR VGND sg13cmos5l_fill_1
XFILLER_99_245 VPWR VGND sg13cmos5l_decap_4
X_07961_ _11070_/D fanout77/X _07976_/B _07960_/Y VPWR VGND sg13cmos5l_o21ai_1
XFILLER_101_217 VPWR VGND sg13cmos5l_decap_4
X_06912_ _06913_/B _11684_/D _11685_/D VPWR VGND sg13cmos5l_nand2_1
X_09700_ _09700_/Y _09807_/A _09700_/B _09700_/C VPWR VGND sg13cmos5l_nor3_1
XFILLER_4_72 VPWR VGND sg13cmos5l_decap_8
XFILLER_67_131 VPWR VGND sg13cmos5l_decap_8
X_07892_ _11036_/D fanout80/X _07901_/B _07891_/Y VPWR VGND sg13cmos5l_a21oi_1
XFILLER_95_484 VPWR VGND sg13cmos5l_fill_2
X_06843_ _06843_/Y _06843_/A _06861_/B VPWR VGND sg13cmos5l_nand2_1
XFILLER_83_602 VPWR VGND sg13cmos5l_decap_4
XFILLER_67_164 VPWR VGND sg13cmos5l_decap_8
X_09631_ _09631_/Y _11033_/Q _09652_/S _09735_/B1 VPWR VGND sg13cmos5l_a21oi_1
XFILLER_95_495 VPWR VGND sg13cmos5l_decap_8
XFILLER_71_808 VPWR VGND sg13cmos5l_decap_8
X_06774_ _06778_/A _10611_/A _06772_/X _06773_/Y VPWR VGND sg13cmos5l_a21o_1
XFILLER_55_348 VPWR VGND sg13cmos5l_decap_8
X_09562_ _09563_/C _09534_/A _09556_/Y _09561_/Y VPWR VGND sg13cmos5l_o21ai_1
X_11374__1527 _11374_/RESET_B VPWR VGND sg13cmos5l_tiehi
X_08513_ _08513_/Y _08513_/A _08533_/B VPWR VGND sg13cmos5l_nor2_1
XFILLER_82_189 VPWR VGND sg13cmos5l_fill_2
XFILLER_36_584 VPWR VGND sg13cmos5l_fill_2
X_09493_ _09493_/Y _10900_/Q _09491_/S _09577_/B1 VPWR VGND sg13cmos5l_a21oi_1
X_08444_ _08444_/Y _08444_/A _08494_/B VPWR VGND sg13cmos5l_nand2_1
XFILLER_23_245 VPWR VGND sg13cmos5l_fill_2
XFILLER_24_768 VPWR VGND sg13cmos5l_decap_8
X_08375_ _11273_/D fanout49/X _08374_/B _08374_/Y VPWR VGND sg13cmos5l_o21ai_1
X_11417__1456 _11417_/RESET_B VPWR VGND sg13cmos5l_tiehi
XFILLER_104_1013 VPWR VGND sg13cmos5l_decap_8
X_07326_ _08700_/A _08924_/A _07326_/B VPWR VGND sg13cmos5l_nand2_1
XFILLER_20_963 VPWR VGND sg13cmos5l_fill_2
XFILLER_20_985 VPWR VGND sg13cmos5l_fill_2
X_11468__1247 _11468_/RESET_B VPWR VGND sg13cmos5l_tiehi
X_07257_ _07257_/Y _07257_/A _07365_/B VPWR VGND sg13cmos5l_nor2_1
XFILLER_20_996 VPWR VGND sg13cmos5l_fill_1
X_07188_ _07188_/Y _07188_/A _07188_/B VPWR VGND sg13cmos5l_nand2_1
X_06208_ _10581_/A _11510_/Q _11479_/Q VPWR VGND sg13cmos5l_nand2_1
XFILLER_105_523 VPWR VGND sg13cmos5l_decap_8
X_06139_ _06140_/D _06139_/A _11576_/Q _11578_/Q VPWR VGND sg13cmos5l_nor3_1
XFILLER_3_7 VPWR VGND sg13cmos5l_decap_8
Xfanout431 _10015_/B1 fanout432/X VPWR VGND sg13cmos5l_buf_1
Xfanout420 _09991_/B1 _09791_/B1 VPWR VGND sg13cmos5l_buf_1
XFILLER_86_440 VPWR VGND sg13cmos5l_decap_8
XFILLER_58_142 VPWR VGND sg13cmos5l_decap_8
Xfanout475 _09955_/B fanout481/X VPWR VGND sg13cmos5l_buf_1
XFILLER_48_56 VPWR VGND sg13cmos5l_fill_2
Xfanout442 _09419_/B fanout451/X VPWR VGND sg13cmos5l_buf_1
Xfanout453 _09551_/S0 _09499_/B VPWR VGND sg13cmos5l_buf_1
Xfanout464 _09840_/S _09659_/S0 VPWR VGND sg13cmos5l_buf_1
XFILLER_74_624 VPWR VGND sg13cmos5l_decap_4
XFILLER_73_101 VPWR VGND sg13cmos5l_fill_2
X_09829_ _09829_/Y _09910_/A _09829_/B _09913_/B VPWR VGND sg13cmos5l_nand3_1
Xfanout486 _06643_/B1 _06400_/Y VPWR VGND sg13cmos5l_buf_1
XFILLER_47_816 VPWR VGND sg13cmos5l_decap_8
Xfanout497 _09747_/B _09319_/C VPWR VGND sg13cmos5l_buf_1
XFILLER_46_315 VPWR VGND sg13cmos5l_fill_2
XFILLER_73_112 VPWR VGND sg13cmos5l_fill_1
X_11030__895 _11030_/RESET_B VPWR VGND sg13cmos5l_tiehi
XFILLER_104_84 VPWR VGND sg13cmos5l_decap_8
XFILLER_55_871 VPWR VGND sg13cmos5l_decap_8
XFILLER_14_201 VPWR VGND sg13cmos5l_decap_4
XFILLER_15_724 VPWR VGND sg13cmos5l_fill_2
X_11722_ _11722_/Q clkload22/A _11722_/D _11722_/RESET_B VPWR VGND sg13cmos5l_dfrbpq_1
XFILLER_42_554 VPWR VGND sg13cmos5l_fill_1
X_11653_ _11653_/Q clkload11/A _11653_/D _11653_/RESET_B VPWR VGND sg13cmos5l_dfrbpq_1
Xfanout60 fanout60/X _07620_/Y VPWR VGND sg13cmos5l_buf_1
X_10604_ _10628_/A _10604_/A _10604_/B VPWR VGND sg13cmos5l_nand2_1
Xfanout82 fanout82/X fanout83/X VPWR VGND sg13cmos5l_buf_1
Xfanout71 _10583_/B _10311_/Y VPWR VGND sg13cmos5l_buf_1
X_11584_ _11584_/Q _11594_/CLK _11584_/D _11584_/RESET_B VPWR VGND sg13cmos5l_dfrbpq_1
Xfanout93 _09915_/A _09314_/A VPWR VGND sg13cmos5l_buf_1
XFILLER_10_462 VPWR VGND sg13cmos5l_fill_1
X_10535_ _10553_/B _10570_/A _10535_/B _10567_/A VPWR VGND sg13cmos5l_nand3b_1
XFILLER_6_433 VPWR VGND sg13cmos5l_fill_2
X_10466_ _10466_/Y _10525_/A _10437_/X _10494_/B1 VPWR VGND sg13cmos5l_a21oi_1
XFILLER_89_96 VPWR VGND sg13cmos5l_fill_2
X_10397_ _10397_/Y _11405_/Q _10842_/Q VPWR VGND sg13cmos5l_nor2_1
XFILLER_2_650 VPWR VGND sg13cmos5l_decap_8
XFILLER_9_1019 VPWR VGND sg13cmos5l_decap_8
XFILLER_78_941 VPWR VGND sg13cmos5l_fill_2
X_11018_ _11018_/Q _11646_/CLK _11018_/D _11018_/RESET_B VPWR VGND sg13cmos5l_dfrbpq_1
XFILLER_92_410 VPWR VGND sg13cmos5l_fill_2
XFILLER_65_613 VPWR VGND sg13cmos5l_decap_8
XFILLER_77_495 VPWR VGND sg13cmos5l_decap_4
XFILLER_64_145 VPWR VGND sg13cmos5l_decap_8
XFILLER_18_551 VPWR VGND sg13cmos5l_fill_2
XFILLER_92_487 VPWR VGND sg13cmos5l_fill_1
X_06490_ _11370_/D _06490_/A _06490_/B VPWR VGND sg13cmos5l_nand2_1
X_11664__1300 _11664_/RESET_B VPWR VGND sg13cmos5l_tiehi
XFILLER_33_565 VPWR VGND sg13cmos5l_fill_1
X_08160_ _11167_/D fanout74/X _08177_/B _08159_/Y VPWR VGND sg13cmos5l_a21oi_1
X_07111_ _07111_/Y hold2759/X _07130_/A2 _07155_/B1 VPWR VGND sg13cmos5l_o21ai_1
X_08091_ _11134_/D fanout77/X _08106_/B _08090_/Y VPWR VGND sg13cmos5l_o21ai_1
XFILLER_9_293 VPWR VGND sg13cmos5l_decap_8
Xclkload52 clkload52/Y clkload52/A VPWR VGND sg13cmos5l_inv_1
Xclkload30 clkload30/X clkload30/A VPWR VGND sg13cmos5l_buf_8
Xclkload41 clkload41/Y clkload41/A VPWR VGND sg13cmos5l_inv_2
X_07042_ _11672_/D hold2490/X _08626_/A1 _07041_/Y VPWR VGND sg13cmos5l_a21o_1
X_11697__1267 _11697_/RESET_B VPWR VGND sg13cmos5l_tiehi
XFILLER_102_526 VPWR VGND sg13cmos5l_fill_2
XFILLER_102_515 VPWR VGND sg13cmos5l_decap_8
Xhold2814 hold2814/X _11486_/Q VPWR VGND sg13cmos5l_dlygate4sd3_1
Xhold2803 hold2803/X _11688_/Q VPWR VGND sg13cmos5l_dlygate4sd3_1
XFILLER_69_930 VPWR VGND sg13cmos5l_decap_8
X_08993_ _09019_/B _11632_/Q _08973_/A _08981_/B _11388_/Q VPWR VGND sg13cmos5l_a22oi_1
Xhold2847 hold2847/X _11730_/Q VPWR VGND sg13cmos5l_dlygate4sd3_1
XFILLER_69_941 VPWR VGND sg13cmos5l_fill_1
Xhold2836 hold2836/X _11725_/Q VPWR VGND sg13cmos5l_dlygate4sd3_1
Xhold2825 hold2825/X _11414_/Q VPWR VGND sg13cmos5l_dlygate4sd3_1
X_07944_ _07944_/Y _07944_/A _07966_/B VPWR VGND sg13cmos5l_nand2_1
XFILLER_29_805 VPWR VGND sg13cmos5l_decap_8
XFILLER_68_451 VPWR VGND sg13cmos5l_decap_8
Xhold2858 hold2858/X _11410_/Q VPWR VGND sg13cmos5l_dlygate4sd3_1
Xhold2869 _11532_/D _10413_/Y VPWR VGND sg13cmos5l_dlygate4sd3_1
X_07875_ _07875_/Y _07875_/A _07875_/B VPWR VGND sg13cmos5l_nor2_1
XFILLER_95_281 VPWR VGND sg13cmos5l_decap_8
X_06826_ _06826_/Y _06826_/A _10785_/B VPWR VGND sg13cmos5l_nand2_1
X_11582__1461 _11582_/RESET_B VPWR VGND sg13cmos5l_tiehi
XFILLER_83_410 VPWR VGND sg13cmos5l_fill_2
XFILLER_68_484 VPWR VGND sg13cmos5l_decap_8
X_09614_ _09614_/Y _09614_/A _09613_/Y VPWR VGND sg13cmos5l_nor2b_1
XFILLER_70_115 VPWR VGND sg13cmos5l_decap_8
XFILLER_55_189 VPWR VGND sg13cmos5l_fill_1
X_06757_ _06757_/Y _10581_/A _06757_/B VPWR VGND sg13cmos5l_nor2_1
X_09545_ _09545_/Y _10934_/Q _09841_/B VPWR VGND sg13cmos5l_nand2_1
XFILLER_70_159 VPWR VGND sg13cmos5l_decap_8
XFILLER_52_863 VPWR VGND sg13cmos5l_decap_8
XFILLER_51_340 VPWR VGND sg13cmos5l_fill_2
X_09476_ _09476_/Y _09469_/Y _09471_/Y _09475_/Y _09579_/B2 VPWR VGND sg13cmos5l_a22oi_1
X_06688_ _06688_/Y _11501_/Q _11470_/Q _06679_/A VPWR VGND sg13cmos5l_a21oi_1
XFILLER_24_543 VPWR VGND sg13cmos5l_decap_8
XFILLER_24_554 VPWR VGND sg13cmos5l_fill_1
XFILLER_34_14 VPWR VGND sg13cmos5l_decap_8
X_08427_ _08427_/Y _08427_/A _08439_/B VPWR VGND sg13cmos5l_nor2_1
XFILLER_51_384 VPWR VGND sg13cmos5l_decap_4
XFILLER_11_237 VPWR VGND sg13cmos5l_fill_1
Xclkload2 clkload2/X clkload2/A VPWR VGND sg13cmos5l_buf_8
X_08358_ _08358_/Y _08358_/A _08358_/B VPWR VGND sg13cmos5l_nand2_1
X_08289_ _08289_/Y _08289_/A _08307_/B VPWR VGND sg13cmos5l_nor2_1
X_07309_ _07309_/Y _07307_/Y _08686_/A _07316_/A2 VPWR VGND sg13cmos5l_a21oi_1
X_10320_ _10326_/B _10422_/A _10313_/Y _10319_/Y VPWR VGND sg13cmos5l_o21ai_1
XFILLER_3_403 VPWR VGND sg13cmos5l_decap_8
X_10251_ _10251_/Y _10250_/B _10289_/A _10250_/D _10250_/A VPWR VGND sg13cmos5l_a22oi_1
XFILLER_4_937 VPWR VGND sg13cmos5l_fill_2
XFILLER_3_425 VPWR VGND sg13cmos5l_decap_4
XFILLER_106_854 VPWR VGND sg13cmos5l_decap_8
XFILLER_105_342 VPWR VGND sg13cmos5l_fill_2
XFILLER_59_33 VPWR VGND sg13cmos5l_decap_4
X_10182_ _10182_/Y _10180_/X _10181_/Y _10707_/C VPWR VGND sg13cmos5l_a21oi_1
XFILLER_78_248 VPWR VGND sg13cmos5l_fill_1
XFILLER_59_440 VPWR VGND sg13cmos5l_decap_8
Xfanout250 _07694_/B _07684_/B VPWR VGND sg13cmos5l_buf_1
Xfanout272 _07244_/A _07168_/Y VPWR VGND sg13cmos5l_buf_1
Xfanout261 _07526_/B _07482_/B VPWR VGND sg13cmos5l_buf_1
Xfanout283 _08348_/B _08311_/Y VPWR VGND sg13cmos5l_buf_1
Xfanout294 _08106_/B _08104_/B VPWR VGND sg13cmos5l_buf_1
XFILLER_101_581 VPWR VGND sg13cmos5l_decap_8
XFILLER_74_432 VPWR VGND sg13cmos5l_fill_1
XFILLER_46_123 VPWR VGND sg13cmos5l_fill_1
XFILLER_19_315 VPWR VGND sg13cmos5l_fill_2
XFILLER_46_145 VPWR VGND sg13cmos5l_fill_2
XFILLER_19_359 VPWR VGND sg13cmos5l_decap_8
XFILLER_74_487 VPWR VGND sg13cmos5l_fill_1
XFILLER_61_126 VPWR VGND sg13cmos5l_decap_4
XFILLER_91_42 VPWR VGND sg13cmos5l_decap_8
XFILLER_27_392 VPWR VGND sg13cmos5l_decap_8
X_11705_ _11705_/Q _11713_/CLK _11705_/D _11705_/RESET_B VPWR VGND sg13cmos5l_dfrbpq_1
XFILLER_30_546 VPWR VGND sg13cmos5l_decap_4
X_11636_ _11636_/Q clkload31/A _11636_/D _11636_/RESET_B VPWR VGND sg13cmos5l_dfrbpq_1
X_11567_ _11567_/Q clkload26/A _11567_/D _11567_/RESET_B VPWR VGND sg13cmos5l_dfrbpq_1
XFILLER_11_771 VPWR VGND sg13cmos5l_fill_2
X_10518_ _10570_/B _11410_/Q _10847_/Q _10848_/Q _10513_/A VPWR VGND sg13cmos5l_a22oi_1
X_10796__933 _10796_/RESET_B VPWR VGND sg13cmos5l_tiehi
XFILLER_6_285 VPWR VGND sg13cmos5l_fill_2
X_11498_ _11498_/Q clkload15/A _11498_/D _11498_/RESET_B VPWR VGND sg13cmos5l_dfrbpq_1
XFILLER_97_502 VPWR VGND sg13cmos5l_fill_1
X_10449_ _10449_/Y _10537_/A _10630_/B VPWR VGND sg13cmos5l_nand2_1
X_11401__1488 _11401_/RESET_B VPWR VGND sg13cmos5l_tiehi
XFILLER_34_4 VPWR VGND sg13cmos5l_fill_2
X_05990_ _06038_/C _10774_/A _05990_/B VPWR VGND sg13cmos5l_or2_1
XFILLER_65_410 VPWR VGND sg13cmos5l_decap_8
XFILLER_37_123 VPWR VGND sg13cmos5l_decap_4
XFILLER_38_668 VPWR VGND sg13cmos5l_decap_8
XFILLER_26_819 VPWR VGND sg13cmos5l_fill_1
X_07660_ _07660_/Y _07660_/A _07684_/B VPWR VGND sg13cmos5l_nor2_1
X_07591_ _07591_/Y _07591_/A _07591_/B VPWR VGND sg13cmos5l_nand2_1
XFILLER_53_638 VPWR VGND sg13cmos5l_decap_8
XFILLER_37_178 VPWR VGND sg13cmos5l_decap_8
XFILLER_18_370 VPWR VGND sg13cmos5l_decap_4
X_06611_ _06612_/B _06609_/Y _06611_/B VPWR VGND sg13cmos5l_nand2b_1
XFILLER_81_969 VPWR VGND sg13cmos5l_decap_8
XFILLER_52_159 VPWR VGND sg13cmos5l_fill_2
XFILLER_46_690 VPWR VGND sg13cmos5l_decap_8
X_09330_ _09330_/Y _07472_/D _09404_/B _09329_/Y VPWR VGND sg13cmos5l_a21oi_1
X_06542_ _06542_/Y _06542_/A _06542_/B VPWR VGND sg13cmos5l_nand2_1
X_09261_ _09261_/Y _09262_/A _10858_/Q VPWR VGND sg13cmos5l_nor2_1
X_11291__1610 _11291_/RESET_B VPWR VGND sg13cmos5l_tiehi
XFILLER_21_513 VPWR VGND sg13cmos5l_decap_4
XFILLER_33_351 VPWR VGND sg13cmos5l_fill_2
X_08212_ _08212_/Y _08212_/A _08228_/B VPWR VGND sg13cmos5l_nand2_1
X_06473_ _06483_/A _06473_/A _10017_/A _06473_/C VPWR VGND sg13cmos5l_nor3_1
X_09192_ _09344_/B _09354_/A _10833_/Q VPWR VGND sg13cmos5l_xor2_1
X_08143_ _08143_/Y _08143_/A _08143_/B VPWR VGND sg13cmos5l_nor2_1
XFILLER_101_1027 VPWR VGND sg13cmos5l_fill_2
XFILLER_101_1016 VPWR VGND sg13cmos5l_decap_8
X_08074_ _08074_/Y _08074_/A _08074_/B VPWR VGND sg13cmos5l_nand2_1
X_07025_ _07025_/Y _11507_/Q _07024_/B _07024_/Y VPWR VGND sg13cmos5l_a21oi_1
XFILLER_20_38 VPWR VGND sg13cmos5l_decap_4
XFILLER_1_918 VPWR VGND sg13cmos5l_decap_8
XFILLER_88_502 VPWR VGND sg13cmos5l_decap_8
Xhold2600 hold2600/X _11562_/Q VPWR VGND sg13cmos5l_dlygate4sd3_1
Xhold2611 _06838_/A _11613_/Q VPWR VGND sg13cmos5l_dlygate4sd3_1
Xhold2622 _07172_/A _11705_/Q VPWR VGND sg13cmos5l_dlygate4sd3_1
Xhold2633 hold2633/X _11749_/Q VPWR VGND sg13cmos5l_dlygate4sd3_1
Xhold2655 _11644_/D _06941_/Y VPWR VGND sg13cmos5l_dlygate4sd3_1
Xhold2644 _11374_/D _08609_/Y VPWR VGND sg13cmos5l_dlygate4sd3_1
XFILLER_57_900 VPWR VGND sg13cmos5l_fill_2
X_08976_ _08976_/Y _08983_/B _08972_/Y _08997_/C _08975_/Y _09131_/A VPWR VGND sg13cmos5l_a221oi_1
Xhold1910 _08324_/A _11248_/Q VPWR VGND sg13cmos5l_dlygate4sd3_1
Xhold1943 _07850_/A _11017_/Q VPWR VGND sg13cmos5l_dlygate4sd3_1
Xhold2699 _10744_/A _11566_/Q VPWR VGND sg13cmos5l_dlygate4sd3_1
Xhold2677 _10126_/B _10851_/Q VPWR VGND sg13cmos5l_dlygate4sd3_1
Xhold1932 _07822_/A _11003_/Q VPWR VGND sg13cmos5l_dlygate4sd3_1
Xhold1954 _08476_/A _11323_/Q VPWR VGND sg13cmos5l_dlygate4sd3_1
Xhold2688 _11699_/D _06890_/X VPWR VGND sg13cmos5l_dlygate4sd3_1
Xhold2666 _11385_/D _08639_/Y VPWR VGND sg13cmos5l_dlygate4sd3_1
Xhold1921 _07946_/A _11063_/Q VPWR VGND sg13cmos5l_dlygate4sd3_1
X_07927_ _11053_/D _08384_/A1 _07940_/B _07926_/Y VPWR VGND sg13cmos5l_o21ai_1
XFILLER_28_101 VPWR VGND sg13cmos5l_fill_1
Xhold1987 _08244_/A _11209_/Q VPWR VGND sg13cmos5l_dlygate4sd3_1
X_07858_ _11019_/D _08053_/A1 _07913_/B _07857_/Y VPWR VGND sg13cmos5l_a21oi_1
Xhold1976 _08110_/A _11144_/Q VPWR VGND sg13cmos5l_dlygate4sd3_1
XFILLER_72_914 VPWR VGND sg13cmos5l_fill_2
Xhold1965 _07804_/A _10994_/Q VPWR VGND sg13cmos5l_dlygate4sd3_1
XFILLER_21_1028 VPWR VGND sg13cmos5l_fill_1
X_07789_ _10986_/D _08508_/A1 _07846_/B _07788_/Y VPWR VGND sg13cmos5l_o21ai_1
X_06809_ _06809_/Y _06809_/A _10763_/S VPWR VGND sg13cmos5l_nand2_1
Xhold1998 _08360_/A _11266_/Q VPWR VGND sg13cmos5l_dlygate4sd3_1
XFILLER_57_999 VPWR VGND sg13cmos5l_fill_2
XFILLER_56_487 VPWR VGND sg13cmos5l_decap_8
XFILLER_44_627 VPWR VGND sg13cmos5l_decap_4
XFILLER_16_329 VPWR VGND sg13cmos5l_fill_1
XFILLER_71_446 VPWR VGND sg13cmos5l_fill_1
X_10865__1117 _10865_/RESET_B VPWR VGND sg13cmos5l_tiehi
X_09528_ _09528_/Y _11349_/Q _09593_/B _09605_/B1 VPWR VGND sg13cmos5l_a21oi_1
X_10901__1081 _10901_/RESET_B VPWR VGND sg13cmos5l_tiehi
XFILLER_25_874 VPWR VGND sg13cmos5l_fill_1
XFILLER_25_896 VPWR VGND sg13cmos5l_fill_2
XFILLER_101_63 VPWR VGND sg13cmos5l_decap_8
XFILLER_12_524 VPWR VGND sg13cmos5l_fill_1
X_09459_ _09460_/C _09534_/A _09453_/X _09458_/Y VPWR VGND sg13cmos5l_o21ai_1
XFILLER_40_877 VPWR VGND sg13cmos5l_decap_8
X_11421_ _11421_/Q clkload53/A _11421_/D _11421_/RESET_B VPWR VGND sg13cmos5l_dfrbpq_1
X_11154__1747 _11154_/RESET_B VPWR VGND sg13cmos5l_tiehi
X_11352_ _11352_/Q _11352_/CLK _11352_/D _11352_/RESET_B VPWR VGND sg13cmos5l_dfrbpq_1
X_10303_ _10491_/B _10303_/A _10302_/Y VPWR VGND sg13cmos5l_nor2b_1
XFILLER_106_651 VPWR VGND sg13cmos5l_decap_8
X_11283_ _11283_/Q _11347_/CLK _11283_/D _11283_/RESET_B VPWR VGND sg13cmos5l_dfrbpq_1
XFILLER_3_244 VPWR VGND sg13cmos5l_decap_8
XFILLER_105_161 VPWR VGND sg13cmos5l_decap_8
X_10234_ _10234_/Y _09335_/A _09335_/B _10317_/B _10233_/Y VPWR VGND sg13cmos5l_a22oi_1
X_10165_ _10166_/B _10173_/A _10165_/B VPWR VGND sg13cmos5l_nor2_1
XFILLER_94_505 VPWR VGND sg13cmos5l_fill_1
XFILLER_86_42 VPWR VGND sg13cmos5l_decap_4
X_10096_ _10096_/Y _10330_/B _09581_/B _10095_/Y VPWR VGND sg13cmos5l_a21oi_1
XFILLER_19_134 VPWR VGND sg13cmos5l_decap_4
XFILLER_19_156 VPWR VGND sg13cmos5l_decap_8
XFILLER_75_785 VPWR VGND sg13cmos5l_decap_8
XFILLER_47_487 VPWR VGND sg13cmos5l_fill_2
XFILLER_35_627 VPWR VGND sg13cmos5l_decap_4
XFILLER_19_178 VPWR VGND sg13cmos5l_fill_2
XFILLER_34_104 VPWR VGND sg13cmos5l_fill_1
XFILLER_63_969 VPWR VGND sg13cmos5l_fill_1
XFILLER_62_446 VPWR VGND sg13cmos5l_fill_1
XFILLER_28_690 VPWR VGND sg13cmos5l_decap_8
XFILLER_62_479 VPWR VGND sg13cmos5l_decap_4
X_10998_ _10998_/Q clkload33/A _10998_/D _10998_/RESET_B VPWR VGND sg13cmos5l_dfrbpq_1
XFILLER_31_822 VPWR VGND sg13cmos5l_fill_2
X_11619_ _11619_/Q _11622_/CLK _11619_/D _11619_/RESET_B VPWR VGND sg13cmos5l_dfrbpq_1
XFILLER_7_583 VPWR VGND sg13cmos5l_decap_4
XFILLER_7_572 VPWR VGND sg13cmos5l_fill_2
XFILLER_98_833 VPWR VGND sg13cmos5l_fill_1
XFILLER_83_1022 VPWR VGND sg13cmos5l_decap_8
X_10943__1039 _10943_/RESET_B VPWR VGND sg13cmos5l_tiehi
XFILLER_58_708 VPWR VGND sg13cmos5l_fill_2
X_08830_ _08830_/Y _08867_/A _08824_/Y _08829_/Y VPWR VGND sg13cmos5l_o21ai_1
XFILLER_97_376 VPWR VGND sg13cmos5l_decap_8
XFILLER_57_207 VPWR VGND sg13cmos5l_fill_1
X_08761_ _11420_/D _08761_/A VPWR VGND sg13cmos5l_inv_1
X_05973_ _05973_/Y _11323_/Q VPWR VGND sg13cmos5l_inv_1
XFILLER_39_933 VPWR VGND sg13cmos5l_decap_8
X_07712_ _07712_/Y _07712_/A _07712_/B VPWR VGND sg13cmos5l_nor2_1
X_08692_ _08693_/A hold2787/X _08895_/B _08896_/B _08922_/A VPWR VGND sg13cmos5l_a22oi_1
XFILLER_39_977 VPWR VGND sg13cmos5l_decap_8
XFILLER_93_571 VPWR VGND sg13cmos5l_fill_1
X_07643_ _07649_/B _11422_/Q _11421_/Q _11420_/Q _07643_/D VPWR VGND sg13cmos5l_nand4_1
X_11232__1669 _11232_/RESET_B VPWR VGND sg13cmos5l_tiehi
XFILLER_65_295 VPWR VGND sg13cmos5l_fill_1
X_09313_ _09314_/C _09313_/A _09321_/B VPWR VGND sg13cmos5l_nor2b_1
X_07574_ _08726_/B _11539_/Q _10814_/Q _07582_/S VPWR VGND sg13cmos5l_mux2_1
X_06525_ _06525_/Y _06525_/A _10693_/C _06525_/C _06525_/D VPWR VGND sg13cmos5l_nand4_1
XFILLER_33_181 VPWR VGND sg13cmos5l_fill_1
X_09244_ _09244_/X _09244_/A _09244_/B VPWR VGND sg13cmos5l_and2_1
Xclkbuf_leaf_60_clk clkload34/A clkbuf_4_8_0_clk/X VPWR VGND sg13cmos5l_buf_8
X_06456_ _06456_/Y _10988_/Q _09529_/B VPWR VGND sg13cmos5l_nand2_1
XFILLER_21_398 VPWR VGND sg13cmos5l_decap_8
X_09175_ _09175_/X _09429_/A _10835_/Q VPWR VGND sg13cmos5l_xor2_1
X_06387_ _06387_/Y _06387_/A _06387_/B VPWR VGND sg13cmos5l_nor2_1
X_08126_ _11150_/D _08321_/A1 _08135_/B _08125_/Y VPWR VGND sg13cmos5l_a21oi_1
XFILLER_31_37 VPWR VGND sg13cmos5l_decap_4
XFILLER_103_7 VPWR VGND sg13cmos5l_decap_8
X_08057_ _11117_/D _08384_/A1 _08074_/B _08056_/Y VPWR VGND sg13cmos5l_o21ai_1
Xoutput26 uio_out[15] _12769_/X VPWR VGND sg13cmos5l_buf_1
X_07008_ _07008_/Y _07008_/A _07036_/B VPWR VGND sg13cmos5l_nor2_1
Xoutput48 uo_out[9] _06557_/Y VPWR VGND sg13cmos5l_buf_1
Xoutput37 uo_out[13] _06569_/Y VPWR VGND sg13cmos5l_buf_1
XFILLER_1_737 VPWR VGND sg13cmos5l_decap_8
X_10919__1063 _10919_/RESET_B VPWR VGND sg13cmos5l_tiehi
Xhold2430 _08525_/A _11347_/Q VPWR VGND sg13cmos5l_dlygate4sd3_1
XFILLER_102_175 VPWR VGND sg13cmos5l_decap_8
Xhold2452 _07772_/A _10979_/Q VPWR VGND sg13cmos5l_dlygate4sd3_1
Xhold2463 hold2463/X _11760_/Q VPWR VGND sg13cmos5l_dlygate4sd3_1
X_08959_ _08959_/Y _08959_/A _09004_/B VPWR VGND sg13cmos5l_nand2_1
XFILLER_5_1022 VPWR VGND sg13cmos5l_decap_8
Xhold2441 _07482_/A _10896_/Q VPWR VGND sg13cmos5l_dlygate4sd3_1
XFILLER_29_421 VPWR VGND sg13cmos5l_fill_1
Xhold2474 _10727_/A _11597_/Q VPWR VGND sg13cmos5l_dlygate4sd3_1
Xhold2485 hold2485/X _11582_/Q VPWR VGND sg13cmos5l_dlygate4sd3_1
Xhold2496 hold2496/X _11658_/Q VPWR VGND sg13cmos5l_dlygate4sd3_1
XFILLER_29_443 VPWR VGND sg13cmos5l_fill_2
X_10921_ _10921_/Q clkload51/A _10921_/D _10921_/RESET_B VPWR VGND sg13cmos5l_dfrbpq_1
XFILLER_72_711 VPWR VGND sg13cmos5l_decap_4
XFILLER_56_78 VPWR VGND sg13cmos5l_decap_4
XFILLER_16_104 VPWR VGND sg13cmos5l_fill_1
XFILLER_17_616 VPWR VGND sg13cmos5l_fill_2
XFILLER_72_744 VPWR VGND sg13cmos5l_fill_2
XFILLER_72_733 VPWR VGND sg13cmos5l_fill_1
XFILLER_71_221 VPWR VGND sg13cmos5l_decap_4
X_11208__1693 _11208_/RESET_B VPWR VGND sg13cmos5l_tiehi
XFILLER_72_33 VPWR VGND sg13cmos5l_decap_8
X_10852_ _10852_/Q _11715_/CLK _10852_/D _10852_/RESET_B VPWR VGND sg13cmos5l_dfrbpq_1
XFILLER_60_928 VPWR VGND sg13cmos5l_decap_4
X_10783_ _10783_/Y _11643_/Q _10783_/B _10783_/C VPWR VGND sg13cmos5l_nand3_1
XFILLER_31_118 VPWR VGND sg13cmos5l_fill_2
X_11692__1272 _11692_/RESET_B VPWR VGND sg13cmos5l_tiehi
XFILLER_13_866 VPWR VGND sg13cmos5l_decap_8
Xclkbuf_leaf_51_clk _11352_/CLK clkload4/A VPWR VGND sg13cmos5l_buf_8
XFILLER_40_685 VPWR VGND sg13cmos5l_decap_8
XFILLER_40_674 VPWR VGND sg13cmos5l_fill_1
X_11404_ _11404_/Q _11535_/CLK _11404_/D _11404_/RESET_B VPWR VGND sg13cmos5l_dfrbpq_1
X_11335_ _11335_/Q clkload49/A _11335_/D _11335_/RESET_B VPWR VGND sg13cmos5l_dfrbpq_1
XFILLER_21_70 VPWR VGND sg13cmos5l_fill_2
X_11266_ _11266_/Q clkload52/A _11266_/D _11266_/RESET_B VPWR VGND sg13cmos5l_dfrbpq_1
XFILLER_4_575 VPWR VGND sg13cmos5l_decap_8
XFILLER_97_63 VPWR VGND sg13cmos5l_decap_8
XFILLER_79_343 VPWR VGND sg13cmos5l_fill_2
X_10217_ _10217_/Y hold2759/X _07067_/X _10166_/X hold2738/X VPWR VGND sg13cmos5l_a22oi_1
XFILLER_97_96 VPWR VGND sg13cmos5l_fill_1
X_11197_ _11197_/Q clkload42/A _11197_/D _11197_/RESET_B VPWR VGND sg13cmos5l_dfrbpq_1
X_10148_ _10148_/X _06251_/A _10135_/B _10147_/Y VPWR VGND sg13cmos5l_a21o_1
X_10079_ _10079_/Y _07036_/A _10092_/B1 _10078_/X VPWR VGND sg13cmos5l_o21ai_1
XFILLER_75_571 VPWR VGND sg13cmos5l_decap_8
XFILLER_36_936 VPWR VGND sg13cmos5l_decap_8
XFILLER_16_682 VPWR VGND sg13cmos5l_fill_2
Xclkbuf_leaf_42_clk _11355_/CLK clkbuf_4_14_0_clk/X VPWR VGND sg13cmos5l_buf_8
XFILLER_43_490 VPWR VGND sg13cmos5l_decap_4
X_07290_ _07290_/Y _11431_/Q _07296_/B VPWR VGND sg13cmos5l_nand2_1
X_06310_ _06310_/Y _10434_/B _06310_/B VPWR VGND sg13cmos5l_nand2b_1
X_06241_ _06242_/A _06444_/A _09270_/A VPWR VGND sg13cmos5l_xor2_1
XFILLER_30_140 VPWR VGND sg13cmos5l_fill_1
XFILLER_30_151 VPWR VGND sg13cmos5l_fill_2
XFILLER_31_685 VPWR VGND sg13cmos5l_decap_8
XFILLER_50_1021 VPWR VGND sg13cmos5l_decap_8
XFILLER_8_892 VPWR VGND sg13cmos5l_decap_8
X_06172_ _06173_/B _06172_/A _09205_/A VPWR VGND sg13cmos5l_nor2_1
XFILLER_7_94 VPWR VGND sg13cmos5l_fill_2
X_09931_ _09931_/Y _09931_/A _09931_/B VPWR VGND sg13cmos5l_nor2_1
Xfanout816 _08648_/A _05933_/Y VPWR VGND sg13cmos5l_buf_1
Xfanout805 _09150_/A _08645_/A1 VPWR VGND sg13cmos5l_buf_1
Xfanout827 _10687_/A _10751_/A VPWR VGND sg13cmos5l_buf_1
X_09862_ _09917_/A _09862_/A _09862_/B _09862_/C VPWR VGND sg13cmos5l_and3_1
X_09793_ _09793_/Y _10911_/Q _09870_/B _09987_/B1 VPWR VGND sg13cmos5l_a21oi_1
X_08813_ _08816_/A _11379_/Q _08817_/D VPWR VGND sg13cmos5l_xnor2_1
XFILLER_85_346 VPWR VGND sg13cmos5l_fill_2
X_08744_ _11416_/D _08744_/A VPWR VGND sg13cmos5l_inv_1
X_05956_ _05956_/Y _11310_/Q VPWR VGND sg13cmos5l_inv_1
XFILLER_27_903 VPWR VGND sg13cmos5l_decap_8
X_05887_ _05887_/Y input11/X VPWR VGND sg13cmos5l_inv_1
XFILLER_53_221 VPWR VGND sg13cmos5l_decap_8
X_08675_ _08849_/B _08846_/A _07490_/X _08689_/A VPWR VGND sg13cmos5l_mux2_1
XFILLER_26_37 VPWR VGND sg13cmos5l_fill_2
X_07626_ _07626_/Y _07638_/A _08754_/B _07625_/Y VPWR VGND sg13cmos5l_a21oi_1
XFILLER_53_254 VPWR VGND sg13cmos5l_fill_1
XFILLER_42_917 VPWR VGND sg13cmos5l_fill_1
XFILLER_26_468 VPWR VGND sg13cmos5l_fill_2
X_07557_ _07558_/B _10477_/A _07562_/D _11409_/Q VPWR VGND sg13cmos5l_a21oi_1
XFILLER_35_991 VPWR VGND sg13cmos5l_decap_8
Xclkbuf_leaf_33_clk clkload51/A clkload5/A VPWR VGND sg13cmos5l_buf_8
X_06508_ _06509_/B hold2776/X _10164_/B _06507_/Y VPWR VGND sg13cmos5l_a21oi_1
XFILLER_50_994 VPWR VGND sg13cmos5l_decap_4
X_07488_ _07488_/Y _07488_/A _07566_/B VPWR VGND sg13cmos5l_nor2_1
X_06439_ _06439_/Y _11517_/Q _09268_/A _06441_/A1 VPWR VGND sg13cmos5l_a21oi_1
X_09227_ _09227_/Y _09216_/Y _09620_/A _09226_/Y VPWR VGND sg13cmos5l_o21ai_1
X_09158_ _09158_/Y _11479_/Q _10852_/Q VPWR VGND sg13cmos5l_nand2_1
X_08109_ _11143_/D fanout54/X _08108_/B _08108_/Y VPWR VGND sg13cmos5l_o21ai_1
X_09089_ _09089_/Y _09104_/A _09088_/X _05939_/A VPWR VGND sg13cmos5l_o21ai_1
X_11120_ _11120_/Q clkload8/A _11120_/D _11120_/RESET_B VPWR VGND sg13cmos5l_dfrbpq_1
XFILLER_104_985 VPWR VGND sg13cmos5l_decap_8
X_11051_ _11051_/Q clkload32/A _11051_/D _11051_/RESET_B VPWR VGND sg13cmos5l_dfrbpq_1
XFILLER_103_484 VPWR VGND sg13cmos5l_fill_1
X_10002_ _10002_/Y _10055_/A _10002_/B _10002_/C VPWR VGND sg13cmos5l_nor3_1
Xhold2282 _07668_/A _10928_/Q VPWR VGND sg13cmos5l_dlygate4sd3_1
Xhold2260 _07455_/A _10892_/Q VPWR VGND sg13cmos5l_dlygate4sd3_1
Xhold2271 _10869_/D _07312_/Y VPWR VGND sg13cmos5l_dlygate4sd3_1
XFILLER_91_305 VPWR VGND sg13cmos5l_fill_1
XFILLER_85_891 VPWR VGND sg13cmos5l_fill_2
Xhold2293 hold2293/X _11767_/Q VPWR VGND sg13cmos5l_dlygate4sd3_1
XFILLER_45_711 VPWR VGND sg13cmos5l_fill_1
XFILLER_29_240 VPWR VGND sg13cmos5l_decap_4
XFILLER_17_435 VPWR VGND sg13cmos5l_decap_8
XFILLER_83_76 VPWR VGND sg13cmos5l_decap_4
XFILLER_72_552 VPWR VGND sg13cmos5l_decap_8
XFILLER_45_766 VPWR VGND sg13cmos5l_fill_1
X_10904_ _10904_/Q _11349_/CLK _10904_/D _10904_/RESET_B VPWR VGND sg13cmos5l_dfrbpq_1
XFILLER_73_1021 VPWR VGND sg13cmos5l_decap_8
XFILLER_72_585 VPWR VGND sg13cmos5l_decap_8
X_10835_ _10835_/Q clkload21/A _10835_/D _10835_/RESET_B VPWR VGND sg13cmos5l_dfrbpq_1
XFILLER_60_736 VPWR VGND sg13cmos5l_fill_2
Xclkbuf_leaf_24_clk clkload29/A clkbuf_4_6_0_clk/X VPWR VGND sg13cmos5l_buf_8
XFILLER_32_449 VPWR VGND sg13cmos5l_decap_8
X_10766_ _10766_/X hold2485/X _10770_/S _07193_/X VPWR VGND sg13cmos5l_a21o_1
X_10697_ _10697_/Y _11641_/Q _06065_/C _10696_/Y VPWR VGND sg13cmos5l_o21ai_1
XFILLER_12_173 VPWR VGND sg13cmos5l_fill_1
XFILLER_8_188 VPWR VGND sg13cmos5l_decap_4
XFILLER_8_177 VPWR VGND sg13cmos5l_fill_2
XFILLER_99_405 VPWR VGND sg13cmos5l_fill_1
X_11318_ _11318_/Q clkload34/A _11318_/D _11318_/RESET_B VPWR VGND sg13cmos5l_dfrbpq_1
X_11249_ _11249_/Q clkload35/A _11249_/D _11249_/RESET_B VPWR VGND sg13cmos5l_dfrbpq_1
XFILLER_68_825 VPWR VGND sg13cmos5l_decap_4
X_10990__992 _10990_/RESET_B VPWR VGND sg13cmos5l_tiehi
X_10860__1122 _10860_/RESET_B VPWR VGND sg13cmos5l_tiehi
XFILLER_95_655 VPWR VGND sg13cmos5l_fill_2
X_06790_ _06790_/Y _06790_/A _06879_/B VPWR VGND sg13cmos5l_nand2_1
XFILLER_94_198 VPWR VGND sg13cmos5l_decap_8
XFILLER_63_552 VPWR VGND sg13cmos5l_fill_1
XFILLER_51_714 VPWR VGND sg13cmos5l_fill_2
X_08460_ _08460_/Y _08460_/A _08468_/B VPWR VGND sg13cmos5l_nand2_1
XFILLER_35_243 VPWR VGND sg13cmos5l_decap_4
X_07411_ _07411_/Y _07409_/Y _08759_/A _07429_/B1 VPWR VGND sg13cmos5l_a21oi_1
XFILLER_63_585 VPWR VGND sg13cmos5l_fill_1
XFILLER_50_224 VPWR VGND sg13cmos5l_decap_8
X_10893__1089 _10893_/RESET_B VPWR VGND sg13cmos5l_tiehi
X_08391_ _08391_/Y _08391_/A _08401_/B VPWR VGND sg13cmos5l_nor2_1
XFILLER_92_0 VPWR VGND sg13cmos5l_decap_8
Xclkbuf_leaf_15_clk clkload24/A clkbuf_4_4_0_clk/X VPWR VGND sg13cmos5l_buf_8
X_07342_ _07342_/Y _07383_/B _07340_/Y _07341_/Y VPWR VGND sg13cmos5l_a21oi_1
X_07273_ _07273_/Y _07271_/Y _07272_/Y _06956_/B VPWR VGND sg13cmos5l_a21oi_1
X_09012_ _09012_/Y _09051_/A1 _09008_/Y _09011_/Y VPWR VGND sg13cmos5l_a21oi_1
X_06224_ _06224_/Y _06732_/A _06741_/A _06224_/C VPWR VGND sg13cmos5l_nand3b_1
X_06155_ _06664_/A _11499_/Q _09214_/A VPWR VGND sg13cmos5l_xor2_1
XFILLER_105_738 VPWR VGND sg13cmos5l_fill_2
X_06086_ _06086_/Y _09278_/A _09301_/S VPWR VGND sg13cmos5l_nand2_1
XFILLER_104_259 VPWR VGND sg13cmos5l_decap_8
Xfanout613 _10006_/A _09731_/A VPWR VGND sg13cmos5l_buf_1
Xfanout602 _06078_/A _06023_/X VPWR VGND sg13cmos5l_buf_1
X_09914_ _09915_/D _09909_/Y _09910_/Y _09913_/Y VPWR VGND sg13cmos5l_o21ai_1
Xfanout624 _07100_/S _05995_/Y VPWR VGND sg13cmos5l_buf_1
XFILLER_98_493 VPWR VGND sg13cmos5l_fill_1
XFILLER_98_460 VPWR VGND sg13cmos5l_decap_4
Xfanout635 _06760_/S _05893_/Y VPWR VGND sg13cmos5l_buf_1
Xfanout657 _10495_/A2 fanout661/X VPWR VGND sg13cmos5l_buf_1
X_09845_ _09845_/X _11137_/Q _11105_/Q _11073_/Q _11041_/Q _09840_/S _09848_/B1 VPWR
+ VGND sg13cmos5l_mux4_1
Xfanout646 _06573_/A1 _06562_/A1 VPWR VGND sg13cmos5l_buf_1
Xfanout679 _05935_/A _10157_/A1 VPWR VGND sg13cmos5l_buf_1
Xfanout668 _10356_/A1 _06505_/A VPWR VGND sg13cmos5l_buf_1
XFILLER_101_988 VPWR VGND sg13cmos5l_decap_8
XFILLER_85_165 VPWR VGND sg13cmos5l_fill_2
XFILLER_58_379 VPWR VGND sg13cmos5l_decap_8
X_09776_ _09857_/A _10293_/A _09828_/B VPWR VGND sg13cmos5l_nand2_1
X_06988_ _06988_/Y _06986_/Y _06987_/Y _07050_/B1 VPWR VGND sg13cmos5l_a21oi_1
XFILLER_37_58 VPWR VGND sg13cmos5l_fill_1
XFILLER_27_711 VPWR VGND sg13cmos5l_fill_2
X_05939_ _05939_/Y _05939_/A VPWR VGND sg13cmos5l_inv_1
XFILLER_73_327 VPWR VGND sg13cmos5l_decap_4
XFILLER_54_530 VPWR VGND sg13cmos5l_fill_2
X_08727_ _09036_/A _08727_/A _08727_/B VPWR VGND sg13cmos5l_nand2_1
XFILLER_2_1025 VPWR VGND sg13cmos5l_decap_4
XFILLER_82_872 VPWR VGND sg13cmos5l_decap_8
X_08658_ _08817_/B _08789_/A _07457_/X _08671_/S VPWR VGND sg13cmos5l_mux2_1
XFILLER_15_917 VPWR VGND sg13cmos5l_decap_8
XFILLER_27_777 VPWR VGND sg13cmos5l_decap_8
X_07609_ _08745_/B _11544_/Q _10819_/Q _07642_/S VPWR VGND sg13cmos5l_mux2_1
XFILLER_26_276 VPWR VGND sg13cmos5l_decap_4
X_08589_ _08589_/Y _11115_/Q _10020_/B _08599_/S1 VPWR VGND sg13cmos5l_a21oi_1
X_11089__1812 _11089_/RESET_B VPWR VGND sg13cmos5l_tiehi
X_10620_ _10621_/A _10620_/A _10620_/B VPWR VGND sg13cmos5l_xor2_1
XFILLER_22_471 VPWR VGND sg13cmos5l_fill_1
X_10551_ _10566_/A _10551_/A _10551_/B VPWR VGND sg13cmos5l_xor2_1
XFILLER_50_791 VPWR VGND sg13cmos5l_fill_1
XFILLER_10_622 VPWR VGND sg13cmos5l_fill_2
X_10482_ _10483_/B _10525_/B _10480_/X _10481_/Y VPWR VGND sg13cmos5l_a21oi_1
XFILLER_6_637 VPWR VGND sg13cmos5l_fill_1
XFILLER_10_699 VPWR VGND sg13cmos5l_decap_8
X_11103_ _11103_/Q clkload57/A _11103_/D _11103_/RESET_B VPWR VGND sg13cmos5l_dfrbpq_1
XFILLER_2_865 VPWR VGND sg13cmos5l_fill_1
XFILLER_1_353 VPWR VGND sg13cmos5l_fill_2
XFILLER_89_471 VPWR VGND sg13cmos5l_fill_1
XFILLER_49_313 VPWR VGND sg13cmos5l_fill_1
X_11034_ _11034_/Q clkload41/A _11034_/D _11034_/RESET_B VPWR VGND sg13cmos5l_dfrbpq_1
XFILLER_89_493 VPWR VGND sg13cmos5l_decap_8
XFILLER_76_143 VPWR VGND sg13cmos5l_fill_2
XFILLER_94_42 VPWR VGND sg13cmos5l_decap_8
XFILLER_91_102 VPWR VGND sg13cmos5l_decap_4
XFILLER_49_368 VPWR VGND sg13cmos5l_decap_8
Xhold2090 _08031_/A _11105_/Q VPWR VGND sg13cmos5l_dlygate4sd3_1
XFILLER_91_113 VPWR VGND sg13cmos5l_fill_1
XFILLER_64_338 VPWR VGND sg13cmos5l_fill_2
XFILLER_73_872 VPWR VGND sg13cmos5l_fill_2
XFILLER_45_596 VPWR VGND sg13cmos5l_decap_4
XFILLER_17_276 VPWR VGND sg13cmos5l_fill_2
XFILLER_32_246 VPWR VGND sg13cmos5l_fill_2
X_10818_ _10818_/Q clkload55/A _10818_/D _10818_/RESET_B VPWR VGND sg13cmos5l_dfrbpq_1
XFILLER_14_961 VPWR VGND sg13cmos5l_fill_2
X_10749_ _10749_/Y _10749_/A _10749_/B _10749_/C VPWR VGND sg13cmos5l_nand3_1
X_10878__1104 _10878_/RESET_B VPWR VGND sg13cmos5l_tiehi
XFILLER_9_497 VPWR VGND sg13cmos5l_decap_4
X_07960_ _07960_/Y _07960_/A _07976_/B VPWR VGND sg13cmos5l_nand2_1
XFILLER_87_419 VPWR VGND sg13cmos5l_fill_1
XFILLER_101_229 VPWR VGND sg13cmos5l_fill_1
X_06911_ _06911_/X hold2705/X _11685_/Q _06917_/B VPWR VGND sg13cmos5l_mux2_1
Xclkbuf_leaf_4_clk _11767_/CLK clkbuf_4_1_0_clk/X VPWR VGND sg13cmos5l_buf_8
X_11167__1734 _11167_/RESET_B VPWR VGND sg13cmos5l_tiehi
X_07891_ _07891_/Y _07891_/A _07901_/B VPWR VGND sg13cmos5l_nor2_1
X_06842_ _06842_/Y _06835_/B _06841_/A _06838_/Y VPWR VGND sg13cmos5l_o21ai_1
XFILLER_67_154 VPWR VGND sg13cmos5l_fill_1
XFILLER_56_839 VPWR VGND sg13cmos5l_decap_4
X_09630_ _09630_/Y _11065_/Q _09630_/B VPWR VGND sg13cmos5l_nand2_1
X_06773_ _06773_/Y _10611_/A _06772_/X _06773_/B1 VPWR VGND sg13cmos5l_o21ai_1
X_09561_ _09561_/Y hold2787/X _09725_/B _09560_/Y VPWR VGND sg13cmos5l_a21oi_1
XFILLER_64_872 VPWR VGND sg13cmos5l_fill_2
XFILLER_48_390 VPWR VGND sg13cmos5l_fill_2
X_08512_ _11340_/D _08512_/A1 _08529_/B _08511_/Y VPWR VGND sg13cmos5l_a21oi_1
XFILLER_64_883 VPWR VGND sg13cmos5l_decap_8
X_11410__1470 _11410_/RESET_B VPWR VGND sg13cmos5l_tiehi
X_09492_ _09492_/Y _10932_/Q _09492_/B VPWR VGND sg13cmos5l_nand2_1
XFILLER_24_725 VPWR VGND sg13cmos5l_fill_2
X_08443_ _11306_/D _08508_/A1 _08494_/B _08442_/Y VPWR VGND sg13cmos5l_o21ai_1
X_08374_ _08374_/Y _08374_/A _08374_/B VPWR VGND sg13cmos5l_nand2_1
XFILLER_51_588 VPWR VGND sg13cmos5l_decap_8
X_07325_ _07325_/Y _11533_/Q _08730_/A VPWR VGND sg13cmos5l_nand2_1
X_07256_ _07256_/Y _09189_/A _07262_/A2 _07255_/Y VPWR VGND sg13cmos5l_a21oi_1
X_11019__906 _11019_/RESET_B VPWR VGND sg13cmos5l_tiehi
X_11494__1195 _11494_/RESET_B VPWR VGND sg13cmos5l_tiehi
X_06207_ _06272_/B _06605_/A _06612_/A _06207_/C _06207_/D VPWR VGND sg13cmos5l_nor4_1
XFILLER_105_502 VPWR VGND sg13cmos5l_fill_2
X_07187_ _07188_/B _10834_/Q _06933_/B _07184_/X _07185_/X VPWR VGND sg13cmos5l_a22oi_1
X_06138_ _06140_/C _11579_/Q _11583_/Q _06138_/C VPWR VGND sg13cmos5l_nor3_1
XFILLER_105_579 VPWR VGND sg13cmos5l_decap_8
X_11614__1363 _11614_/RESET_B VPWR VGND sg13cmos5l_tiehi
XFILLER_79_909 VPWR VGND sg13cmos5l_fill_1
XFILLER_78_408 VPWR VGND sg13cmos5l_decap_4
X_06069_ _11755_/D _06066_/Y _06068_/Y _06092_/B VPWR VGND sg13cmos5l_a21oi_1
Xfanout432 fanout432/X _06454_/Y VPWR VGND sg13cmos5l_buf_1
Xfanout421 _09791_/B1 fanout422/X VPWR VGND sg13cmos5l_buf_1
Xfanout410 _09715_/B1 fanout422/X VPWR VGND sg13cmos5l_buf_1
XFILLER_101_730 VPWR VGND sg13cmos5l_fill_1
Xfanout443 _10012_/B _10020_/B VPWR VGND sg13cmos5l_buf_1
Xfanout454 _09576_/B _09491_/S VPWR VGND sg13cmos5l_buf_1
Xfanout465 _09652_/S _09733_/S VPWR VGND sg13cmos5l_buf_1
XFILLER_24_1026 VPWR VGND sg13cmos5l_fill_2
XFILLER_101_785 VPWR VGND sg13cmos5l_fill_1
Xfanout498 _09968_/B _09970_/B VPWR VGND sg13cmos5l_buf_1
Xfanout476 _09962_/B fanout481/X VPWR VGND sg13cmos5l_buf_1
Xfanout487 _06773_/B1 _06400_/Y VPWR VGND sg13cmos5l_buf_1
X_09828_ _09913_/B _10307_/A _09828_/B VPWR VGND sg13cmos5l_nand2_1
XFILLER_104_63 VPWR VGND sg13cmos5l_decap_8
X_09759_ _09759_/Y _10910_/Q _09870_/B _09987_/B1 VPWR VGND sg13cmos5l_a21oi_1
XFILLER_46_338 VPWR VGND sg13cmos5l_decap_8
XFILLER_64_34 VPWR VGND sg13cmos5l_fill_2
XFILLER_61_308 VPWR VGND sg13cmos5l_fill_1
XFILLER_39_390 VPWR VGND sg13cmos5l_fill_2
X_10956__1026 _10956_/RESET_B VPWR VGND sg13cmos5l_tiehi
XFILLER_55_894 VPWR VGND sg13cmos5l_fill_1
XFILLER_27_585 VPWR VGND sg13cmos5l_fill_1
X_11721_ _11721_/Q clkload22/A _11721_/D _11721_/RESET_B VPWR VGND sg13cmos5l_dfrbpq_1
XFILLER_70_875 VPWR VGND sg13cmos5l_decap_8
X_11652_ _11652_/Q _11668_/CLK _11652_/D _11652_/RESET_B VPWR VGND sg13cmos5l_dfrbpq_1
Xfanout50 fanout50/X _07652_/Y VPWR VGND sg13cmos5l_buf_1
Xfanout72 fanout72/X _07593_/Y VPWR VGND sg13cmos5l_buf_1
Xfanout61 fanout61/X _07612_/Y VPWR VGND sg13cmos5l_buf_1
XFILLER_70_1024 VPWR VGND sg13cmos5l_decap_4
X_10603_ _11544_/D _10595_/Y _10600_/Y _10602_/Y VPWR VGND sg13cmos5l_a21oi_1
Xfanout83 fanout83/X _07559_/Y VPWR VGND sg13cmos5l_buf_1
X_11583_ _11583_/Q clkload27/A _11583_/D _11583_/RESET_B VPWR VGND sg13cmos5l_dfrbpq_1
Xfanout94 _09314_/A fanout95/X VPWR VGND sg13cmos5l_buf_1
XFILLER_11_953 VPWR VGND sg13cmos5l_fill_2
X_10534_ _10567_/A _10534_/A _10536_/C VPWR VGND sg13cmos5l_nor2b_1
XFILLER_7_946 VPWR VGND sg13cmos5l_fill_2
X_11245__1656 _11245_/RESET_B VPWR VGND sg13cmos5l_tiehi
XFILLER_13_71 VPWR VGND sg13cmos5l_decap_4
XFILLER_89_42 VPWR VGND sg13cmos5l_decap_8
X_10465_ _10465_/Y _10539_/A _10465_/B VPWR VGND sg13cmos5l_nand2_1
XFILLER_7_979 VPWR VGND sg13cmos5l_decap_8
XFILLER_89_53 VPWR VGND sg13cmos5l_fill_2
X_10396_ _11531_/D _10391_/Y _10392_/Y _10395_/Y _10443_/B1 _10560_/A VPWR VGND sg13cmos5l_a221oi_1
XFILLER_36_8 VPWR VGND sg13cmos5l_fill_2
XFILLER_1_183 VPWR VGND sg13cmos5l_fill_2
X_11017_ _11017_/Q clkload51/A _11017_/D _11017_/RESET_B VPWR VGND sg13cmos5l_dfrbpq_1
XFILLER_77_474 VPWR VGND sg13cmos5l_decap_8
XFILLER_37_327 VPWR VGND sg13cmos5l_decap_4
XFILLER_80_628 VPWR VGND sg13cmos5l_fill_1
XFILLER_64_179 VPWR VGND sg13cmos5l_fill_2
XFILLER_33_511 VPWR VGND sg13cmos5l_decap_4
XFILLER_33_522 VPWR VGND sg13cmos5l_decap_8
XFILLER_73_691 VPWR VGND sg13cmos5l_decap_4
XFILLER_21_706 VPWR VGND sg13cmos5l_decap_4
X_07110_ _11720_/D _05886_/Y _07132_/A2 _07109_/Y VPWR VGND sg13cmos5l_a21oi_1
X_08090_ _08090_/Y _08090_/A _08106_/B VPWR VGND sg13cmos5l_nand2_1
Xclkload20 clkload20/Y clkload20/A VPWR VGND sg13cmos5l_inv_4
XFILLER_86_1020 VPWR VGND sg13cmos5l_decap_8
Xclkload53 clkload53/Y clkload53/A VPWR VGND sg13cmos5l_inv_2
Xclkload31 clkload31/Y clkload31/A VPWR VGND sg13cmos5l_inv_2
Xclkload42 clkload42/Y clkload42/A VPWR VGND sg13cmos5l_inv_2
X_07041_ _07041_/Y _06974_/Y _07040_/Y _07050_/B1 VPWR VGND sg13cmos5l_a21oi_1
XFILLER_6_990 VPWR VGND sg13cmos5l_decap_8
XFILLER_88_717 VPWR VGND sg13cmos5l_fill_1
XFILLER_47_1026 VPWR VGND sg13cmos5l_fill_2
Xhold2804 hold2804/X _11421_/Q VPWR VGND sg13cmos5l_dlygate4sd3_1
X_08992_ _09018_/A _11389_/Q _08992_/B VPWR VGND sg13cmos5l_xnor2_1
Xhold2815 _11549_/D _10677_/Y VPWR VGND sg13cmos5l_dlygate4sd3_1
Xhold2848 hold2848/X _11456_/Q VPWR VGND sg13cmos5l_dlygate4sd3_1
Xhold2826 hold2826/X _11389_/Q VPWR VGND sg13cmos5l_dlygate4sd3_1
X_07943_ _11061_/D _08073_/A1 _07942_/B _07942_/Y VPWR VGND sg13cmos5l_o21ai_1
Xhold2837 hold2837/X _11462_/Q VPWR VGND sg13cmos5l_dlygate4sd3_1
XFILLER_96_783 VPWR VGND sg13cmos5l_fill_2
XFILLER_68_474 VPWR VGND sg13cmos5l_fill_1
Xhold2859 _06197_/A _11489_/Q VPWR VGND sg13cmos5l_dlygate4sd3_1
X_07874_ _11027_/D _08526_/A1 _07881_/B _07873_/Y VPWR VGND sg13cmos5l_a21oi_1
XFILLER_28_305 VPWR VGND sg13cmos5l_decap_4
X_06825_ _06825_/Y _06825_/A _06825_/B VPWR VGND sg13cmos5l_nand2_1
XFILLER_56_625 VPWR VGND sg13cmos5l_decap_8
X_09613_ _09613_/Y _09613_/A _09721_/B VPWR VGND sg13cmos5l_nand2_1
XFILLER_55_157 VPWR VGND sg13cmos5l_fill_1
X_11323__1578 _11323_/RESET_B VPWR VGND sg13cmos5l_tiehi
X_06756_ _06756_/Y _06756_/A _06756_/B VPWR VGND sg13cmos5l_xnor2_1
X_09544_ _09544_/X _10998_/Q _10966_/Q _09544_/S VPWR VGND sg13cmos5l_mux2_1
XFILLER_70_138 VPWR VGND sg13cmos5l_fill_2
XFILLER_52_831 VPWR VGND sg13cmos5l_decap_8
X_09475_ _09475_/Y _11283_/Q _09578_/A2 _09474_/Y VPWR VGND sg13cmos5l_o21ai_1
X_06687_ _06687_/Y _06687_/A _06687_/B VPWR VGND sg13cmos5l_nand2_1
X_08426_ _11298_/D fanout63/X _08433_/B _08425_/Y VPWR VGND sg13cmos5l_a21oi_1
XFILLER_11_205 VPWR VGND sg13cmos5l_decap_4
XFILLER_12_728 VPWR VGND sg13cmos5l_decap_8
X_08357_ _11264_/D fanout72/X _08366_/B _08356_/Y VPWR VGND sg13cmos5l_o21ai_1
Xclkload3 clkload3/X clkload3/A VPWR VGND sg13cmos5l_buf_8
XFILLER_20_761 VPWR VGND sg13cmos5l_decap_8
X_08288_ _11230_/D fanout76/X _08301_/B _08287_/Y VPWR VGND sg13cmos5l_a21oi_1
X_07308_ _08686_/A _08882_/A _07326_/B VPWR VGND sg13cmos5l_nand2_1
XFILLER_20_772 VPWR VGND sg13cmos5l_fill_1
X_07239_ _07239_/Y _10854_/Q _07239_/A2 _07243_/B1 hold2733/X VPWR VGND sg13cmos5l_a22oi_1
XFILLER_106_833 VPWR VGND sg13cmos5l_decap_8
X_10250_ _10255_/B _10250_/A _10250_/B _10289_/A _10250_/D VPWR VGND sg13cmos5l_and4_1
XFILLER_105_321 VPWR VGND sg13cmos5l_decap_8
XFILLER_59_23 VPWR VGND sg13cmos5l_fill_1
XFILLER_3_437 VPWR VGND sg13cmos5l_fill_1
X_10181_ _10181_/Y _05879_/Y _10180_/B _10173_/B VPWR VGND sg13cmos5l_a21oi_1
XFILLER_105_398 VPWR VGND sg13cmos5l_decap_8
Xfanout240 _07760_/B _07750_/B VPWR VGND sg13cmos5l_buf_1
Xfanout273 _07250_/A _07168_/Y VPWR VGND sg13cmos5l_buf_1
Xfanout262 _07482_/B fanout271/X VPWR VGND sg13cmos5l_buf_1
Xfanout251 _07684_/B fanout256/X VPWR VGND sg13cmos5l_buf_1
Xfanout295 _08104_/B _08112_/B VPWR VGND sg13cmos5l_buf_1
Xfanout284 _08372_/B _08374_/B VPWR VGND sg13cmos5l_buf_1
XFILLER_75_22 VPWR VGND sg13cmos5l_fill_2
XFILLER_62_628 VPWR VGND sg13cmos5l_fill_2
XFILLER_61_105 VPWR VGND sg13cmos5l_decap_4
XFILLER_46_168 VPWR VGND sg13cmos5l_decap_8
XFILLER_28_872 VPWR VGND sg13cmos5l_fill_1
XFILLER_91_21 VPWR VGND sg13cmos5l_decap_8
X_11704_ _11704_/Q _11713_/CLK _11704_/D _11704_/RESET_B VPWR VGND sg13cmos5l_dfrbpq_1
XFILLER_43_864 VPWR VGND sg13cmos5l_decap_8
XFILLER_30_536 VPWR VGND sg13cmos5l_decap_4
X_11635_ _11635_/Q clkload31/A _11635_/D _11635_/RESET_B VPWR VGND sg13cmos5l_dfrbpq_1
XFILLER_11_761 VPWR VGND sg13cmos5l_fill_1
XFILLER_30_569 VPWR VGND sg13cmos5l_fill_1
X_11566_ _11566_/Q clkload26/A _11566_/D _11566_/RESET_B VPWR VGND sg13cmos5l_dfrbpq_1
X_10517_ _10534_/A _11412_/Q _10849_/Q VPWR VGND sg13cmos5l_xnor2_1
X_11497_ _11497_/Q clkload15/A _11497_/D _11497_/RESET_B VPWR VGND sg13cmos5l_dfrbpq_1
X_10448_ _10450_/B hold2769/X _09218_/B _10418_/Y VPWR VGND sg13cmos5l_a21oi_1
XFILLER_97_514 VPWR VGND sg13cmos5l_fill_1
X_10379_ _10454_/A _10334_/B _10333_/Y _10378_/Y VPWR VGND sg13cmos5l_o21ai_1
XFILLER_69_238 VPWR VGND sg13cmos5l_fill_2
XFILLER_2_481 VPWR VGND sg13cmos5l_decap_8
XFILLER_78_750 VPWR VGND sg13cmos5l_decap_8
XFILLER_66_923 VPWR VGND sg13cmos5l_decap_8
XFILLER_27_4 VPWR VGND sg13cmos5l_decap_4
XFILLER_93_720 VPWR VGND sg13cmos5l_decap_4
XFILLER_66_978 VPWR VGND sg13cmos5l_decap_8
XFILLER_93_797 VPWR VGND sg13cmos5l_decap_4
XFILLER_80_425 VPWR VGND sg13cmos5l_decap_8
X_07590_ _07591_/B _05860_/Y _11541_/Q _07589_/X VPWR VGND sg13cmos5l_a21oi_1
X_06610_ _06611_/B _06631_/S _06610_/B _06610_/C VPWR VGND sg13cmos5l_nand3_1
XFILLER_52_138 VPWR VGND sg13cmos5l_decap_8
X_06541_ _06542_/B _06571_/B2 _10878_/Q _10862_/Q _06574_/B2 VPWR VGND sg13cmos5l_a22oi_1
XFILLER_80_469 VPWR VGND sg13cmos5l_decap_4
X_09260_ _09260_/Y _09262_/A _10858_/Q VPWR VGND sg13cmos5l_nand2_1
X_06472_ _06473_/C _06468_/Y _06469_/Y _06470_/Y _06471_/Y _06474_/A VPWR VGND sg13cmos5l_a221oi_1
X_08211_ _11192_/D _08471_/A1 _08216_/B _08210_/Y VPWR VGND sg13cmos5l_o21ai_1
XFILLER_21_547 VPWR VGND sg13cmos5l_fill_1
XFILLER_33_396 VPWR VGND sg13cmos5l_decap_8
X_09191_ _09344_/A _09180_/Y _09340_/B _09179_/Y VPWR VGND sg13cmos5l_o21ai_1
XFILLER_21_558 VPWR VGND sg13cmos5l_fill_1
X_08142_ _11158_/D _08337_/A1 _08141_/B _08141_/Y VPWR VGND sg13cmos5l_a21oi_1
X_08073_ _11125_/D _08073_/A1 _08078_/B _08072_/Y VPWR VGND sg13cmos5l_o21ai_1
X_07024_ _07024_/Y _07024_/A _07024_/B VPWR VGND sg13cmos5l_nor2_1
XFILLER_102_302 VPWR VGND sg13cmos5l_decap_4
XFILLER_0_418 VPWR VGND sg13cmos5l_decap_4
XFILLER_102_346 VPWR VGND sg13cmos5l_fill_2
XFILLER_88_536 VPWR VGND sg13cmos5l_decap_4
Xhold2612 _11613_/D _06842_/Y VPWR VGND sg13cmos5l_dlygate4sd3_1
Xhold2601 _07193_/A _11711_/Q VPWR VGND sg13cmos5l_dlygate4sd3_1
X_08975_ _08975_/Y _08975_/A VPWR VGND sg13cmos5l_inv_1
Xhold1911 _07848_/A _11016_/Q VPWR VGND sg13cmos5l_dlygate4sd3_1
Xhold1900 _08232_/A _11203_/Q VPWR VGND sg13cmos5l_dlygate4sd3_1
Xhold2634 _11749_/D _06021_/Y VPWR VGND sg13cmos5l_dlygate4sd3_1
Xhold2656 hold2656/X _11612_/Q VPWR VGND sg13cmos5l_dlygate4sd3_1
Xhold2645 hold2645/X _11722_/Q VPWR VGND sg13cmos5l_dlygate4sd3_1
XFILLER_69_761 VPWR VGND sg13cmos5l_decap_8
Xhold2623 _10830_/D _07174_/Y VPWR VGND sg13cmos5l_dlygate4sd3_1
X_07926_ _07926_/Y _07926_/A _07940_/B VPWR VGND sg13cmos5l_nand2_1
XFILLER_84_720 VPWR VGND sg13cmos5l_fill_1
Xhold1933 _08084_/A _11131_/Q VPWR VGND sg13cmos5l_dlygate4sd3_1
Xhold2667 hold2667/X _11707_/Q VPWR VGND sg13cmos5l_dlygate4sd3_1
Xhold2689 hold2689/X _11718_/Q VPWR VGND sg13cmos5l_dlygate4sd3_1
Xhold2678 hold2678/X _11702_/Q VPWR VGND sg13cmos5l_dlygate4sd3_1
XFILLER_57_934 VPWR VGND sg13cmos5l_decap_4
Xhold1944 _07800_/A _10992_/Q VPWR VGND sg13cmos5l_dlygate4sd3_1
XFILLER_21_1018 VPWR VGND sg13cmos5l_fill_1
XFILLER_29_636 VPWR VGND sg13cmos5l_decap_4
Xhold1922 _08340_/A _11256_/Q VPWR VGND sg13cmos5l_dlygate4sd3_1
Xhold1988 _08112_/A _11145_/Q VPWR VGND sg13cmos5l_dlygate4sd3_1
X_07857_ _07857_/Y _07857_/A _07913_/B VPWR VGND sg13cmos5l_nor2_1
XFILLER_84_775 VPWR VGND sg13cmos5l_fill_2
Xhold1955 _07930_/A _11055_/Q VPWR VGND sg13cmos5l_dlygate4sd3_1
Xhold1977 _08448_/A _11309_/Q VPWR VGND sg13cmos5l_dlygate4sd3_1
Xhold1966 _08196_/A _11185_/Q VPWR VGND sg13cmos5l_dlygate4sd3_1
XFILLER_29_669 VPWR VGND sg13cmos5l_decap_4
X_07788_ _07788_/Y _07788_/A _07846_/B VPWR VGND sg13cmos5l_nand2_1
X_06808_ _06808_/Y _06875_/A _06807_/Y _06806_/Y VPWR VGND sg13cmos5l_o21ai_1
XFILLER_44_639 VPWR VGND sg13cmos5l_fill_2
Xhold1999 _07824_/A _11004_/Q VPWR VGND sg13cmos5l_dlygate4sd3_1
XFILLER_16_308 VPWR VGND sg13cmos5l_decap_8
XFILLER_28_179 VPWR VGND sg13cmos5l_fill_1
X_09527_ _09527_/X _11253_/Q _11221_/Q _11189_/Q _11157_/Q _09652_/S _06477_/B VPWR
+ VGND sg13cmos5l_mux4_1
X_06739_ _06739_/Y _06739_/A _10270_/A _06739_/C VPWR VGND sg13cmos5l_nor3_1
XFILLER_101_42 VPWR VGND sg13cmos5l_decap_8
XFILLER_40_812 VPWR VGND sg13cmos5l_fill_2
XFILLER_52_683 VPWR VGND sg13cmos5l_decap_8
X_09458_ _09458_/Y hold2777/X _09404_/B _09379_/C _09457_/Y VPWR VGND sg13cmos5l_a22oi_1
X_08409_ _08409_/Y _08409_/A _08415_/B VPWR VGND sg13cmos5l_nor2_1
X_09389_ _09389_/Y _10992_/Q _09492_/B _09575_/S1 VPWR VGND sg13cmos5l_a21oi_1
X_11420_ _11420_/Q clkload53/A _11420_/D _11420_/RESET_B VPWR VGND sg13cmos5l_dfrbpq_1
XFILLER_61_79 VPWR VGND sg13cmos5l_decap_8
X_11351_ _11351_/Q clkload16/A _11351_/D _11351_/RESET_B VPWR VGND sg13cmos5l_dfrbpq_1
X_10302_ _10302_/Y _10293_/B _10293_/C _10293_/A VPWR VGND sg13cmos5l_o21ai_1
XFILLER_4_724 VPWR VGND sg13cmos5l_fill_2
XFILLER_4_702 VPWR VGND sg13cmos5l_fill_2
XFILLER_3_201 VPWR VGND sg13cmos5l_decap_8
XFILLER_106_630 VPWR VGND sg13cmos5l_decap_8
X_11282_ _11282_/Q clkload17/A _11282_/D _11282_/RESET_B VPWR VGND sg13cmos5l_dfrbpq_1
XFILLER_105_140 VPWR VGND sg13cmos5l_decap_8
XFILLER_79_525 VPWR VGND sg13cmos5l_decap_4
X_10233_ _10233_/Y _10694_/A _10233_/B VPWR VGND sg13cmos5l_nor2_1
XFILLER_86_21 VPWR VGND sg13cmos5l_decap_8
X_10164_ _10164_/Y _10694_/A _10164_/B VPWR VGND sg13cmos5l_nand2_1
X_11655__1309 _11655_/RESET_B VPWR VGND sg13cmos5l_tiehi
XFILLER_87_591 VPWR VGND sg13cmos5l_fill_1
XFILLER_59_260 VPWR VGND sg13cmos5l_decap_4
XFILLER_0_985 VPWR VGND sg13cmos5l_decap_8
X_10095_ _10095_/Y _10330_/B _10842_/Q _10131_/A2 VPWR VGND sg13cmos5l_o21ai_1
XFILLER_101_390 VPWR VGND sg13cmos5l_fill_2
XFILLER_48_978 VPWR VGND sg13cmos5l_fill_2
XFILLER_47_433 VPWR VGND sg13cmos5l_decap_8
XFILLER_63_926 VPWR VGND sg13cmos5l_decap_4
XFILLER_47_466 VPWR VGND sg13cmos5l_decap_8
XFILLER_74_296 VPWR VGND sg13cmos5l_decap_8
XFILLER_62_458 VPWR VGND sg13cmos5l_decap_8
XFILLER_90_789 VPWR VGND sg13cmos5l_decap_4
XFILLER_90_778 VPWR VGND sg13cmos5l_fill_2
XFILLER_71_970 VPWR VGND sg13cmos5l_fill_2
XFILLER_37_1003 VPWR VGND sg13cmos5l_fill_1
X_10997_ _10997_/Q clkload40/A _10997_/D _10997_/RESET_B VPWR VGND sg13cmos5l_dfrbpq_1
XFILLER_27_190 VPWR VGND sg13cmos5l_fill_2
XFILLER_96_7 VPWR VGND sg13cmos5l_decap_8
XFILLER_43_694 VPWR VGND sg13cmos5l_decap_4
XFILLER_42_182 VPWR VGND sg13cmos5l_decap_8
XFILLER_42_193 VPWR VGND sg13cmos5l_fill_2
X_11506__1171 _11506_/RESET_B VPWR VGND sg13cmos5l_tiehi
X_11618_ _11618_/Q _11622_/CLK _11618_/D _11618_/RESET_B VPWR VGND sg13cmos5l_dfrbpq_1
X_10804__941 _10804_/RESET_B VPWR VGND sg13cmos5l_tiehi
X_11549_ _11549_/Q clkload46/A _11549_/D _11549_/RESET_B VPWR VGND sg13cmos5l_dfrbpq_1
XFILLER_98_812 VPWR VGND sg13cmos5l_fill_2
X_10951__1031 _10951_/RESET_B VPWR VGND sg13cmos5l_tiehi
XFILLER_32_2 VPWR VGND sg13cmos5l_fill_1
X_08760_ _08761_/A hold2619/X _09093_/B _09118_/A _09106_/B1 VPWR VGND sg13cmos5l_a22oi_1
X_05972_ _05972_/Y _05972_/A VPWR VGND sg13cmos5l_inv_1
XFILLER_57_219 VPWR VGND sg13cmos5l_decap_8
XFILLER_38_422 VPWR VGND sg13cmos5l_fill_2
XFILLER_66_764 VPWR VGND sg13cmos5l_decap_8
X_07711_ _10949_/D fanout57/X _07712_/B _07710_/Y VPWR VGND sg13cmos5l_a21oi_1
X_08691_ _08930_/A _08896_/B VPWR VGND sg13cmos5l_inv_1
XFILLER_18_0 VPWR VGND sg13cmos5l_fill_2
XFILLER_81_723 VPWR VGND sg13cmos5l_decap_4
X_07642_ _08766_/B _11549_/Q _10824_/Q _07642_/S VPWR VGND sg13cmos5l_mux2_1
XFILLER_66_775 VPWR VGND sg13cmos5l_fill_1
X_11240__1661 _11240_/RESET_B VPWR VGND sg13cmos5l_tiehi
XFILLER_80_255 VPWR VGND sg13cmos5l_fill_1
X_09312_ _09313_/A _10171_/A hold2774/X _09303_/D VPWR VGND sg13cmos5l_o21ai_1
X_07573_ _10909_/D _07595_/B fanout79/X _07572_/Y VPWR VGND sg13cmos5l_a21oi_1
X_06524_ _06525_/D _10162_/A _11372_/Q _06524_/C VPWR VGND sg13cmos5l_nand3_1
XFILLER_40_119 VPWR VGND sg13cmos5l_decap_4
XFILLER_21_311 VPWR VGND sg13cmos5l_fill_1
X_06455_ _06455_/X _10644_/B1 _11631_/Q _06453_/X VPWR VGND sg13cmos5l_a21o_1
X_09243_ _09862_/A _09171_/Y _09244_/A VPWR VGND sg13cmos5l_nand2b_1
X_06386_ _06387_/B _06264_/B _06266_/Y _06261_/Y VPWR VGND sg13cmos5l_o21ai_1
XFILLER_21_377 VPWR VGND sg13cmos5l_decap_8
X_09174_ _09174_/X _09429_/A _10835_/Q VPWR VGND sg13cmos5l_and2_1
X_08125_ _08125_/Y _08125_/A _08135_/B VPWR VGND sg13cmos5l_nor2_1
XFILLER_31_27 VPWR VGND sg13cmos5l_fill_1
X_08056_ _08056_/Y _08056_/A _08074_/B VPWR VGND sg13cmos5l_nand2_1
XFILLER_89_812 VPWR VGND sg13cmos5l_fill_2
XFILLER_89_801 VPWR VGND sg13cmos5l_fill_2
X_07007_ _10469_/C _07007_/A _10171_/B VPWR VGND sg13cmos5l_or2_1
Xoutput38 uo_out[14] _06572_/Y VPWR VGND sg13cmos5l_buf_1
Xoutput27 uio_out[4] _12765_/X VPWR VGND sg13cmos5l_buf_1
XFILLER_88_333 VPWR VGND sg13cmos5l_decap_8
XFILLER_88_322 VPWR VGND sg13cmos5l_decap_4
XFILLER_102_154 VPWR VGND sg13cmos5l_decap_8
XFILLER_88_344 VPWR VGND sg13cmos5l_decap_8
Xhold2431 _10703_/B _11751_/Q VPWR VGND sg13cmos5l_dlygate4sd3_1
Xhold2420 _07627_/A _10917_/Q VPWR VGND sg13cmos5l_dlygate4sd3_1
XFILLER_103_688 VPWR VGND sg13cmos5l_fill_2
Xhold2453 _07178_/A _11694_/Q VPWR VGND sg13cmos5l_dlygate4sd3_1
Xhold2442 _07181_/A _11695_/Q VPWR VGND sg13cmos5l_dlygate4sd3_1
Xhold2464 _11759_/D _06131_/Y VPWR VGND sg13cmos5l_dlygate4sd3_1
X_08958_ _08958_/Y _08956_/Y _08957_/Y _08948_/Y VPWR VGND sg13cmos5l_o21ai_1
XFILLER_5_1001 VPWR VGND sg13cmos5l_decap_8
Xhold2486 _11582_/D _10766_/X VPWR VGND sg13cmos5l_dlygate4sd3_1
Xhold2475 _10729_/A _10727_/Y VPWR VGND sg13cmos5l_dlygate4sd3_1
X_07909_ _07909_/Y _07909_/A _07909_/B VPWR VGND sg13cmos5l_nor2_1
XFILLER_56_230 VPWR VGND sg13cmos5l_decap_4
X_08889_ _08889_/X _08889_/A _08889_/B VPWR VGND sg13cmos5l_and2_1
Xhold2497 _11658_/D _06985_/X VPWR VGND sg13cmos5l_dlygate4sd3_1
X_10920_ _10920_/Q clkload51/A _10920_/D _10920_/RESET_B VPWR VGND sg13cmos5l_dfrbpq_1
XFILLER_45_948 VPWR VGND sg13cmos5l_fill_1
XFILLER_72_767 VPWR VGND sg13cmos5l_fill_1
XFILLER_71_244 VPWR VGND sg13cmos5l_fill_2
X_10851_ _10851_/Q _11715_/CLK _10851_/D _10851_/RESET_B VPWR VGND sg13cmos5l_dfrbpq_1
X_10782_ _10782_/Y _10782_/A _10791_/B VPWR VGND sg13cmos5l_nand2_1
XFILLER_71_299 VPWR VGND sg13cmos5l_fill_1
XFILLER_40_620 VPWR VGND sg13cmos5l_decap_8
XFILLER_9_805 VPWR VGND sg13cmos5l_decap_4
XFILLER_8_337 VPWR VGND sg13cmos5l_fill_1
XFILLER_8_304 VPWR VGND sg13cmos5l_decap_8
XFILLER_9_849 VPWR VGND sg13cmos5l_fill_1
X_11709__1255 _11709_/RESET_B VPWR VGND sg13cmos5l_tiehi
X_11403_ _11403_/Q clkload20/A _11403_/D _11403_/RESET_B VPWR VGND sg13cmos5l_dfrbpq_1
X_11103__1798 _11103_/RESET_B VPWR VGND sg13cmos5l_tiehi
XFILLER_99_609 VPWR VGND sg13cmos5l_fill_1
X_11334_ _11334_/Q clkload53/A _11334_/D _11334_/RESET_B VPWR VGND sg13cmos5l_dfrbpq_1
XFILLER_98_119 VPWR VGND sg13cmos5l_decap_8
X_11265_ _11265_/Q _11265_/CLK _11265_/D _11265_/RESET_B VPWR VGND sg13cmos5l_dfrbpq_1
XFILLER_97_42 VPWR VGND sg13cmos5l_decap_8
X_10216_ _10216_/Y hold2834/X _10172_/Y _10173_/Y hold2753/X _10226_/C1 VPWR VGND
+ sg13cmos5l_a221oi_1
X_11282__1619 _11282_/RESET_B VPWR VGND sg13cmos5l_tiehi
X_11196_ _11196_/Q _11356_/CLK _11196_/D _11196_/RESET_B VPWR VGND sg13cmos5l_dfrbpq_1
XFILLER_95_848 VPWR VGND sg13cmos5l_fill_1
X_10147_ _10147_/Y _05935_/A _09996_/B _10146_/Y VPWR VGND sg13cmos5l_a21oi_1
XFILLER_67_528 VPWR VGND sg13cmos5l_fill_1
XFILLER_0_782 VPWR VGND sg13cmos5l_fill_1
XFILLER_11_7 VPWR VGND sg13cmos5l_decap_8
X_10078_ _10078_/X _10070_/A _09428_/Y _10077_/Y VPWR VGND sg13cmos5l_a21o_1
XFILLER_63_712 VPWR VGND sg13cmos5l_fill_1
XFILLER_90_531 VPWR VGND sg13cmos5l_fill_1
XFILLER_51_918 VPWR VGND sg13cmos5l_fill_1
XFILLER_50_406 VPWR VGND sg13cmos5l_decap_4
XFILLER_44_970 VPWR VGND sg13cmos5l_fill_2
XFILLER_90_597 VPWR VGND sg13cmos5l_fill_1
Xclkbuf_0_clk clkbuf_0_clk/X clk VPWR VGND sg13cmos5l_buf_8
XFILLER_31_653 VPWR VGND sg13cmos5l_decap_4
X_10969__1013 _10969_/RESET_B VPWR VGND sg13cmos5l_tiehi
X_06240_ _06272_/C _06240_/A VPWR VGND sg13cmos5l_inv_1
XFILLER_8_882 VPWR VGND sg13cmos5l_fill_1
XFILLER_11_1028 VPWR VGND sg13cmos5l_fill_1
X_06171_ _06171_/Y _06172_/A _09205_/A VPWR VGND sg13cmos5l_nand2_1
XFILLER_7_392 VPWR VGND sg13cmos5l_fill_2
X_09930_ _09931_/B _09926_/Y _09927_/Y _09928_/Y _09929_/Y _06476_/A VPWR VGND sg13cmos5l_a221oi_1
Xfanout806 _08645_/A1 hold2927/X VPWR VGND sg13cmos5l_buf_1
XFILLER_97_152 VPWR VGND sg13cmos5l_fill_2
Xfanout817 _10739_/A _10560_/A VPWR VGND sg13cmos5l_buf_1
Xfanout828 _10751_/A _10326_/A VPWR VGND sg13cmos5l_buf_1
X_09861_ _11479_/D _09885_/A _09915_/A _09839_/Y _09860_/Y VPWR VGND sg13cmos5l_a22oi_1
X_11258__1643 _11258_/RESET_B VPWR VGND sg13cmos5l_tiehi
XFILLER_100_625 VPWR VGND sg13cmos5l_decap_8
X_09792_ _09792_/Y _10943_/Q _10041_/B VPWR VGND sg13cmos5l_nand2_1
XFILLER_97_163 VPWR VGND sg13cmos5l_fill_1
X_08812_ _08812_/X _11379_/Q _08817_/D VPWR VGND sg13cmos5l_and2_1
X_08743_ _08744_/A hold2768/X _09093_/B _09068_/B _09106_/B1 VPWR VGND sg13cmos5l_a22oi_1
X_05955_ _05955_/Y _10832_/Q VPWR VGND sg13cmos5l_inv_1
XFILLER_39_742 VPWR VGND sg13cmos5l_decap_8
XFILLER_39_786 VPWR VGND sg13cmos5l_decap_4
XFILLER_27_926 VPWR VGND sg13cmos5l_fill_2
X_05886_ _05886_/Y input12/X VPWR VGND sg13cmos5l_inv_1
X_08674_ _11399_/D _08674_/A VPWR VGND sg13cmos5l_inv_1
XFILLER_26_414 VPWR VGND sg13cmos5l_decap_4
XFILLER_27_948 VPWR VGND sg13cmos5l_decap_8
X_07625_ _07625_/Y _07643_/D _07624_/Y VPWR VGND sg13cmos5l_nor2b_1
XFILLER_41_406 VPWR VGND sg13cmos5l_fill_2
XFILLER_14_609 VPWR VGND sg13cmos5l_decap_8
X_07556_ _07556_/Y _11409_/Q _10477_/A _07562_/D VPWR VGND sg13cmos5l_nand3_1
X_06507_ _06507_/Y _06507_/A _10164_/B _06507_/C VPWR VGND sg13cmos5l_nor3_1
XFILLER_22_631 VPWR VGND sg13cmos5l_fill_2
X_09226_ _09226_/Y _09217_/A _10844_/Q _09225_/Y VPWR VGND sg13cmos5l_a21oi_1
X_07487_ _07487_/Y _07493_/A _07484_/X _07486_/Y VPWR VGND sg13cmos5l_a21oi_1
X_06438_ _10824_/D _06244_/Y _06435_/Y _06437_/Y VPWR VGND sg13cmos5l_o21ai_1
X_09157_ _09272_/A _09268_/A _09157_/B VPWR VGND sg13cmos5l_nand2_1
X_06369_ _06374_/A _06721_/A _06713_/A VPWR VGND sg13cmos5l_nand2_1
X_08108_ _08108_/Y _08108_/A _08108_/B VPWR VGND sg13cmos5l_nand2_1
X_09088_ _09088_/X _09102_/A _09103_/A VPWR VGND sg13cmos5l_xor2_1
X_08039_ _08039_/Y _08039_/A _08041_/B VPWR VGND sg13cmos5l_nor2_1
XFILLER_104_964 VPWR VGND sg13cmos5l_decap_8
X_11050_ _11050_/Q _11646_/CLK _11050_/D _11050_/RESET_B VPWR VGND sg13cmos5l_dfrbpq_1
XFILLER_77_815 VPWR VGND sg13cmos5l_decap_8
XFILLER_77_826 VPWR VGND sg13cmos5l_fill_2
X_10001_ _10002_/C _09909_/Y _09998_/Y _10000_/Y VPWR VGND sg13cmos5l_o21ai_1
XFILLER_67_56 VPWR VGND sg13cmos5l_fill_1
XFILLER_67_45 VPWR VGND sg13cmos5l_decap_8
XFILLER_67_34 VPWR VGND sg13cmos5l_fill_1
Xhold2272 _07776_/A _10981_/Q VPWR VGND sg13cmos5l_dlygate4sd3_1
Xhold2250 _07738_/A _10962_/Q VPWR VGND sg13cmos5l_dlygate4sd3_1
Xhold2261 _07891_/A _11036_/Q VPWR VGND sg13cmos5l_dlygate4sd3_1
XFILLER_45_701 VPWR VGND sg13cmos5l_decap_4
Xhold2294 _08834_/A _11430_/Q VPWR VGND sg13cmos5l_dlygate4sd3_1
Xhold2283 _08403_/A _11287_/Q VPWR VGND sg13cmos5l_dlygate4sd3_1
XFILLER_45_734 VPWR VGND sg13cmos5l_decap_4
XFILLER_72_542 VPWR VGND sg13cmos5l_fill_1
XFILLER_60_704 VPWR VGND sg13cmos5l_decap_8
XFILLER_45_789 VPWR VGND sg13cmos5l_decap_8
X_10903_ _10903_/Q _11347_/CLK _10903_/D _10903_/RESET_B VPWR VGND sg13cmos5l_dfrbpq_1
XFILLER_33_918 VPWR VGND sg13cmos5l_decap_8
X_10834_ _10834_/Q clkload21/A _10834_/D _10834_/RESET_B VPWR VGND sg13cmos5l_dfrbpq_1
X_10765_ _10765_/X hold2501/X _06933_/B _07189_/X VPWR VGND sg13cmos5l_a21o_1
X_11336__1565 _11336_/RESET_B VPWR VGND sg13cmos5l_tiehi
X_10696_ _10696_/Y _10696_/A _10696_/B VPWR VGND sg13cmos5l_nand2_1
XFILLER_9_646 VPWR VGND sg13cmos5l_fill_1
XFILLER_8_167 VPWR VGND sg13cmos5l_fill_2
X_11317_ _11317_/Q _11352_/CLK _11317_/D _11317_/RESET_B VPWR VGND sg13cmos5l_dfrbpq_1
X_11248_ _11248_/Q _11668_/CLK _11248_/D _11248_/RESET_B VPWR VGND sg13cmos5l_dfrbpq_1
X_11179_ _11179_/Q clkload32/A _11179_/D _11179_/RESET_B VPWR VGND sg13cmos5l_dfrbpq_1
XFILLER_95_612 VPWR VGND sg13cmos5l_decap_4
XFILLER_83_818 VPWR VGND sg13cmos5l_decap_8
XFILLER_76_892 VPWR VGND sg13cmos5l_fill_2
XFILLER_75_391 VPWR VGND sg13cmos5l_decap_8
XFILLER_35_211 VPWR VGND sg13cmos5l_fill_2
X_07410_ _08759_/A _09108_/A _07416_/B VPWR VGND sg13cmos5l_nand2_1
XFILLER_51_726 VPWR VGND sg13cmos5l_decap_8
X_08390_ _11280_/D _08520_/A1 _08403_/B _08389_/Y VPWR VGND sg13cmos5l_a21oi_1
X_07341_ _07341_/Y _07341_/A _07383_/B VPWR VGND sg13cmos5l_nor2_1
XFILLER_85_0 VPWR VGND sg13cmos5l_decap_8
X_07272_ _07272_/Y _08811_/A _07296_/B VPWR VGND sg13cmos5l_nand2_1
X_09011_ _09011_/Y _09051_/A1 _09010_/Y _09030_/A1 VPWR VGND sg13cmos5l_o21ai_1
X_06223_ _06741_/A _06223_/A _06223_/B VPWR VGND sg13cmos5l_nand2_1
X_11650__1314 _11650_/RESET_B VPWR VGND sg13cmos5l_tiehi
X_06154_ _06670_/A _11499_/Q _09214_/A VPWR VGND sg13cmos5l_nor2_1
XFILLER_105_717 VPWR VGND sg13cmos5l_decap_8
XFILLER_104_238 VPWR VGND sg13cmos5l_decap_8
X_06085_ _09910_/A _06085_/A _09301_/S VPWR VGND sg13cmos5l_and2_1
Xfanout614 _09731_/A _06009_/X VPWR VGND sg13cmos5l_buf_1
X_09913_ _09913_/Y _09998_/A _09913_/B _09913_/C VPWR VGND sg13cmos5l_nand3_1
Xfanout603 _08922_/A _08946_/B1 VPWR VGND sg13cmos5l_buf_1
XFILLER_99_984 VPWR VGND sg13cmos5l_decap_8
Xfanout636 _06631_/S _05893_/Y VPWR VGND sg13cmos5l_buf_1
Xfanout625 _07227_/B1 _06038_/C VPWR VGND sg13cmos5l_buf_1
Xfanout658 _10547_/A2 fanout661/X VPWR VGND sg13cmos5l_buf_1
Xfanout647 _06133_/A _06562_/A1 VPWR VGND sg13cmos5l_buf_1
X_09844_ _09844_/Y _09848_/B1 _09840_/X _09843_/Y VPWR VGND sg13cmos5l_o21ai_1
XFILLER_101_967 VPWR VGND sg13cmos5l_decap_8
XFILLER_86_667 VPWR VGND sg13cmos5l_fill_1
XFILLER_85_133 VPWR VGND sg13cmos5l_fill_1
XFILLER_58_325 VPWR VGND sg13cmos5l_decap_4
Xfanout669 _06505_/A _11754_/Q VPWR VGND sg13cmos5l_buf_1
XFILLER_67_870 VPWR VGND sg13cmos5l_decap_8
X_09775_ _09779_/B _09775_/A _09775_/B VPWR VGND sg13cmos5l_nand2_1
X_06987_ _06987_/Y _06990_/B1 _11498_/Q VPWR VGND sg13cmos5l_nand2b_1
XFILLER_2_1004 VPWR VGND sg13cmos5l_decap_8
X_05938_ _06060_/B _08607_/B VPWR VGND sg13cmos5l_inv_1
X_08726_ _08727_/B _08730_/A _08726_/B VPWR VGND sg13cmos5l_nand2_1
XFILLER_27_745 VPWR VGND sg13cmos5l_decap_8
XFILLER_82_851 VPWR VGND sg13cmos5l_fill_2
X_08657_ _11394_/D _08657_/A VPWR VGND sg13cmos5l_inv_1
XFILLER_26_255 VPWR VGND sg13cmos5l_decap_8
X_05869_ _07521_/A _11404_/Q VPWR VGND sg13cmos5l_inv_1
X_07608_ _10914_/D _07607_/B fanout63/X _07607_/Y VPWR VGND sg13cmos5l_a21oi_1
XFILLER_54_597 VPWR VGND sg13cmos5l_decap_4
XFILLER_54_575 VPWR VGND sg13cmos5l_decap_4
XFILLER_53_14 VPWR VGND sg13cmos5l_decap_8
X_11429__1432 _11429_/RESET_B VPWR VGND sg13cmos5l_tiehi
X_08588_ _08588_/Y _11083_/Q _08588_/B VPWR VGND sg13cmos5l_nand2_1
X_07539_ _07539_/X _07582_/S _10809_/Q VPWR VGND sg13cmos5l_and2_1
X_10550_ _10550_/X _11414_/Q _10551_/B VPWR VGND sg13cmos5l_and2_1
X_10481_ _10481_/Y _10481_/A _10481_/B VPWR VGND sg13cmos5l_xnor2_1
X_09209_ _09209_/Y _11466_/Q _10839_/Q _10840_/Q _09559_/A VPWR VGND sg13cmos5l_a22oi_1
XFILLER_5_148 VPWR VGND sg13cmos5l_decap_4
XFILLER_78_33 VPWR VGND sg13cmos5l_fill_1
XFILLER_2_811 VPWR VGND sg13cmos5l_decap_8
X_11102_ _11102_/Q clkload58/A _11102_/D _11102_/RESET_B VPWR VGND sg13cmos5l_dfrbpq_1
XFILLER_78_99 VPWR VGND sg13cmos5l_fill_1
XFILLER_77_612 VPWR VGND sg13cmos5l_decap_8
XFILLER_2_877 VPWR VGND sg13cmos5l_fill_2
X_11033_ _11033_/Q clkload41/A _11033_/D _11033_/RESET_B VPWR VGND sg13cmos5l_dfrbpq_1
XFILLER_94_21 VPWR VGND sg13cmos5l_decap_8
Xhold2080 _11573_/D _10756_/Y VPWR VGND sg13cmos5l_dlygate4sd3_1
XFILLER_77_689 VPWR VGND sg13cmos5l_decap_4
XFILLER_64_306 VPWR VGND sg13cmos5l_fill_1
Xhold2091 _10789_/A _11594_/Q VPWR VGND sg13cmos5l_dlygate4sd3_1
XFILLER_45_531 VPWR VGND sg13cmos5l_decap_4
XFILLER_27_81 VPWR VGND sg13cmos5l_decap_8
XFILLER_33_737 VPWR VGND sg13cmos5l_fill_1
XFILLER_60_556 VPWR VGND sg13cmos5l_decap_8
XFILLER_60_534 VPWR VGND sg13cmos5l_fill_2
XFILLER_14_940 VPWR VGND sg13cmos5l_fill_2
XFILLER_60_589 VPWR VGND sg13cmos5l_decap_8
X_10817_ _10817_/Q clkload48/A _10817_/D _10817_/RESET_B VPWR VGND sg13cmos5l_dfrbpq_1
XFILLER_14_984 VPWR VGND sg13cmos5l_decap_4
X_10748_ _10748_/Y _10748_/A _10748_/B VPWR VGND sg13cmos5l_nand2_1
XFILLER_43_80 VPWR VGND sg13cmos5l_decap_8
X_10679_ _10680_/B _10679_/A _10679_/B VPWR VGND sg13cmos5l_xnor2_1
XFILLER_57_4 VPWR VGND sg13cmos5l_decap_4
XFILLER_99_214 VPWR VGND sg13cmos5l_decap_4
XFILLER_5_671 VPWR VGND sg13cmos5l_fill_1
X_06910_ _06910_/X _11716_/Q hold2701/X _06917_/B VPWR VGND sg13cmos5l_mux2_1
XFILLER_68_623 VPWR VGND sg13cmos5l_fill_2
XFILLER_95_420 VPWR VGND sg13cmos5l_fill_1
XFILLER_68_634 VPWR VGND sg13cmos5l_decap_8
X_07890_ _11035_/D fanout82/X _07909_/B _07889_/Y VPWR VGND sg13cmos5l_a21oi_1
X_06841_ _06841_/Y _06841_/A VPWR VGND sg13cmos5l_inv_1
XFILLER_68_689 VPWR VGND sg13cmos5l_fill_1
XFILLER_56_818 VPWR VGND sg13cmos5l_decap_8
XFILLER_49_870 VPWR VGND sg13cmos5l_fill_1
XFILLER_95_486 VPWR VGND sg13cmos5l_fill_1
X_06772_ _06772_/X _06387_/Y _06390_/Y _06772_/S VPWR VGND sg13cmos5l_mux2_1
XFILLER_55_328 VPWR VGND sg13cmos5l_decap_4
X_09560_ _09560_/Y _09722_/A _09560_/B _09642_/B VPWR VGND sg13cmos5l_nor3_1
XFILLER_36_542 VPWR VGND sg13cmos5l_fill_1
X_09491_ _09491_/X _10996_/Q _10964_/Q _09491_/S VPWR VGND sg13cmos5l_mux2_1
X_08511_ _08511_/Y _08511_/A _08529_/B VPWR VGND sg13cmos5l_nor2_1
X_08442_ _08442_/Y _08442_/A _08494_/B VPWR VGND sg13cmos5l_nand2_1
X_11704__1260 _11704_/RESET_B VPWR VGND sg13cmos5l_tiehi
XFILLER_51_523 VPWR VGND sg13cmos5l_decap_8
XFILLER_51_534 VPWR VGND sg13cmos5l_fill_1
XFILLER_23_247 VPWR VGND sg13cmos5l_fill_1
X_08373_ _11272_/D fanout52/X _08372_/B _08372_/Y VPWR VGND sg13cmos5l_o21ai_1
XFILLER_17_1012 VPWR VGND sg13cmos5l_decap_8
X_07324_ _07324_/Y _07425_/B _07322_/Y _07323_/Y VPWR VGND sg13cmos5l_a21oi_1
X_07255_ _07255_/Y _07253_/Y _07254_/Y _06956_/B VPWR VGND sg13cmos5l_a21oi_1
XFILLER_20_954 VPWR VGND sg13cmos5l_fill_1
XFILLER_20_987 VPWR VGND sg13cmos5l_fill_1
X_06206_ _06207_/D _06628_/A _06620_/A _06590_/A VPWR VGND sg13cmos5l_nand3_1
X_07186_ _07186_/Y _10776_/A _07186_/B _07190_/C VPWR VGND sg13cmos5l_nand3_1
X_06137_ _06138_/C _11580_/Q _11581_/Q VPWR VGND sg13cmos5l_nand2_1
XFILLER_2_118 VPWR VGND sg13cmos5l_decap_4
XFILLER_105_558 VPWR VGND sg13cmos5l_decap_8
X_06068_ _06068_/Y _10709_/A _06071_/A _06065_/Y VPWR VGND sg13cmos5l_a21oi_1
XFILLER_99_770 VPWR VGND sg13cmos5l_decap_8
Xfanout422 fanout422/X _06455_/X VPWR VGND sg13cmos5l_buf_1
Xfanout400 _10043_/C1 _09983_/C1 VPWR VGND sg13cmos5l_buf_1
Xfanout411 _09848_/B1 _09659_/S1 VPWR VGND sg13cmos5l_buf_1
XFILLER_98_291 VPWR VGND sg13cmos5l_decap_8
Xfanout444 _10020_/B fanout451/X VPWR VGND sg13cmos5l_buf_1
XFILLER_59_645 VPWR VGND sg13cmos5l_fill_2
Xfanout433 _09492_/B _09570_/B VPWR VGND sg13cmos5l_buf_1
Xfanout455 _09491_/S _09499_/B VPWR VGND sg13cmos5l_buf_1
Xfanout466 _09733_/S _09659_/S0 VPWR VGND sg13cmos5l_buf_1
X_09827_ _09827_/Y _09818_/Y _09820_/Y _09826_/Y VPWR VGND sg13cmos5l_a21oi_1
XFILLER_87_998 VPWR VGND sg13cmos5l_decap_4
Xfanout477 _09814_/S _09824_/A2 VPWR VGND sg13cmos5l_buf_1
XFILLER_86_475 VPWR VGND sg13cmos5l_decap_8
Xfanout499 _09970_/B _09319_/C VPWR VGND sg13cmos5l_buf_1
Xfanout488 _10073_/B _10088_/A2 VPWR VGND sg13cmos5l_buf_1
XFILLER_104_42 VPWR VGND sg13cmos5l_decap_8
XFILLER_101_797 VPWR VGND sg13cmos5l_decap_8
X_09758_ _09758_/Y _10942_/Q _09823_/B VPWR VGND sg13cmos5l_nand2_1
XFILLER_86_486 VPWR VGND sg13cmos5l_fill_1
XFILLER_73_103 VPWR VGND sg13cmos5l_fill_1
XFILLER_74_659 VPWR VGND sg13cmos5l_fill_1
X_08709_ _08954_/B _08950_/B VPWR VGND sg13cmos5l_inv_1
XFILLER_27_542 VPWR VGND sg13cmos5l_fill_1
XFILLER_27_553 VPWR VGND sg13cmos5l_fill_1
XFILLER_82_670 VPWR VGND sg13cmos5l_fill_2
X_11720_ _11720_/Q _11766_/CLK _11720_/D _11720_/RESET_B VPWR VGND sg13cmos5l_dfrbpq_1
X_09689_ _09689_/Y _11355_/Q _09955_/B VPWR VGND sg13cmos5l_nand2_1
XFILLER_15_726 VPWR VGND sg13cmos5l_fill_1
XFILLER_70_898 VPWR VGND sg13cmos5l_decap_8
XFILLER_70_887 VPWR VGND sg13cmos5l_decap_8
XFILLER_42_589 VPWR VGND sg13cmos5l_decap_8
X_11651_ _11651_/Q _11668_/CLK _11651_/D _11651_/RESET_B VPWR VGND sg13cmos5l_dfrbpq_1
XFILLER_30_729 VPWR VGND sg13cmos5l_fill_2
Xfanout73 fanout73/X _07593_/Y VPWR VGND sg13cmos5l_buf_1
Xfanout51 fanout51/X fanout52/X VPWR VGND sg13cmos5l_buf_1
X_11582_ _11582_/Q _11594_/CLK _11582_/D _11582_/RESET_B VPWR VGND sg13cmos5l_dfrbpq_1
Xfanout62 fanout62/X _07612_/Y VPWR VGND sg13cmos5l_buf_1
X_10602_ _10602_/Y fanout85/X _10601_/X _10783_/B VPWR VGND sg13cmos5l_o21ai_1
Xfanout95 fanout95/X _09283_/Y VPWR VGND sg13cmos5l_buf_1
Xfanout84 fanout84/X fanout85/X VPWR VGND sg13cmos5l_buf_1
X_10533_ _10537_/B _10534_/A _10520_/Y _10532_/Y VPWR VGND sg13cmos5l_o21ai_1
XFILLER_7_925 VPWR VGND sg13cmos5l_decap_8
XFILLER_22_291 VPWR VGND sg13cmos5l_decap_8
X_11731__1218 _11731_/RESET_B VPWR VGND sg13cmos5l_tiehi
XFILLER_7_958 VPWR VGND sg13cmos5l_fill_2
XFILLER_6_413 VPWR VGND sg13cmos5l_fill_2
XFILLER_13_61 VPWR VGND sg13cmos5l_fill_1
XFILLER_89_21 VPWR VGND sg13cmos5l_decap_8
X_10464_ _10465_/B _10464_/A _10464_/B VPWR VGND sg13cmos5l_and2_1
XFILLER_6_457 VPWR VGND sg13cmos5l_decap_4
X_10395_ _10395_/Y hold2831/X _10166_/B _10394_/Y VPWR VGND sg13cmos5l_o21ai_1
XFILLER_96_228 VPWR VGND sg13cmos5l_fill_2
XFILLER_104_591 VPWR VGND sg13cmos5l_decap_8
XFILLER_77_431 VPWR VGND sg13cmos5l_fill_2
X_11016_ _11016_/Q clkload51/A _11016_/D _11016_/RESET_B VPWR VGND sg13cmos5l_dfrbpq_1
XFILLER_78_998 VPWR VGND sg13cmos5l_decap_4
XFILLER_92_412 VPWR VGND sg13cmos5l_fill_1
XFILLER_92_445 VPWR VGND sg13cmos5l_decap_4
XFILLER_80_618 VPWR VGND sg13cmos5l_fill_2
XFILLER_61_898 VPWR VGND sg13cmos5l_decap_8
X_11385__1513 _11385_/RESET_B VPWR VGND sg13cmos5l_tiehi
Xclkload10 clkload10/X clkload10/A VPWR VGND sg13cmos5l_buf_8
Xclkload32 clkload32/Y clkload32/A VPWR VGND sg13cmos5l_inv_1
Xclkload21 clkload21/Y clkload21/A VPWR VGND sg13cmos5l_inv_2
X_07040_ _07040_/Y _11511_/Q _10165_/B VPWR VGND sg13cmos5l_nand2_1
X_11413__1464 _11413_/RESET_B VPWR VGND sg13cmos5l_tiehi
Xclkload43 clkload43/Y clkload43/A VPWR VGND sg13cmos5l_inv_2
Xclkload54 clkload54/Y clkload54/A VPWR VGND sg13cmos5l_inv_2
X_11446__1398 _11446_/RESET_B VPWR VGND sg13cmos5l_tiehi
X_08991_ _09020_/A _11389_/Q _08992_/B VPWR VGND sg13cmos5l_nand2_1
Xhold2805 _09218_/B _10843_/Q VPWR VGND sg13cmos5l_dlygate4sd3_1
XFILLER_102_539 VPWR VGND sg13cmos5l_fill_2
XFILLER_69_954 VPWR VGND sg13cmos5l_decap_8
Xhold2816 _09234_/B _10846_/Q VPWR VGND sg13cmos5l_dlygate4sd3_1
Xhold2827 hold2827/X _11403_/Q VPWR VGND sg13cmos5l_dlygate4sd3_1
Xhold2838 _11525_/D _10228_/Y VPWR VGND sg13cmos5l_dlygate4sd3_1
X_07942_ _07942_/Y _07942_/A _07942_/B VPWR VGND sg13cmos5l_nand2_1
X_11116__1785 _11116_/RESET_B VPWR VGND sg13cmos5l_tiehi
Xhold2849 hold2849/X _10858_/Q VPWR VGND sg13cmos5l_dlygate4sd3_1
XFILLER_69_965 VPWR VGND sg13cmos5l_fill_2
X_07873_ _07873_/Y _07873_/A _07881_/B VPWR VGND sg13cmos5l_nor2_1
X_11497__1189 _11497_/RESET_B VPWR VGND sg13cmos5l_tiehi
X_06824_ _06824_/Y _06801_/Y _06818_/Y _06823_/Y VPWR VGND sg13cmos5l_o21ai_1
XFILLER_83_412 VPWR VGND sg13cmos5l_fill_1
XFILLER_55_125 VPWR VGND sg13cmos5l_decap_8
X_09612_ _09612_/Y _10440_/A1 _09668_/B _09644_/A VPWR VGND sg13cmos5l_o21ai_1
X_11295__1606 _11295_/RESET_B VPWR VGND sg13cmos5l_tiehi
X_11756__917 _11756_/RESET_B VPWR VGND sg13cmos5l_tiehi
XFILLER_55_136 VPWR VGND sg13cmos5l_fill_2
XFILLER_37_862 VPWR VGND sg13cmos5l_decap_8
X_09543_ _09543_/Y _09731_/A _09565_/B _09543_/C VPWR VGND sg13cmos5l_nand3_1
X_11331__1570 _11331_/RESET_B VPWR VGND sg13cmos5l_tiehi
X_11617__1357 _11617_/RESET_B VPWR VGND sg13cmos5l_tiehi
XFILLER_52_821 VPWR VGND sg13cmos5l_decap_4
XFILLER_43_309 VPWR VGND sg13cmos5l_fill_2
XFILLER_37_884 VPWR VGND sg13cmos5l_fill_1
X_06755_ _06756_/B _06752_/Y _06753_/Y _06754_/Y _06679_/A VPWR VGND sg13cmos5l_a22oi_1
XFILLER_51_331 VPWR VGND sg13cmos5l_fill_1
X_09474_ _09474_/Y _05960_/Y _09492_/B _09577_/B1 _09473_/Y VPWR VGND sg13cmos5l_a22oi_1
X_11025__900 _11025_/RESET_B VPWR VGND sg13cmos5l_tiehi
X_06686_ _06686_/X _06686_/A _06686_/B VPWR VGND sg13cmos5l_or2_1
X_08425_ _08425_/Y _08425_/A _08433_/B VPWR VGND sg13cmos5l_nor2_1
X_08356_ _08356_/Y _08356_/A _08366_/B VPWR VGND sg13cmos5l_nand2_1
Xclkload4 clkload4/X clkload4/A VPWR VGND sg13cmos5l_buf_8
X_07307_ _07307_/Y _11530_/Q _08689_/A VPWR VGND sg13cmos5l_nand2_1
X_08287_ _08287_/Y _08287_/A _08301_/B VPWR VGND sg13cmos5l_nor2_1
X_10821__958 _10821_/RESET_B VPWR VGND sg13cmos5l_tiehi
X_07238_ _10853_/D _07244_/A _07238_/B VPWR VGND sg13cmos5l_nand2_1
XFILLER_106_812 VPWR VGND sg13cmos5l_decap_8
X_07169_ _07169_/Y _07205_/B _06038_/C VPWR VGND sg13cmos5l_nor2b_1
XFILLER_4_939 VPWR VGND sg13cmos5l_fill_1
XFILLER_105_344 VPWR VGND sg13cmos5l_fill_1
XFILLER_106_889 VPWR VGND sg13cmos5l_decap_8
XFILLER_105_377 VPWR VGND sg13cmos5l_decap_8
X_10180_ _10180_/X _10180_/A _10180_/B VPWR VGND sg13cmos5l_or2_1
XFILLER_87_740 VPWR VGND sg13cmos5l_decap_8
Xfanout241 _07750_/B fanout246/X VPWR VGND sg13cmos5l_buf_1
Xfanout230 _07877_/B _07883_/B VPWR VGND sg13cmos5l_buf_1
Xfanout252 _07718_/B _07712_/B VPWR VGND sg13cmos5l_buf_1
Xfanout274 _09068_/A _08738_/Y VPWR VGND sg13cmos5l_buf_1
Xfanout263 _07595_/B _07566_/B VPWR VGND sg13cmos5l_buf_1
Xfanout296 _08112_/B _08108_/B VPWR VGND sg13cmos5l_buf_1
Xfanout285 _08366_/B _08374_/B VPWR VGND sg13cmos5l_buf_1
XFILLER_86_261 VPWR VGND sg13cmos5l_fill_2
XFILLER_75_957 VPWR VGND sg13cmos5l_decap_8
XFILLER_47_648 VPWR VGND sg13cmos5l_decap_8
XFILLER_47_626 VPWR VGND sg13cmos5l_decap_4
XFILLER_19_317 VPWR VGND sg13cmos5l_fill_1
XFILLER_74_445 VPWR VGND sg13cmos5l_decap_8
XFILLER_46_147 VPWR VGND sg13cmos5l_fill_1
X_10905__1077 _10905_/RESET_B VPWR VGND sg13cmos5l_tiehi
XFILLER_62_618 VPWR VGND sg13cmos5l_fill_2
XFILLER_55_670 VPWR VGND sg13cmos5l_fill_1
XFILLER_28_884 VPWR VGND sg13cmos5l_decap_4
XFILLER_43_843 VPWR VGND sg13cmos5l_fill_1
XFILLER_70_651 VPWR VGND sg13cmos5l_fill_2
X_11703_ _11703_/Q clkload31/A _11703_/D _11703_/RESET_B VPWR VGND sg13cmos5l_dfrbpq_1
X_11634_ _11634_/Q _11713_/CLK _11634_/D _11634_/RESET_B VPWR VGND sg13cmos5l_dfrbpq_1
X_11565_ _11565_/Q clkload26/A _11565_/D _11565_/RESET_B VPWR VGND sg13cmos5l_dfrbpq_1
X_10516_ _11538_/D _10449_/Y _10515_/Y _10511_/Y VPWR VGND sg13cmos5l_o21ai_1
X_11496_ _11496_/Q clkload15/A _11496_/D _11496_/RESET_B VPWR VGND sg13cmos5l_dfrbpq_1
X_10447_ _10453_/D _10447_/A _10844_/Q VPWR VGND sg13cmos5l_xnor2_1
XFILLER_7_788 VPWR VGND sg13cmos5l_decap_4
X_11373__1528 _11373_/RESET_B VPWR VGND sg13cmos5l_tiehi
X_10378_ _10378_/Y _10378_/A _10378_/B _10378_/C VPWR VGND sg13cmos5l_nor3_1
XFILLER_3_983 VPWR VGND sg13cmos5l_decap_8
XFILLER_38_626 VPWR VGND sg13cmos5l_decap_8
XFILLER_38_659 VPWR VGND sg13cmos5l_decap_4
XFILLER_1_42 VPWR VGND sg13cmos5l_decap_4
XFILLER_1_53 VPWR VGND sg13cmos5l_decap_8
XFILLER_93_787 VPWR VGND sg13cmos5l_fill_1
XFILLER_52_117 VPWR VGND sg13cmos5l_fill_2
X_06540_ _06542_/A _06571_/A1 _11668_/Q _11652_/Q _06531_/A VPWR VGND sg13cmos5l_a22oi_1
XFILLER_19_895 VPWR VGND sg13cmos5l_fill_2
X_06471_ _06471_/Y _11020_/Q _06468_/B _09601_/B1 VPWR VGND sg13cmos5l_a21oi_1
XFILLER_33_353 VPWR VGND sg13cmos5l_fill_1
XFILLER_60_150 VPWR VGND sg13cmos5l_decap_4
X_08210_ _08210_/Y _08210_/A _08216_/B VPWR VGND sg13cmos5l_nand2_1
XFILLER_34_898 VPWR VGND sg13cmos5l_fill_1
X_09190_ _09340_/B _09325_/A _09325_/B _09183_/Y VPWR VGND sg13cmos5l_a21oi_1
X_08141_ _08141_/Y _08141_/A _08141_/B VPWR VGND sg13cmos5l_nor2_1
XFILLER_14_1026 VPWR VGND sg13cmos5l_fill_2
X_08072_ _08072_/Y _08072_/A _08078_/B VPWR VGND sg13cmos5l_nand2_1
XFILLER_106_119 VPWR VGND sg13cmos5l_decap_8
X_07023_ _07023_/Y _07026_/B _07021_/Y _07022_/Y VPWR VGND sg13cmos5l_o21ai_1
X_11349__1552 _11349_/RESET_B VPWR VGND sg13cmos5l_tiehi
XFILLER_102_336 VPWR VGND sg13cmos5l_fill_1
Xhold2602 _07244_/B _07243_/Y VPWR VGND sg13cmos5l_dlygate4sd3_1
Xhold2613 hold2613/X _11727_/Q VPWR VGND sg13cmos5l_dlygate4sd3_1
X_08974_ _08975_/A _08973_/A _08973_/B _09061_/A VPWR VGND sg13cmos5l_o21ai_1
Xhold1901 _08442_/A _11306_/Q VPWR VGND sg13cmos5l_dlygate4sd3_1
Xhold2635 _06092_/A _11768_/Q VPWR VGND sg13cmos5l_dlygate4sd3_1
Xhold2624 _06035_/D _11611_/Q VPWR VGND sg13cmos5l_dlygate4sd3_1
Xhold2646 _06943_/C _06918_/Y VPWR VGND sg13cmos5l_dlygate4sd3_1
XFILLER_57_902 VPWR VGND sg13cmos5l_fill_1
XFILLER_29_38 VPWR VGND sg13cmos5l_fill_2
X_07925_ _11052_/D _08317_/A1 _07942_/B _07924_/Y VPWR VGND sg13cmos5l_o21ai_1
Xhold1923 _08052_/A _11115_/Q VPWR VGND sg13cmos5l_dlygate4sd3_1
Xhold2657 _06837_/A _06836_/Y VPWR VGND sg13cmos5l_dlygate4sd3_1
Xhold1912 _07954_/A _11067_/Q VPWR VGND sg13cmos5l_dlygate4sd3_1
Xhold2668 _07236_/B _07235_/Y VPWR VGND sg13cmos5l_dlygate4sd3_1
Xhold2679 _11702_/D _07089_/X VPWR VGND sg13cmos5l_dlygate4sd3_1
XFILLER_56_401 VPWR VGND sg13cmos5l_fill_2
Xhold1934 _07934_/A _11057_/Q VPWR VGND sg13cmos5l_dlygate4sd3_1
Xhold1945 _07792_/A _10988_/Q VPWR VGND sg13cmos5l_dlygate4sd3_1
X_07856_ _11018_/D _08313_/A1 _07913_/B _07855_/Y VPWR VGND sg13cmos5l_a21oi_1
XFILLER_84_754 VPWR VGND sg13cmos5l_decap_8
XFILLER_72_905 VPWR VGND sg13cmos5l_fill_1
Xhold1956 _08905_/A _11436_/Q VPWR VGND sg13cmos5l_dlygate4sd3_1
Xhold1967 _08895_/A _11435_/Q VPWR VGND sg13cmos5l_dlygate4sd3_1
Xhold1978 _08096_/A _11137_/Q VPWR VGND sg13cmos5l_dlygate4sd3_1
X_07787_ _07787_/Y _07721_/A _08311_/A VPWR VGND sg13cmos5l_nand2b_1
X_06807_ _06807_/Y _11641_/Q _06879_/B VPWR VGND sg13cmos5l_nand2_1
Xhold1989 _08326_/A _11249_/Q VPWR VGND sg13cmos5l_dlygate4sd3_1
XFILLER_37_692 VPWR VGND sg13cmos5l_decap_8
X_09526_ _09533_/A _09633_/A _09526_/B _09526_/C VPWR VGND sg13cmos5l_nor3_1
X_06738_ _06739_/C _06738_/A _06738_/B VPWR VGND sg13cmos5l_nor2_1
XFILLER_101_21 VPWR VGND sg13cmos5l_decap_8
XFILLER_52_662 VPWR VGND sg13cmos5l_decap_8
X_09457_ _09457_/Y _09537_/A _09457_/B VPWR VGND sg13cmos5l_nor2_1
XFILLER_51_161 VPWR VGND sg13cmos5l_decap_4
XFILLER_40_824 VPWR VGND sg13cmos5l_decap_8
XFILLER_12_515 VPWR VGND sg13cmos5l_fill_2
X_08408_ _11289_/D fanout98/X _08423_/B _08407_/Y VPWR VGND sg13cmos5l_a21oi_1
X_06669_ _06669_/Y _06664_/A _06662_/B _06291_/B VPWR VGND sg13cmos5l_o21ai_1
XFILLER_24_364 VPWR VGND sg13cmos5l_decap_8
XFILLER_101_98 VPWR VGND sg13cmos5l_decap_8
XFILLER_12_559 VPWR VGND sg13cmos5l_decap_4
X_09388_ _09388_/Y _10960_/Q _09440_/B VPWR VGND sg13cmos5l_nand2_1
X_08339_ _11255_/D _08339_/A1 _08338_/B _08338_/Y VPWR VGND sg13cmos5l_o21ai_1
X_11350_ _11350_/Q _11356_/CLK _11350_/D _11350_/RESET_B VPWR VGND sg13cmos5l_dfrbpq_1
X_10301_ _10491_/A _10481_/A _10300_/B _10296_/Y VPWR VGND sg13cmos5l_o21ai_1
XFILLER_4_714 VPWR VGND sg13cmos5l_decap_4
X_11281_ _11281_/Q clkload35/A _11281_/D _11281_/RESET_B VPWR VGND sg13cmos5l_dfrbpq_1
XFILLER_106_686 VPWR VGND sg13cmos5l_decap_8
X_10232_ _10233_/B _10232_/A _10232_/B _10232_/C VPWR VGND sg13cmos5l_nor3_1
XFILLER_10_73 VPWR VGND sg13cmos5l_fill_2
XFILLER_105_196 VPWR VGND sg13cmos5l_decap_8
X_10163_ _10662_/A _10703_/A _10693_/C VPWR VGND sg13cmos5l_nor2_1
XFILLER_48_913 VPWR VGND sg13cmos5l_decap_8
XFILLER_0_964 VPWR VGND sg13cmos5l_decap_8
X_11663__1301 _11663_/RESET_B VPWR VGND sg13cmos5l_tiehi
XFILLER_47_401 VPWR VGND sg13cmos5l_decap_8
X_10094_ _11499_/D hold2890/X _10115_/A2 _10093_/Y VPWR VGND sg13cmos5l_a21o_1
XFILLER_59_283 VPWR VGND sg13cmos5l_fill_1
XFILLER_74_264 VPWR VGND sg13cmos5l_decap_8
XFILLER_62_404 VPWR VGND sg13cmos5l_decap_8
XFILLER_90_746 VPWR VGND sg13cmos5l_decap_8
XFILLER_62_437 VPWR VGND sg13cmos5l_fill_1
XFILLER_62_426 VPWR VGND sg13cmos5l_decap_8
X_11696__1268 _11696_/RESET_B VPWR VGND sg13cmos5l_tiehi
XFILLER_90_768 VPWR VGND sg13cmos5l_fill_2
XFILLER_43_651 VPWR VGND sg13cmos5l_decap_8
X_10996_ _10996_/Q _11347_/CLK _10996_/D _10996_/RESET_B VPWR VGND sg13cmos5l_dfrbpq_1
XFILLER_16_865 VPWR VGND sg13cmos5l_decap_8
XFILLER_16_887 VPWR VGND sg13cmos5l_fill_2
XFILLER_89_7 VPWR VGND sg13cmos5l_decap_8
XFILLER_30_345 VPWR VGND sg13cmos5l_decap_4
X_11617_ _11617_/Q clkload27/A _11617_/D _11617_/RESET_B VPWR VGND sg13cmos5l_dfrbpq_1
XFILLER_30_378 VPWR VGND sg13cmos5l_decap_4
X_11548_ _11548_/Q clkload47/A _11548_/D _11548_/RESET_B VPWR VGND sg13cmos5l_dfrbpq_1
XFILLER_11_592 VPWR VGND sg13cmos5l_decap_8
XFILLER_7_574 VPWR VGND sg13cmos5l_fill_1
X_11479_ _11479_/Q clkload48/A _11479_/D _11479_/RESET_B VPWR VGND sg13cmos5l_dfrbpq_1
X_07710_ _07710_/Y _07710_/A _07712_/B VPWR VGND sg13cmos5l_nor2_1
X_05971_ _05971_/Y _11322_/Q VPWR VGND sg13cmos5l_inv_1
XFILLER_66_732 VPWR VGND sg13cmos5l_fill_1
XFILLER_54_905 VPWR VGND sg13cmos5l_fill_1
X_08690_ _08896_/B _08690_/A _08690_/B VPWR VGND sg13cmos5l_nand2_1
XFILLER_93_584 VPWR VGND sg13cmos5l_decap_4
X_07641_ _10919_/D _07640_/B fanout53/X _07640_/Y VPWR VGND sg13cmos5l_a21oi_1
XFILLER_66_787 VPWR VGND sg13cmos5l_decap_8
X_07572_ _07572_/Y _07572_/A _07595_/B VPWR VGND sg13cmos5l_nor2_1
X_09311_ _09314_/B _09884_/A _09309_/Y _09310_/Y VPWR VGND sg13cmos5l_a21oi_1
X_06523_ _06525_/C _06523_/A _06523_/B VPWR VGND sg13cmos5l_or2_1
XFILLER_90_1017 VPWR VGND sg13cmos5l_fill_2
X_11022__903 _11022_/RESET_B VPWR VGND sg13cmos5l_tiehi
XFILLER_22_813 VPWR VGND sg13cmos5l_fill_1
X_06454_ _06454_/Y _10644_/B1 _11631_/Q _06453_/X VPWR VGND sg13cmos5l_a21oi_1
X_09242_ _09754_/B _09242_/A _09244_/B VPWR VGND sg13cmos5l_nor2b_1
X_06385_ _06387_/A _06389_/A _10581_/B _06385_/C VPWR VGND sg13cmos5l_nor3_1
X_09173_ _09173_/X _09456_/A _10836_/Q VPWR VGND sg13cmos5l_xor2_1
X_08124_ _11149_/D _08319_/A1 _08135_/B _08123_/Y VPWR VGND sg13cmos5l_a21oi_1
XFILLER_30_890 VPWR VGND sg13cmos5l_decap_8
X_08055_ _11116_/D _08317_/A1 _08088_/B _08054_/Y VPWR VGND sg13cmos5l_o21ai_1
X_07006_ _07006_/Y _07006_/A _07006_/B VPWR VGND sg13cmos5l_nor2_1
Xoutput39 uo_out[15] _06575_/Y VPWR VGND sg13cmos5l_buf_1
Xoutput28 uio_out[5] _06105_/Y VPWR VGND sg13cmos5l_buf_1
XFILLER_103_623 VPWR VGND sg13cmos5l_fill_2
XFILLER_89_857 VPWR VGND sg13cmos5l_decap_4
XFILLER_103_678 VPWR VGND sg13cmos5l_fill_1
XFILLER_102_133 VPWR VGND sg13cmos5l_decap_8
Xhold2410 _08431_/A _11301_/Q VPWR VGND sg13cmos5l_dlygate4sd3_1
Xhold2421 _08413_/A _11292_/Q VPWR VGND sg13cmos5l_dlygate4sd3_1
XFILLER_0_238 VPWR VGND sg13cmos5l_fill_1
XFILLER_88_378 VPWR VGND sg13cmos5l_decap_8
XFILLER_69_570 VPWR VGND sg13cmos5l_decap_4
Xhold2443 _10833_/D _07183_/Y VPWR VGND sg13cmos5l_dlygate4sd3_1
Xhold2454 _10832_/D _07180_/Y VPWR VGND sg13cmos5l_dlygate4sd3_1
X_08957_ _08957_/Y _10793_/Q _08950_/B _08957_/B1 VPWR VGND sg13cmos5l_o21ai_1
Xhold2432 _07758_/A _10972_/Q VPWR VGND sg13cmos5l_dlygate4sd3_1
X_07908_ _11044_/D fanout59/X _07913_/B _07907_/Y VPWR VGND sg13cmos5l_a21oi_1
Xhold2487 _08565_/A _11367_/Q VPWR VGND sg13cmos5l_dlygate4sd3_1
Xhold2476 _11560_/D _10729_/Y VPWR VGND sg13cmos5l_dlygate4sd3_1
Xhold2498 hold2498/X _11584_/Q VPWR VGND sg13cmos5l_dlygate4sd3_1
XFILLER_56_36 VPWR VGND sg13cmos5l_decap_4
X_08888_ _08897_/B _08910_/A _08906_/A _08888_/C VPWR VGND sg13cmos5l_or3_1
Xhold2465 _06117_/C _11759_/Q VPWR VGND sg13cmos5l_dlygate4sd3_1
X_07839_ _11011_/D fanout62/X _07850_/B _07838_/Y VPWR VGND sg13cmos5l_o21ai_1
XFILLER_56_264 VPWR VGND sg13cmos5l_decap_8
XFILLER_56_69 VPWR VGND sg13cmos5l_fill_1
XFILLER_56_58 VPWR VGND sg13cmos5l_decap_8
XFILLER_29_478 VPWR VGND sg13cmos5l_fill_2
XFILLER_72_746 VPWR VGND sg13cmos5l_fill_1
X_10850_ _10850_/Q _11715_/CLK _10850_/D _10850_/RESET_B VPWR VGND sg13cmos5l_dfrbpq_1
XFILLER_56_297 VPWR VGND sg13cmos5l_decap_8
XFILLER_56_275 VPWR VGND sg13cmos5l_fill_1
X_10781_ _11590_/D _10781_/A VPWR VGND sg13cmos5l_inv_1
XFILLER_71_278 VPWR VGND sg13cmos5l_fill_1
XFILLER_13_835 VPWR VGND sg13cmos5l_decap_8
X_09509_ _09509_/Y hold2786/X _09805_/A2 _09432_/B _09508_/Y VPWR VGND sg13cmos5l_a22oi_1
X_11402_ _11402_/Q clkload20/A _11402_/D _11402_/RESET_B VPWR VGND sg13cmos5l_dfrbpq_1
X_11111__1790 _11111_/RESET_B VPWR VGND sg13cmos5l_tiehi
X_11333_ _11333_/Q clkload54/A _11333_/D _11333_/RESET_B VPWR VGND sg13cmos5l_dfrbpq_1
XFILLER_4_522 VPWR VGND sg13cmos5l_decap_4
XFILLER_97_21 VPWR VGND sg13cmos5l_decap_8
X_11264_ _11264_/Q clkload56/A _11264_/D _11264_/RESET_B VPWR VGND sg13cmos5l_dfrbpq_1
XFILLER_106_483 VPWR VGND sg13cmos5l_decap_8
X_11509__1165 _11509_/RESET_B VPWR VGND sg13cmos5l_tiehi
X_10215_ _10215_/Y _09319_/A _09335_/B _10213_/Y _10214_/Y VPWR VGND sg13cmos5l_a22oi_1
X_11290__1611 _11290_/RESET_B VPWR VGND sg13cmos5l_tiehi
XFILLER_79_345 VPWR VGND sg13cmos5l_fill_1
X_11195_ _11195_/Q clkload43/A _11195_/D _11195_/RESET_B VPWR VGND sg13cmos5l_dfrbpq_1
XFILLER_79_389 VPWR VGND sg13cmos5l_decap_8
XFILLER_79_378 VPWR VGND sg13cmos5l_decap_8
X_10146_ _10146_/Y _05935_/A _10857_/Q _10123_/A VPWR VGND sg13cmos5l_o21ai_1
XFILLER_0_772 VPWR VGND sg13cmos5l_fill_2
XFILLER_48_743 VPWR VGND sg13cmos5l_fill_1
XFILLER_48_732 VPWR VGND sg13cmos5l_decap_8
X_10077_ _10077_/Y _10070_/A _10836_/Q _10092_/B1 VPWR VGND sg13cmos5l_o21ai_1
XFILLER_63_735 VPWR VGND sg13cmos5l_fill_2
XFILLER_90_543 VPWR VGND sg13cmos5l_fill_2
XFILLER_63_768 VPWR VGND sg13cmos5l_fill_2
XFILLER_51_908 VPWR VGND sg13cmos5l_fill_2
X_10979_ _10979_/Q clkload46/A _10979_/D _10979_/RESET_B VPWR VGND sg13cmos5l_dfrbpq_1
XFILLER_30_153 VPWR VGND sg13cmos5l_fill_1
XFILLER_30_197 VPWR VGND sg13cmos5l_decap_8
XFILLER_11_1007 VPWR VGND sg13cmos5l_decap_8
X_06170_ _06173_/A _06172_/A _09205_/A VPWR VGND sg13cmos5l_and2_1
XFILLER_104_409 VPWR VGND sg13cmos5l_decap_8
X_11537__1499 _11537_/RESET_B VPWR VGND sg13cmos5l_tiehi
X_09860_ _09860_/Y _09915_/A _09860_/B _09860_/C VPWR VGND sg13cmos5l_nor3_1
Xfanout807 _08832_/A1 _08774_/B VPWR VGND sg13cmos5l_buf_1
X_10864__1118 _10864_/RESET_B VPWR VGND sg13cmos5l_tiehi
XFILLER_97_131 VPWR VGND sg13cmos5l_decap_8
Xfanout829 _10728_/B _10691_/C VPWR VGND sg13cmos5l_buf_1
XFILLER_86_816 VPWR VGND sg13cmos5l_fill_1
Xfanout818 _10685_/A _10560_/A VPWR VGND sg13cmos5l_buf_1
X_10900__1082 _10900_/RESET_B VPWR VGND sg13cmos5l_tiehi
XFILLER_30_0 VPWR VGND sg13cmos5l_fill_2
X_09791_ _09791_/Y _10975_/Q _09870_/B _09791_/B1 VPWR VGND sg13cmos5l_a21oi_1
XFILLER_85_315 VPWR VGND sg13cmos5l_decap_8
X_08811_ _08811_/Y _08811_/A _08811_/B VPWR VGND sg13cmos5l_nand2_1
X_08742_ _09068_/B _08742_/A _08742_/B VPWR VGND sg13cmos5l_nand2_1
X_05954_ _05954_/Y _11309_/Q VPWR VGND sg13cmos5l_inv_1
X_08673_ _08674_/A _10229_/A _08846_/B _08841_/A _08856_/B1 VPWR VGND sg13cmos5l_a22oi_1
XFILLER_39_776 VPWR VGND sg13cmos5l_decap_4
X_07624_ _07624_/Y _07623_/A _07623_/B _07638_/A VPWR VGND sg13cmos5l_a21oi_1
XFILLER_66_584 VPWR VGND sg13cmos5l_decap_8
X_05885_ _05885_/Y input13/X VPWR VGND sg13cmos5l_inv_1
XFILLER_54_724 VPWR VGND sg13cmos5l_decap_8
X_11153__1748 _11153_/RESET_B VPWR VGND sg13cmos5l_tiehi
XFILLER_26_39 VPWR VGND sg13cmos5l_fill_1
XFILLER_53_289 VPWR VGND sg13cmos5l_decap_8
X_07555_ _08712_/B _11536_/Q _10811_/Q _07582_/S VPWR VGND sg13cmos5l_mux2_1
X_06506_ _06507_/C _06506_/A _06506_/B VPWR VGND sg13cmos5l_xor2_1
XFILLER_22_621 VPWR VGND sg13cmos5l_fill_1
X_07486_ _07486_/Y _10229_/A _07500_/D _07485_/Y VPWR VGND sg13cmos5l_a21oi_1
X_06437_ _06437_/Y _06643_/B1 _06434_/Y _06436_/Y VPWR VGND sg13cmos5l_a21oi_1
XFILLER_42_38 VPWR VGND sg13cmos5l_fill_2
X_09225_ _09225_/Y _09225_/A _09225_/B _09225_/C VPWR VGND sg13cmos5l_nor3_1
XFILLER_6_809 VPWR VGND sg13cmos5l_fill_2
XFILLER_10_838 VPWR VGND sg13cmos5l_decap_4
X_09156_ _11454_/D _09153_/Y _09154_/Y _09155_/Y VPWR VGND sg13cmos5l_o21ai_1
X_06368_ _06368_/Y _06670_/B _06366_/Y _06367_/Y VPWR VGND sg13cmos5l_o21ai_1
X_08107_ _11142_/D fanout56/X _08104_/B _08106_/Y VPWR VGND sg13cmos5l_o21ai_1
X_09087_ _09087_/Y _09097_/B _09087_/B VPWR VGND sg13cmos5l_xnor2_1
X_06299_ _06299_/Y _11498_/Q _09431_/A _06298_/Y VPWR VGND sg13cmos5l_o21ai_1
X_08038_ _11108_/D fanout60/X _08043_/B _08037_/Y VPWR VGND sg13cmos5l_a21oi_1
XFILLER_104_943 VPWR VGND sg13cmos5l_decap_8
X_10000_ _10000_/Y _10653_/A _09911_/B _09913_/C _09999_/Y VPWR VGND sg13cmos5l_a22oi_1
XFILLER_1_569 VPWR VGND sg13cmos5l_fill_2
XFILLER_27_1014 VPWR VGND sg13cmos5l_decap_4
XFILLER_89_698 VPWR VGND sg13cmos5l_decap_8
XFILLER_77_849 VPWR VGND sg13cmos5l_fill_1
X_09989_ _09989_/Y _09989_/A _09989_/B _09989_/C VPWR VGND sg13cmos5l_nor3_1
XFILLER_49_518 VPWR VGND sg13cmos5l_decap_8
Xhold2251 _08377_/A _11274_/Q VPWR VGND sg13cmos5l_dlygate4sd3_1
XFILLER_67_79 VPWR VGND sg13cmos5l_fill_2
Xhold2273 _07299_/A _10867_/Q VPWR VGND sg13cmos5l_dlygate4sd3_1
Xhold2262 _08133_/A _11154_/Q VPWR VGND sg13cmos5l_dlygate4sd3_1
Xhold2240 _08253_/A _11213_/Q VPWR VGND sg13cmos5l_dlygate4sd3_1
Xhold2284 _07613_/A _10915_/Q VPWR VGND sg13cmos5l_dlygate4sd3_1
Xhold2295 _07760_/A _10973_/Q VPWR VGND sg13cmos5l_dlygate4sd3_1
XFILLER_85_893 VPWR VGND sg13cmos5l_fill_1
XFILLER_83_23 VPWR VGND sg13cmos5l_decap_8
XFILLER_57_584 VPWR VGND sg13cmos5l_decap_8
XFILLER_17_415 VPWR VGND sg13cmos5l_fill_2
X_10902_ _10902_/Q clkload33/A _10902_/D _10902_/RESET_B VPWR VGND sg13cmos5l_dfrbpq_1
X_11129__1772 _11129_/RESET_B VPWR VGND sg13cmos5l_tiehi
X_10833_ _10833_/Q clkload19/A _10833_/D _10833_/RESET_B VPWR VGND sg13cmos5l_dfrbpq_1
XFILLER_25_470 VPWR VGND sg13cmos5l_decap_8
X_10764_ _10764_/X hold2494/X _06933_/B _07184_/X VPWR VGND sg13cmos5l_a21o_1
XFILLER_8_102 VPWR VGND sg13cmos5l_fill_1
X_10695_ _10695_/Y _10695_/A _10695_/B _10695_/C _10695_/D VPWR VGND sg13cmos5l_nor4_1
XFILLER_40_473 VPWR VGND sg13cmos5l_decap_8
XFILLER_8_124 VPWR VGND sg13cmos5l_fill_2
XFILLER_8_179 VPWR VGND sg13cmos5l_fill_1
XFILLER_59_8 VPWR VGND sg13cmos5l_fill_1
XFILLER_4_352 VPWR VGND sg13cmos5l_decap_8
X_11316_ _11316_/Q clkload16/A _11316_/D _11316_/RESET_B VPWR VGND sg13cmos5l_dfrbpq_1
XFILLER_4_363 VPWR VGND sg13cmos5l_fill_1
XFILLER_106_280 VPWR VGND sg13cmos5l_decap_8
X_11247_ _11247_/Q clkload43/A _11247_/D _11247_/RESET_B VPWR VGND sg13cmos5l_dfrbpq_1
X_11178_ _11178_/Q _11646_/CLK _11178_/D _11178_/RESET_B VPWR VGND sg13cmos5l_dfrbpq_1
XFILLER_80_1027 VPWR VGND sg13cmos5l_fill_2
XFILLER_79_153 VPWR VGND sg13cmos5l_decap_4
XFILLER_95_657 VPWR VGND sg13cmos5l_fill_1
XFILLER_68_849 VPWR VGND sg13cmos5l_decap_8
X_11740__1200 _11740_/RESET_B VPWR VGND sg13cmos5l_tiehi
X_10129_ _10129_/Y _10584_/A _10852_/Q _10123_/A VPWR VGND sg13cmos5l_o21ai_1
XFILLER_0_580 VPWR VGND sg13cmos5l_decap_8
XFILLER_94_145 VPWR VGND sg13cmos5l_decap_8
XFILLER_76_882 VPWR VGND sg13cmos5l_fill_2
XFILLER_36_713 VPWR VGND sg13cmos5l_fill_2
XFILLER_36_757 VPWR VGND sg13cmos5l_decap_8
XFILLER_90_362 VPWR VGND sg13cmos5l_fill_1
X_07340_ _07340_/Y _09557_/A _07340_/A2 _07339_/Y VPWR VGND sg13cmos5l_a21oi_1
X_10918__1064 _10918_/RESET_B VPWR VGND sg13cmos5l_tiehi
X_09010_ _09010_/Y _09036_/A _09036_/D VPWR VGND sg13cmos5l_xnor2_1
X_07271_ _07271_/Y _11524_/Q _08667_/S VPWR VGND sg13cmos5l_nand2_1
XFILLER_32_996 VPWR VGND sg13cmos5l_fill_1
X_06222_ _06371_/B _06223_/A _06223_/B VPWR VGND sg13cmos5l_and2_1
X_06153_ _06362_/A _11499_/Q _09214_/A VPWR VGND sg13cmos5l_nand2_1
XFILLER_104_217 VPWR VGND sg13cmos5l_decap_8
X_06084_ _06089_/C _06084_/A _10707_/A VPWR VGND sg13cmos5l_nor2b_1
X_11207__1694 _11207_/RESET_B VPWR VGND sg13cmos5l_tiehi
X_09912_ _09913_/C _09912_/A _09968_/B VPWR VGND sg13cmos5l_nand2_1
Xfanout604 _08946_/B1 _06023_/X VPWR VGND sg13cmos5l_buf_1
Xfanout615 _09345_/A _10032_/A VPWR VGND sg13cmos5l_buf_1
Xfanout626 _10719_/C _09131_/A VPWR VGND sg13cmos5l_buf_1
Xfanout637 _10694_/A _05861_/Y VPWR VGND sg13cmos5l_buf_1
Xfanout648 _06562_/A1 _11763_/Q VPWR VGND sg13cmos5l_buf_1
X_09843_ _09843_/Y _09841_/Y _09842_/Y _09846_/A1 VPWR VGND sg13cmos5l_a21oi_1
Xfanout659 _10656_/B _09278_/A VPWR VGND sg13cmos5l_buf_1
X_11691__1273 _11691_/RESET_B VPWR VGND sg13cmos5l_tiehi
XFILLER_85_167 VPWR VGND sg13cmos5l_fill_1
X_10836__1170 _10836_/RESET_B VPWR VGND sg13cmos5l_tiehi
X_09774_ _09775_/B _05901_/Y _09747_/B _09697_/B VPWR VGND sg13cmos5l_a21oi_1
X_06986_ _06986_/Y _11498_/Q _07006_/A _06990_/B1 _11490_/Q VPWR VGND sg13cmos5l_a22oi_1
XFILLER_96_1012 VPWR VGND sg13cmos5l_decap_8
X_05937_ _06060_/A _06059_/A VPWR VGND sg13cmos5l_inv_1
X_08725_ _11411_/D _08725_/A VPWR VGND sg13cmos5l_inv_1
XFILLER_26_212 VPWR VGND sg13cmos5l_decap_8
XFILLER_54_532 VPWR VGND sg13cmos5l_fill_1
X_08656_ _08657_/A _07472_/D _08811_/B _08817_/A _08831_/B1 VPWR VGND sg13cmos5l_a22oi_1
X_05868_ _10456_/A _11406_/Q VPWR VGND sg13cmos5l_inv_1
X_07607_ _07607_/Y _07607_/A _07607_/B VPWR VGND sg13cmos5l_nor2_1
X_08587_ _08587_/Y _06060_/A _09858_/B2 _08585_/Y _08586_/Y VPWR VGND sg13cmos5l_a22oi_1
XFILLER_42_716 VPWR VGND sg13cmos5l_decap_4
XFILLER_42_749 VPWR VGND sg13cmos5l_fill_2
X_07538_ _10904_/D _07537_/B _08536_/A1 _07537_/Y VPWR VGND sg13cmos5l_a21oi_1
XFILLER_23_952 VPWR VGND sg13cmos5l_decap_8
XFILLER_50_771 VPWR VGND sg13cmos5l_decap_8
XFILLER_23_963 VPWR VGND sg13cmos5l_decap_8
X_07469_ _10894_/D _07482_/B _08451_/A1 _07468_/Y VPWR VGND sg13cmos5l_a21oi_1
X_10480_ _10480_/X _10479_/A _10479_/B _11505_/Q VPWR VGND sg13cmos5l_a21o_1
X_09208_ _09211_/A _09208_/A _09208_/B _09208_/C VPWR VGND sg13cmos5l_nor3_1
X_09139_ _09139_/Y _09148_/B VPWR VGND sg13cmos5l_inv_1
XFILLER_5_127 VPWR VGND sg13cmos5l_decap_8
XFILLER_5_105 VPWR VGND sg13cmos5l_fill_1
X_11101_ _11101_/Q clkload42/A _11101_/D _11101_/RESET_B VPWR VGND sg13cmos5l_dfrbpq_1
XFILLER_89_440 VPWR VGND sg13cmos5l_fill_1
XFILLER_78_45 VPWR VGND sg13cmos5l_fill_2
XFILLER_2_856 VPWR VGND sg13cmos5l_fill_2
XFILLER_104_762 VPWR VGND sg13cmos5l_fill_2
X_11032_ _11032_/Q _11349_/CLK _11032_/D _11032_/RESET_B VPWR VGND sg13cmos5l_dfrbpq_1
XFILLER_77_657 VPWR VGND sg13cmos5l_fill_1
XFILLER_77_646 VPWR VGND sg13cmos5l_decap_8
XFILLER_49_326 VPWR VGND sg13cmos5l_decap_8
Xhold2081 _08990_/A _11442_/Q VPWR VGND sg13cmos5l_dlygate4sd3_1
Xhold2070 _11668_/D _07027_/Y VPWR VGND sg13cmos5l_dlygate4sd3_1
XFILLER_92_627 VPWR VGND sg13cmos5l_decap_8
Xhold2092 _11594_/D _10790_/Y VPWR VGND sg13cmos5l_dlygate4sd3_1
XFILLER_85_690 VPWR VGND sg13cmos5l_decap_8
XFILLER_45_521 VPWR VGND sg13cmos5l_fill_2
XFILLER_73_885 VPWR VGND sg13cmos5l_fill_1
XFILLER_73_874 VPWR VGND sg13cmos5l_fill_1
XFILLER_72_362 VPWR VGND sg13cmos5l_fill_2
XFILLER_32_248 VPWR VGND sg13cmos5l_fill_1
XFILLER_33_749 VPWR VGND sg13cmos5l_decap_8
XFILLER_60_568 VPWR VGND sg13cmos5l_decap_8
X_10816_ _10816_/Q clkload37/A _10816_/D _10816_/RESET_B VPWR VGND sg13cmos5l_dfrbpq_1
X_10747_ _10749_/B _10747_/A _10747_/B VPWR VGND sg13cmos5l_nand2_1
X_10678_ _10680_/A _10666_/Y _10668_/Y _10667_/Y VPWR VGND sg13cmos5l_o21ai_1
XFILLER_71_7 VPWR VGND sg13cmos5l_decap_4
XFILLER_96_955 VPWR VGND sg13cmos5l_fill_1
XFILLER_96_944 VPWR VGND sg13cmos5l_decap_8
XFILLER_95_432 VPWR VGND sg13cmos5l_fill_2
X_06840_ _06841_/A _06840_/A _06848_/B VPWR VGND sg13cmos5l_or2_1
XFILLER_68_657 VPWR VGND sg13cmos5l_fill_2
XFILLER_67_145 VPWR VGND sg13cmos5l_fill_1
X_06771_ _10819_/D _06264_/B _06769_/Y _06770_/Y VPWR VGND sg13cmos5l_o21ai_1
X_08510_ _11339_/D _08510_/A1 _08559_/B _08509_/Y VPWR VGND sg13cmos5l_a21oi_1
XFILLER_82_148 VPWR VGND sg13cmos5l_fill_2
X_09490_ _09490_/Y _09514_/C _09490_/B VPWR VGND sg13cmos5l_nand2_1
X_08441_ _08441_/Y _08441_/A _08441_/B VPWR VGND sg13cmos5l_nand2_1
XFILLER_64_874 VPWR VGND sg13cmos5l_fill_1
XFILLER_24_727 VPWR VGND sg13cmos5l_fill_1
XFILLER_24_749 VPWR VGND sg13cmos5l_decap_8
X_08372_ _08372_/Y _08372_/A _08372_/B VPWR VGND sg13cmos5l_nand2_1
XFILLER_51_557 VPWR VGND sg13cmos5l_fill_2
X_07323_ _07323_/Y _07323_/A _07425_/B VPWR VGND sg13cmos5l_nor2_1
XFILLER_32_793 VPWR VGND sg13cmos5l_decap_8
XFILLER_104_1027 VPWR VGND sg13cmos5l_fill_2
X_07254_ _07254_/Y _11425_/Q _07296_/B VPWR VGND sg13cmos5l_nand2_1
X_06205_ _06207_/C _06205_/A _06582_/A _06597_/A VPWR VGND sg13cmos5l_nand3_1
X_07185_ _07185_/X _07185_/A _07185_/B VPWR VGND sg13cmos5l_or2_1
XFILLER_105_504 VPWR VGND sg13cmos5l_fill_1
X_06136_ _06140_/B _11582_/Q _11585_/Q _11584_/Q _11586_/Q VPWR VGND sg13cmos5l_nor4_1
XFILLER_105_537 VPWR VGND sg13cmos5l_decap_8
X_06067_ _06067_/X _10826_/Q _06927_/A VPWR VGND sg13cmos5l_or2_1
Xfanout401 _09983_/C1 _10016_/C1 VPWR VGND sg13cmos5l_buf_1
Xfanout423 _09577_/B1 fanout432/X VPWR VGND sg13cmos5l_buf_1
Xfanout412 _06477_/B _09659_/S1 VPWR VGND sg13cmos5l_buf_1
XFILLER_58_101 VPWR VGND sg13cmos5l_fill_2
Xfanout445 _09957_/B _09981_/B VPWR VGND sg13cmos5l_buf_1
Xfanout434 _09570_/B _06512_/B VPWR VGND sg13cmos5l_buf_1
Xfanout456 _09499_/B _06451_/Y VPWR VGND sg13cmos5l_buf_1
XFILLER_104_21 VPWR VGND sg13cmos5l_decap_8
X_09826_ _09826_/Y _09902_/A _09821_/X _09825_/Y VPWR VGND sg13cmos5l_o21ai_1
XFILLER_87_977 VPWR VGND sg13cmos5l_decap_8
Xfanout478 _09984_/B _09824_/A2 VPWR VGND sg13cmos5l_buf_1
XFILLER_58_156 VPWR VGND sg13cmos5l_decap_8
XFILLER_46_307 VPWR VGND sg13cmos5l_fill_1
Xfanout489 _10088_/A2 _10062_/A2 VPWR VGND sg13cmos5l_buf_1
XFILLER_24_1028 VPWR VGND sg13cmos5l_fill_1
Xfanout467 _09659_/S0 fanout482/X VPWR VGND sg13cmos5l_buf_1
X_09757_ _09757_/Y _10974_/Q _09870_/B _09990_/S1 VPWR VGND sg13cmos5l_a21oi_1
X_06969_ _06969_/X _11492_/Q hold2596/X _07030_/B VPWR VGND sg13cmos5l_mux2_1
XFILLER_64_36 VPWR VGND sg13cmos5l_fill_1
XFILLER_64_14 VPWR VGND sg13cmos5l_fill_2
X_08708_ _08950_/B _07362_/B _07550_/B _07338_/Y VPWR VGND sg13cmos5l_o21ai_1
XFILLER_104_98 VPWR VGND sg13cmos5l_decap_8
X_09688_ _09688_/X _11259_/Q _11227_/Q _11195_/Q _11163_/Q _06468_/B _09688_/S1 VPWR
+ VGND sg13cmos5l_mux4_1
XFILLER_27_565 VPWR VGND sg13cmos5l_decap_8
X_08639_ _08639_/Y _05945_/Y _08642_/S _08638_/Y VPWR VGND sg13cmos5l_a21oi_1
XFILLER_80_13 VPWR VGND sg13cmos5l_decap_8
X_11650_ _11650_/Q _11668_/CLK _11650_/D _11650_/RESET_B VPWR VGND sg13cmos5l_dfrbpq_1
XFILLER_30_708 VPWR VGND sg13cmos5l_decap_8
Xfanout74 fanout74/X _07586_/Y VPWR VGND sg13cmos5l_buf_1
Xfanout52 fanout52/X _07645_/Y VPWR VGND sg13cmos5l_buf_1
Xfanout63 fanout63/X _07606_/Y VPWR VGND sg13cmos5l_buf_1
XFILLER_70_1004 VPWR VGND sg13cmos5l_fill_2
X_11581_ _11581_/Q clkload21/A _11581_/D _11581_/RESET_B VPWR VGND sg13cmos5l_dfrbpq_1
X_10601_ _10601_/X _10601_/A _10675_/B VPWR VGND sg13cmos5l_and2_1
Xfanout85 fanout85/X _10468_/Y VPWR VGND sg13cmos5l_buf_1
X_10532_ _10532_/Y hold2807/X _10849_/Q _10536_/C VPWR VGND sg13cmos5l_a21oi_1
XFILLER_13_51 VPWR VGND sg13cmos5l_fill_2
Xfanout96 fanout96/X _07552_/Y VPWR VGND sg13cmos5l_buf_1
X_10463_ _10464_/B _10424_/A _10479_/B _10479_/C _10433_/A _10433_/B VPWR VGND sg13cmos5l_a221oi_1
X_10394_ _10394_/Y _10411_/A _10394_/B VPWR VGND sg13cmos5l_nor2_1
XFILLER_2_664 VPWR VGND sg13cmos5l_fill_2
X_11015_ _11015_/Q _11364_/CLK _11015_/D _11015_/RESET_B VPWR VGND sg13cmos5l_dfrbpq_1
XFILLER_78_955 VPWR VGND sg13cmos5l_decap_8
XFILLER_1_185 VPWR VGND sg13cmos5l_fill_1
XFILLER_49_156 VPWR VGND sg13cmos5l_fill_2
XFILLER_64_104 VPWR VGND sg13cmos5l_fill_2
XFILLER_37_307 VPWR VGND sg13cmos5l_decap_4
XFILLER_46_852 VPWR VGND sg13cmos5l_fill_1
XFILLER_38_92 VPWR VGND sg13cmos5l_decap_8
XFILLER_18_543 VPWR VGND sg13cmos5l_decap_4
XFILLER_73_671 VPWR VGND sg13cmos5l_decap_8
XFILLER_73_660 VPWR VGND sg13cmos5l_fill_1
XFILLER_61_822 VPWR VGND sg13cmos5l_fill_2
XFILLER_60_354 VPWR VGND sg13cmos5l_decap_8
XFILLER_60_376 VPWR VGND sg13cmos5l_decap_8
XFILLER_86_1000 VPWR VGND sg13cmos5l_decap_4
Xclkload22 clkload22/X clkload22/A VPWR VGND sg13cmos5l_buf_8
Xclkload44 clkload44/X clkload44/A VPWR VGND sg13cmos5l_buf_8
Xclkload33 clkload33/Y clkload33/A VPWR VGND sg13cmos5l_inv_1
Xclkload11 clkload11/X clkload11/A VPWR VGND sg13cmos5l_buf_8
Xclkload55 clkload55/X clkload55/A VPWR VGND sg13cmos5l_buf_8
XFILLER_47_1028 VPWR VGND sg13cmos5l_fill_1
X_08990_ _08990_/Y _08990_/A _09004_/B VPWR VGND sg13cmos5l_nand2_1
X_11088__1813 _11088_/RESET_B VPWR VGND sg13cmos5l_tiehi
Xhold2828 _10135_/A _11512_/Q VPWR VGND sg13cmos5l_dlygate4sd3_1
Xhold2806 hold2806/X _11739_/Q VPWR VGND sg13cmos5l_dlygate4sd3_1
Xhold2817 _10846_/D _07224_/Y VPWR VGND sg13cmos5l_dlygate4sd3_1
X_07941_ _11060_/D _08071_/A1 _07940_/B _07940_/Y VPWR VGND sg13cmos5l_o21ai_1
Xhold2839 hold2839/X _11501_/Q VPWR VGND sg13cmos5l_dlygate4sd3_1
XFILLER_68_465 VPWR VGND sg13cmos5l_fill_1
X_07872_ _11026_/D _08524_/A1 _07881_/B _07871_/Y VPWR VGND sg13cmos5l_a21oi_1
XFILLER_29_819 VPWR VGND sg13cmos5l_fill_2
XFILLER_96_785 VPWR VGND sg13cmos5l_fill_1
XFILLER_95_262 VPWR VGND sg13cmos5l_decap_8
X_06823_ _06823_/Y _06823_/A _10785_/B VPWR VGND sg13cmos5l_nand2_1
XFILLER_68_498 VPWR VGND sg13cmos5l_fill_1
X_09611_ _09611_/Y _09611_/A _09721_/B VPWR VGND sg13cmos5l_nor2_1
XFILLER_56_649 VPWR VGND sg13cmos5l_decap_8
XFILLER_37_830 VPWR VGND sg13cmos5l_decap_8
X_09542_ _09543_/C _09215_/B _09542_/B VPWR VGND sg13cmos5l_nand2b_1
X_06754_ _06754_/Y _06748_/A _06745_/Y _06308_/Y VPWR VGND sg13cmos5l_o21ai_1
XFILLER_52_800 VPWR VGND sg13cmos5l_fill_2
XFILLER_36_351 VPWR VGND sg13cmos5l_decap_4
XFILLER_93_1026 VPWR VGND sg13cmos5l_fill_2
XFILLER_64_682 VPWR VGND sg13cmos5l_fill_2
X_09473_ _09473_/Y _11347_/Q _09576_/B VPWR VGND sg13cmos5l_nand2_1
X_06685_ _06686_/B _06685_/A _06685_/B VPWR VGND sg13cmos5l_nor2_1
XFILLER_63_192 VPWR VGND sg13cmos5l_fill_1
XFILLER_52_877 VPWR VGND sg13cmos5l_decap_4
X_08424_ _11297_/D fanout68/X _08423_/B _08423_/Y VPWR VGND sg13cmos5l_a21oi_1
XFILLER_34_39 VPWR VGND sg13cmos5l_fill_1
X_08355_ _11263_/D fanout74/X _08372_/B _08354_/Y VPWR VGND sg13cmos5l_o21ai_1
XFILLER_52_899 VPWR VGND sg13cmos5l_decap_8
XFILLER_51_398 VPWR VGND sg13cmos5l_decap_4
Xclkload5 clkload5/X clkload5/A VPWR VGND sg13cmos5l_buf_8
X_07306_ _07306_/Y _07407_/B _07304_/Y _07305_/Y VPWR VGND sg13cmos5l_a21oi_1
XFILLER_50_38 VPWR VGND sg13cmos5l_decap_4
X_08286_ _11229_/D fanout78/X _08285_/B _08285_/Y VPWR VGND sg13cmos5l_a21oi_1
X_07237_ _07237_/Y _10853_/Q _07237_/A2 _07243_/B1 hold2658/X VPWR VGND sg13cmos5l_a22oi_1
XFILLER_105_301 VPWR VGND sg13cmos5l_decap_8
X_07168_ _07168_/Y _07167_/Y _10783_/C VPWR VGND sg13cmos5l_nand2b_1
XFILLER_3_417 VPWR VGND sg13cmos5l_fill_2
XFILLER_106_868 VPWR VGND sg13cmos5l_decap_8
X_06119_ _06120_/A _06133_/B _06122_/B _06121_/B _06133_/A VPWR VGND sg13cmos5l_a22oi_1
XFILLER_105_356 VPWR VGND sg13cmos5l_decap_8
X_07099_ _11714_/D _07205_/A _07098_/B _07098_/Y VPWR VGND sg13cmos5l_a21oi_1
XFILLER_1_7 VPWR VGND sg13cmos5l_decap_8
XFILLER_87_730 VPWR VGND sg13cmos5l_fill_2
Xfanout231 _07883_/B _07854_/Y VPWR VGND sg13cmos5l_buf_1
Xfanout220 _08007_/B _08013_/B VPWR VGND sg13cmos5l_buf_1
Xfanout253 _07704_/B _07712_/B VPWR VGND sg13cmos5l_buf_1
Xfanout242 _07784_/B _07778_/B VPWR VGND sg13cmos5l_buf_1
Xfanout264 _07517_/B _07566_/B VPWR VGND sg13cmos5l_buf_1
Xfanout297 _08108_/B _08049_/Y VPWR VGND sg13cmos5l_buf_1
XFILLER_86_284 VPWR VGND sg13cmos5l_fill_1
XFILLER_86_273 VPWR VGND sg13cmos5l_decap_8
Xfanout286 _08368_/B _08374_/B VPWR VGND sg13cmos5l_buf_1
XFILLER_75_24 VPWR VGND sg13cmos5l_fill_1
X_09809_ _09811_/C _09754_/A _09754_/B _09166_/D VPWR VGND sg13cmos5l_o21ai_1
XFILLER_47_616 VPWR VGND sg13cmos5l_decap_4
Xfanout275 _08876_/A _08890_/A VPWR VGND sg13cmos5l_buf_1
XFILLER_19_329 VPWR VGND sg13cmos5l_decap_8
XFILLER_90_906 VPWR VGND sg13cmos5l_decap_4
XFILLER_75_57 VPWR VGND sg13cmos5l_decap_8
X_10877__1105 _10877_/RESET_B VPWR VGND sg13cmos5l_tiehi
XFILLER_28_841 VPWR VGND sg13cmos5l_fill_1
XFILLER_15_524 VPWR VGND sg13cmos5l_fill_2
XFILLER_91_56 VPWR VGND sg13cmos5l_decap_8
X_11702_ _11702_/Q clkload31/A _11702_/D _11702_/RESET_B VPWR VGND sg13cmos5l_dfrbpq_1
X_11633_ _11633_/Q _11713_/CLK _11633_/D _11633_/RESET_B VPWR VGND sg13cmos5l_dfrbpq_1
X_11166__1735 _11166_/RESET_B VPWR VGND sg13cmos5l_tiehi
X_11564_ _11564_/Q clkload29/A _11564_/D _11564_/RESET_B VPWR VGND sg13cmos5l_dfrbpq_1
XFILLER_7_712 VPWR VGND sg13cmos5l_fill_1
XFILLER_6_200 VPWR VGND sg13cmos5l_decap_8
X_10515_ _10515_/Y _10568_/B _10515_/B VPWR VGND sg13cmos5l_xnor2_1
X_11495_ _11495_/Q _11671_/CLK _11495_/D _11495_/RESET_B VPWR VGND sg13cmos5l_dfrbpq_1
X_10446_ _10456_/C _11407_/Q _10844_/Q VPWR VGND sg13cmos5l_nor2_1
XFILLER_6_255 VPWR VGND sg13cmos5l_fill_2
X_10377_ _10378_/C _10347_/Y _10363_/Y _10362_/Y VPWR VGND sg13cmos5l_o21ai_1
XFILLER_105_890 VPWR VGND sg13cmos5l_decap_8
XFILLER_97_538 VPWR VGND sg13cmos5l_fill_1
XFILLER_97_527 VPWR VGND sg13cmos5l_decap_4
X_11416__1458 _11416_/RESET_B VPWR VGND sg13cmos5l_tiehi
XFILLER_93_700 VPWR VGND sg13cmos5l_fill_2
XFILLER_78_796 VPWR VGND sg13cmos5l_fill_2
XFILLER_78_785 VPWR VGND sg13cmos5l_decap_8
XFILLER_78_774 VPWR VGND sg13cmos5l_decap_4
XFILLER_66_947 VPWR VGND sg13cmos5l_fill_2
XFILLER_38_638 VPWR VGND sg13cmos5l_decap_8
XFILLER_1_21 VPWR VGND sg13cmos5l_decap_8
XFILLER_65_435 VPWR VGND sg13cmos5l_decap_8
XFILLER_92_276 VPWR VGND sg13cmos5l_decap_8
XFILLER_65_479 VPWR VGND sg13cmos5l_decap_8
XFILLER_34_844 VPWR VGND sg13cmos5l_decap_4
Xclkbuf_leaf_72_clk clkload10/A clkbuf_4_0_0_clk/X VPWR VGND sg13cmos5l_buf_8
X_06470_ _06470_/Y _11052_/Q _09600_/B VPWR VGND sg13cmos5l_nand2_1
X_11613__1364 _11613_/RESET_B VPWR VGND sg13cmos5l_tiehi
XFILLER_33_365 VPWR VGND sg13cmos5l_decap_8
XFILLER_14_1005 VPWR VGND sg13cmos5l_decap_8
X_08140_ _11157_/D _08530_/A1 _08155_/B _08139_/Y VPWR VGND sg13cmos5l_a21oi_1
X_08071_ _11124_/D _08071_/A1 _08074_/B _08070_/Y VPWR VGND sg13cmos5l_o21ai_1
XFILLER_60_0 VPWR VGND sg13cmos5l_fill_1
X_07022_ _07022_/Y _07022_/A _07026_/B VPWR VGND sg13cmos5l_nand2_1
X_10955__1027 _10955_/RESET_B VPWR VGND sg13cmos5l_tiehi
XFILLER_88_516 VPWR VGND sg13cmos5l_fill_2
XFILLER_103_849 VPWR VGND sg13cmos5l_decap_8
Xhold2603 _08624_/A _11376_/Q VPWR VGND sg13cmos5l_dlygate4sd3_1
X_08973_ _08997_/C _08973_/A _08973_/B VPWR VGND sg13cmos5l_nand2_1
Xhold1902 _08090_/A _11134_/Q VPWR VGND sg13cmos5l_dlygate4sd3_1
Xhold2614 hold2614/X _11574_/Q VPWR VGND sg13cmos5l_dlygate4sd3_1
Xhold2625 _06834_/A _06833_/Y VPWR VGND sg13cmos5l_dlygate4sd3_1
Xhold2647 hold2647/X _06943_/Y VPWR VGND sg13cmos5l_dlygate4sd3_1
Xhold2636 hold2636/X _06080_/Y VPWR VGND sg13cmos5l_dlygate4sd3_1
XFILLER_29_28 VPWR VGND sg13cmos5l_fill_2
X_07924_ _07924_/Y _07924_/A _07942_/B VPWR VGND sg13cmos5l_nand2_1
Xhold1913 _07960_/A _11070_/Q VPWR VGND sg13cmos5l_dlygate4sd3_1
Xhold2669 _06927_/A _11640_/Q VPWR VGND sg13cmos5l_dlygate4sd3_1
Xhold1924 _08366_/A _11269_/Q VPWR VGND sg13cmos5l_dlygate4sd3_1
Xhold2658 hold2658/X _11708_/Q VPWR VGND sg13cmos5l_dlygate4sd3_1
Xhold1935 _08328_/A _11250_/Q VPWR VGND sg13cmos5l_dlygate4sd3_1
XFILLER_96_593 VPWR VGND sg13cmos5l_fill_1
X_07855_ _07855_/Y _07855_/A _07913_/B VPWR VGND sg13cmos5l_nor2_1
XFILLER_56_457 VPWR VGND sg13cmos5l_decap_8
Xhold1968 _11435_/D _08904_/Y VPWR VGND sg13cmos5l_dlygate4sd3_1
Xhold1957 _08064_/A _11121_/Q VPWR VGND sg13cmos5l_dlygate4sd3_1
Xhold1946 _08186_/A _11180_/Q VPWR VGND sg13cmos5l_dlygate4sd3_1
X_11244__1657 _11244_/RESET_B VPWR VGND sg13cmos5l_tiehi
XFILLER_28_115 VPWR VGND sg13cmos5l_fill_2
X_07786_ _08311_/A _07786_/A _07786_/B _08441_/A _07786_/D VPWR VGND sg13cmos5l_nor4_1
X_06806_ _06806_/Y _06806_/A _10762_/S VPWR VGND sg13cmos5l_nand2_1
XFILLER_84_788 VPWR VGND sg13cmos5l_decap_4
XFILLER_83_254 VPWR VGND sg13cmos5l_fill_2
XFILLER_56_468 VPWR VGND sg13cmos5l_decap_8
XFILLER_45_38 VPWR VGND sg13cmos5l_fill_1
Xhold1979 _08080_/A _11129_/Q VPWR VGND sg13cmos5l_dlygate4sd3_1
X_11546__1481 _11546_/RESET_B VPWR VGND sg13cmos5l_tiehi
X_09525_ _09526_/C _09521_/Y _09522_/Y _09523_/Y _09524_/Y _06474_/A VPWR VGND sg13cmos5l_a221oi_1
X_06737_ _06737_/Y _06732_/A _06728_/B _06306_/Y VPWR VGND sg13cmos5l_o21ai_1
Xclkbuf_leaf_63_clk _11535_/CLK clkload3/A VPWR VGND sg13cmos5l_buf_8
XFILLER_36_192 VPWR VGND sg13cmos5l_decap_8
X_06668_ _10806_/D _06668_/A1 _06664_/Y _06667_/Y VPWR VGND sg13cmos5l_o21ai_1
X_09456_ _09457_/B _09456_/A _09456_/B VPWR VGND sg13cmos5l_nor2_1
X_08407_ _08407_/Y _08407_/A _08423_/B VPWR VGND sg13cmos5l_nor2_1
XFILLER_101_77 VPWR VGND sg13cmos5l_decap_8
XFILLER_51_184 VPWR VGND sg13cmos5l_decap_8
X_06599_ _06599_/Y _06614_/A _06599_/B VPWR VGND sg13cmos5l_nor2_1
XFILLER_8_509 VPWR VGND sg13cmos5l_decap_4
X_09387_ _09387_/X _11120_/Q _11088_/Q _11056_/Q _11024_/Q _09440_/B _09551_/S1 VPWR
+ VGND sg13cmos5l_mux4_1
XFILLER_24_398 VPWR VGND sg13cmos5l_decap_8
X_08338_ _08338_/Y _08338_/A _08338_/B VPWR VGND sg13cmos5l_nand2_1
X_08269_ _08269_/Y _08269_/A _08293_/B VPWR VGND sg13cmos5l_nor2_1
X_10300_ _10481_/B _10300_/A _10300_/B VPWR VGND sg13cmos5l_nor2_1
XFILLER_4_726 VPWR VGND sg13cmos5l_fill_1
XFILLER_4_704 VPWR VGND sg13cmos5l_fill_1
X_11280_ _11280_/Q _11671_/CLK _11280_/D _11280_/RESET_B VPWR VGND sg13cmos5l_dfrbpq_1
X_10231_ _10317_/B _10232_/A _10232_/B _10232_/C VPWR VGND sg13cmos5l_o21ai_1
XFILLER_106_665 VPWR VGND sg13cmos5l_decap_8
XFILLER_10_63 VPWR VGND sg13cmos5l_fill_1
XFILLER_3_258 VPWR VGND sg13cmos5l_decap_8
XFILLER_105_175 VPWR VGND sg13cmos5l_decap_8
X_10162_ _10162_/X _10162_/A _10162_/B VPWR VGND sg13cmos5l_or2_1
XFILLER_0_943 VPWR VGND sg13cmos5l_decap_8
X_10093_ _10093_/Y _10330_/B _09556_/Y _10092_/Y VPWR VGND sg13cmos5l_a21oi_1
XFILLER_86_89 VPWR VGND sg13cmos5l_decap_8
XFILLER_101_392 VPWR VGND sg13cmos5l_fill_1
XFILLER_75_733 VPWR VGND sg13cmos5l_fill_2
XFILLER_74_210 VPWR VGND sg13cmos5l_fill_1
XFILLER_47_424 VPWR VGND sg13cmos5l_fill_1
XFILLER_19_61 VPWR VGND sg13cmos5l_fill_1
XFILLER_90_703 VPWR VGND sg13cmos5l_fill_2
XFILLER_19_148 VPWR VGND sg13cmos5l_fill_2
XFILLER_90_736 VPWR VGND sg13cmos5l_fill_1
XFILLER_74_287 VPWR VGND sg13cmos5l_fill_1
XFILLER_71_972 VPWR VGND sg13cmos5l_fill_1
X_10995_ _10995_/Q clkload17/A _10995_/D _10995_/RESET_B VPWR VGND sg13cmos5l_dfrbpq_1
Xclkbuf_leaf_54_clk clkload41/A clkbuf_4_10_0_clk/X VPWR VGND sg13cmos5l_buf_8
XFILLER_15_321 VPWR VGND sg13cmos5l_decap_4
XFILLER_42_151 VPWR VGND sg13cmos5l_fill_1
XFILLER_35_82 VPWR VGND sg13cmos5l_decap_8
XFILLER_30_324 VPWR VGND sg13cmos5l_fill_1
X_11616_ _11616_/Q clkload27/A _11616_/D _11616_/RESET_B VPWR VGND sg13cmos5l_dfrbpq_1
XFILLER_30_357 VPWR VGND sg13cmos5l_decap_8
X_11547_ _11547_/Q clkload47/A _11547_/D _11547_/RESET_B VPWR VGND sg13cmos5l_dfrbpq_1
X_11478_ _11478_/Q clkload48/A _11478_/D _11478_/RESET_B VPWR VGND sg13cmos5l_dfrbpq_1
X_11322__1579 _11322_/RESET_B VPWR VGND sg13cmos5l_tiehi
X_10429_ _10429_/Y _10429_/A _10422_/Y VPWR VGND sg13cmos5l_nor2b_1
X_05970_ _05970_/Y _05970_/A VPWR VGND sg13cmos5l_inv_1
XFILLER_38_402 VPWR VGND sg13cmos5l_decap_8
XFILLER_39_947 VPWR VGND sg13cmos5l_decap_8
XFILLER_38_446 VPWR VGND sg13cmos5l_decap_8
XFILLER_18_2 VPWR VGND sg13cmos5l_fill_1
X_07640_ _07640_/Y _07640_/A _07640_/B VPWR VGND sg13cmos5l_nor2_1
XFILLER_93_552 VPWR VGND sg13cmos5l_decap_4
XFILLER_54_939 VPWR VGND sg13cmos5l_fill_1
XFILLER_81_747 VPWR VGND sg13cmos5l_fill_1
XFILLER_80_213 VPWR VGND sg13cmos5l_fill_1
X_07571_ _07571_/Y _07577_/A _08721_/B _07570_/Y VPWR VGND sg13cmos5l_a21oi_1
Xclkbuf_leaf_45_clk clkload48/A clkbuf_4_12_0_clk/X VPWR VGND sg13cmos5l_buf_8
X_09310_ _09310_/Y _09376_/A _09301_/S _09319_/C VPWR VGND sg13cmos5l_o21ai_1
X_06522_ _06523_/B _09395_/A _06517_/X _06521_/Y VPWR VGND sg13cmos5l_o21ai_1
XFILLER_34_652 VPWR VGND sg13cmos5l_decap_8
XFILLER_61_460 VPWR VGND sg13cmos5l_decap_8
X_06453_ _06453_/X _10140_/A _11634_/Q VPWR VGND sg13cmos5l_and2_1
X_09241_ _09244_/B _10267_/D _10848_/Q _09240_/Y VPWR VGND sg13cmos5l_a21oi_1
XFILLER_33_195 VPWR VGND sg13cmos5l_decap_4
X_09172_ _09172_/X _09456_/A _10836_/Q VPWR VGND sg13cmos5l_and2_1
X_06384_ _06385_/C _06368_/Y _06374_/Y _06383_/Y _06211_/B _06382_/X VPWR VGND sg13cmos5l_a221oi_1
X_08123_ _08123_/Y _08123_/A _08135_/B VPWR VGND sg13cmos5l_nor2_1
X_08054_ _08054_/Y _08054_/A _08088_/B VPWR VGND sg13cmos5l_nand2_1
X_07005_ _07005_/X hold2477/X _07062_/S _07004_/Y VPWR VGND sg13cmos5l_a21o_1
Xoutput29 uio_out[6] _12766_/X VPWR VGND sg13cmos5l_buf_1
XFILLER_103_602 VPWR VGND sg13cmos5l_decap_8
XFILLER_88_302 VPWR VGND sg13cmos5l_decap_4
XFILLER_102_112 VPWR VGND sg13cmos5l_decap_8
Xhold2411 _07879_/A _11030_/Q VPWR VGND sg13cmos5l_dlygate4sd3_1
Xhold2422 _07734_/A _10960_/Q VPWR VGND sg13cmos5l_dlygate4sd3_1
Xhold2400 _07263_/A _10861_/Q VPWR VGND sg13cmos5l_dlygate4sd3_1
Xhold2455 _06828_/A _11610_/Q VPWR VGND sg13cmos5l_dlygate4sd3_1
Xhold2433 _08778_/A _11425_/Q VPWR VGND sg13cmos5l_dlygate4sd3_1
X_08956_ _08956_/Y _08955_/A _08952_/Y _08953_/Y _08955_/Y _09131_/A VPWR VGND sg13cmos5l_a221oi_1
Xhold2444 _07317_/A _10870_/Q VPWR VGND sg13cmos5l_dlygate4sd3_1
XFILLER_102_189 VPWR VGND sg13cmos5l_decap_8
X_07907_ _07907_/Y _07907_/A _07913_/B VPWR VGND sg13cmos5l_nor2_1
Xhold2488 _06823_/A _11608_/Q VPWR VGND sg13cmos5l_dlygate4sd3_1
XFILLER_56_26 VPWR VGND sg13cmos5l_fill_1
X_08887_ _08889_/B _08910_/A _08888_/C _08906_/A VPWR VGND sg13cmos5l_o21ai_1
Xhold2466 _06118_/B _06117_/Y VPWR VGND sg13cmos5l_dlygate4sd3_1
Xhold2477 hold2477/X _11663_/Q VPWR VGND sg13cmos5l_dlygate4sd3_1
X_07838_ _07838_/Y _07838_/A _07850_/B VPWR VGND sg13cmos5l_nand2_1
XFILLER_84_541 VPWR VGND sg13cmos5l_fill_2
Xhold2499 _11584_/D _10768_/X VPWR VGND sg13cmos5l_dlygate4sd3_1
XFILLER_57_788 VPWR VGND sg13cmos5l_fill_1
Xclkbuf_leaf_36_clk clkload57/A clkload6/A VPWR VGND sg13cmos5l_buf_8
XFILLER_72_758 VPWR VGND sg13cmos5l_decap_8
XFILLER_44_449 VPWR VGND sg13cmos5l_fill_2
X_07769_ _10977_/D fanout67/X _07768_/B _07768_/Y VPWR VGND sg13cmos5l_a21oi_1
X_09508_ _09508_/Y _09537_/A _09508_/B VPWR VGND sg13cmos5l_nor2_1
X_10780_ _10781_/A _10688_/A _10771_/B _10777_/C _10779_/Y VPWR VGND sg13cmos5l_a22oi_1
XFILLER_71_268 VPWR VGND sg13cmos5l_fill_2
XFILLER_13_803 VPWR VGND sg13cmos5l_decap_8
X_09439_ _09460_/B _09439_/A _09438_/Y VPWR VGND sg13cmos5l_nor2b_1
XFILLER_8_328 VPWR VGND sg13cmos5l_decap_8
X_11401_ _11401_/Q _11528_/CLK _11401_/D _11401_/RESET_B VPWR VGND sg13cmos5l_dfrbpq_1
XFILLER_21_40 VPWR VGND sg13cmos5l_decap_8
X_11332_ _11332_/Q _11594_/CLK _11332_/D _11332_/RESET_B VPWR VGND sg13cmos5l_dfrbpq_1
X_11263_ _11263_/Q _11364_/CLK _11263_/D _11263_/RESET_B VPWR VGND sg13cmos5l_dfrbpq_1
X_11456__1360 _11456_/RESET_B VPWR VGND sg13cmos5l_tiehi
XFILLER_106_462 VPWR VGND sg13cmos5l_decap_8
XFILLER_79_302 VPWR VGND sg13cmos5l_decap_8
X_10214_ _10214_/Y _10694_/A _10214_/B VPWR VGND sg13cmos5l_nor2_1
XFILLER_4_589 VPWR VGND sg13cmos5l_decap_8
X_11194_ _11194_/Q _11361_/CLK _11194_/D _11194_/RESET_B VPWR VGND sg13cmos5l_dfrbpq_1
XFILLER_97_77 VPWR VGND sg13cmos5l_decap_8
XFILLER_79_357 VPWR VGND sg13cmos5l_fill_1
X_10145_ _10145_/X hold2906/X _10149_/B _10144_/Y VPWR VGND sg13cmos5l_a21o_1
XFILLER_67_519 VPWR VGND sg13cmos5l_decap_8
XFILLER_67_508 VPWR VGND sg13cmos5l_fill_2
XFILLER_0_751 VPWR VGND sg13cmos5l_decap_8
XFILLER_94_327 VPWR VGND sg13cmos5l_decap_8
X_10076_ _10076_/Y _10073_/B _10075_/Y _10073_/Y VPWR VGND sg13cmos5l_o21ai_1
XFILLER_48_788 VPWR VGND sg13cmos5l_decap_4
XFILLER_35_405 VPWR VGND sg13cmos5l_decap_8
XFILLER_35_427 VPWR VGND sg13cmos5l_fill_2
XFILLER_35_416 VPWR VGND sg13cmos5l_fill_1
XFILLER_29_980 VPWR VGND sg13cmos5l_decap_8
Xclkbuf_leaf_27_clk clkload31/A clkbuf_4_6_0_clk/X VPWR VGND sg13cmos5l_buf_8
XFILLER_35_449 VPWR VGND sg13cmos5l_fill_1
X_10978_ _10978_/Q _11362_/CLK _10978_/D _10978_/RESET_B VPWR VGND sg13cmos5l_dfrbpq_1
XFILLER_44_972 VPWR VGND sg13cmos5l_fill_1
XFILLER_43_471 VPWR VGND sg13cmos5l_decap_8
XFILLER_15_151 VPWR VGND sg13cmos5l_fill_1
XFILLER_15_162 VPWR VGND sg13cmos5l_fill_2
XFILLER_7_394 VPWR VGND sg13cmos5l_fill_1
X_10872__1110 _10872_/RESET_B VPWR VGND sg13cmos5l_tiehi
XFILLER_97_110 VPWR VGND sg13cmos5l_decap_8
XFILLER_86_806 VPWR VGND sg13cmos5l_fill_2
Xfanout819 _10560_/A _05933_/Y VPWR VGND sg13cmos5l_buf_1
X_08810_ _11427_/D _08808_/Y _08809_/Y _08801_/Y VPWR VGND sg13cmos5l_o21ai_1
Xfanout808 _08880_/A1 _08774_/B VPWR VGND sg13cmos5l_buf_1
X_09790_ _09790_/Y _11007_/Q _10041_/B VPWR VGND sg13cmos5l_nand2_1
XFILLER_98_688 VPWR VGND sg13cmos5l_fill_1
XFILLER_97_154 VPWR VGND sg13cmos5l_fill_1
X_05953_ _05953_/Y _10831_/Q VPWR VGND sg13cmos5l_inv_1
X_08741_ _08742_/B _08750_/A _08741_/B VPWR VGND sg13cmos5l_nand2_1
X_05884_ _05884_/Y input14/X VPWR VGND sg13cmos5l_inv_1
X_08672_ _08852_/B _08841_/A VPWR VGND sg13cmos5l_inv_1
XFILLER_39_755 VPWR VGND sg13cmos5l_decap_8
XFILLER_27_928 VPWR VGND sg13cmos5l_fill_1
X_07623_ _07643_/D _07623_/A _07623_/B VPWR VGND sg13cmos5l_nor2_1
XFILLER_54_714 VPWR VGND sg13cmos5l_fill_2
Xclkbuf_leaf_18_clk _11646_/CLK clkload1/A VPWR VGND sg13cmos5l_buf_8
XFILLER_81_566 VPWR VGND sg13cmos5l_decap_4
XFILLER_53_246 VPWR VGND sg13cmos5l_fill_1
XFILLER_53_235 VPWR VGND sg13cmos5l_decap_8
X_11161__1740 _11161_/RESET_B VPWR VGND sg13cmos5l_tiehi
X_07554_ _07554_/Y _07554_/A _07629_/B VPWR VGND sg13cmos5l_nor2_1
XFILLER_41_408 VPWR VGND sg13cmos5l_fill_1
XFILLER_50_931 VPWR VGND sg13cmos5l_fill_2
X_06505_ _06509_/A _06505_/A _06505_/B VPWR VGND sg13cmos5l_nand2_1
XFILLER_22_633 VPWR VGND sg13cmos5l_fill_1
X_07485_ _07485_/Y _10229_/A _07500_/D _07515_/A VPWR VGND sg13cmos5l_o21ai_1
XFILLER_34_471 VPWR VGND sg13cmos5l_decap_8
X_06436_ _06436_/Y _06436_/A _06722_/B VPWR VGND sg13cmos5l_nor2_1
XFILLER_61_290 VPWR VGND sg13cmos5l_decap_8
XFILLER_21_154 VPWR VGND sg13cmos5l_fill_2
X_09224_ _09225_/C _09214_/A _10841_/Q _10842_/Q _09480_/A VPWR VGND sg13cmos5l_a22oi_1
XFILLER_22_688 VPWR VGND sg13cmos5l_decap_8
XFILLER_22_699 VPWR VGND sg13cmos5l_decap_8
X_09155_ _09155_/Y _09155_/A _09155_/B VPWR VGND sg13cmos5l_nand2_1
X_06367_ _06367_/Y _06364_/Y _06366_/C _06361_/Y VPWR VGND sg13cmos5l_a21oi_1
XFILLER_21_198 VPWR VGND sg13cmos5l_decap_8
X_08106_ _08106_/Y _08106_/A _08106_/B VPWR VGND sg13cmos5l_nand2_1
X_09086_ _09087_/B _09075_/X _09097_/A _09076_/Y VPWR VGND sg13cmos5l_o21ai_1
X_06298_ _06298_/Y _06179_/B _06646_/A _06297_/Y VPWR VGND sg13cmos5l_a21oi_1
X_08037_ _08037_/Y _08037_/A _08043_/B VPWR VGND sg13cmos5l_nor2_1
XFILLER_101_7 VPWR VGND sg13cmos5l_decap_8
XFILLER_104_922 VPWR VGND sg13cmos5l_decap_8
XFILLER_89_611 VPWR VGND sg13cmos5l_fill_2
XFILLER_1_504 VPWR VGND sg13cmos5l_decap_8
XFILLER_104_999 VPWR VGND sg13cmos5l_decap_8
X_09988_ _09989_/C _09984_/Y _09985_/Y _09986_/Y _09987_/Y _10038_/C1 VPWR VGND sg13cmos5l_a221oi_1
XFILLER_76_316 VPWR VGND sg13cmos5l_decap_4
XFILLER_67_25 VPWR VGND sg13cmos5l_decap_8
Xhold2230 _08009_/A _11094_/Q VPWR VGND sg13cmos5l_dlygate4sd3_1
Xhold2263 _08563_/A _11366_/Q VPWR VGND sg13cmos5l_dlygate4sd3_1
X_08939_ _08964_/B _08914_/A _08930_/B _08926_/Y VPWR VGND sg13cmos5l_o21ai_1
Xhold2241 _08519_/A _11344_/Q VPWR VGND sg13cmos5l_dlygate4sd3_1
Xhold2252 _08149_/A _11162_/Q VPWR VGND sg13cmos5l_dlygate4sd3_1
Xhold2274 hold2274/X _07299_/Y VPWR VGND sg13cmos5l_dlygate4sd3_1
Xhold2285 _08153_/A _11164_/Q VPWR VGND sg13cmos5l_dlygate4sd3_1
Xhold2296 _08511_/A _11340_/Q VPWR VGND sg13cmos5l_dlygate4sd3_1
XFILLER_91_319 VPWR VGND sg13cmos5l_fill_2
XFILLER_44_202 VPWR VGND sg13cmos5l_decap_8
X_10901_ _10901_/Q clkload40/A _10901_/D _10901_/RESET_B VPWR VGND sg13cmos5l_dfrbpq_1
XFILLER_83_57 VPWR VGND sg13cmos5l_fill_2
XFILLER_17_449 VPWR VGND sg13cmos5l_decap_8
XFILLER_29_298 VPWR VGND sg13cmos5l_fill_2
XFILLER_72_599 VPWR VGND sg13cmos5l_fill_2
XFILLER_72_566 VPWR VGND sg13cmos5l_fill_2
X_10832_ _10832_/Q clkload19/A _10832_/D _10832_/RESET_B VPWR VGND sg13cmos5l_dfrbpq_1
XFILLER_16_40 VPWR VGND sg13cmos5l_decap_4
X_10763_ _10763_/X _06779_/D hold2575/X _10763_/S VPWR VGND sg13cmos5l_mux2_1
XFILLER_53_791 VPWR VGND sg13cmos5l_decap_8
XFILLER_41_942 VPWR VGND sg13cmos5l_fill_1
XFILLER_16_95 VPWR VGND sg13cmos5l_fill_2
X_10950__1032 _10950_/RESET_B VPWR VGND sg13cmos5l_tiehi
XFILLER_9_615 VPWR VGND sg13cmos5l_fill_2
X_10694_ _10695_/D _10694_/A _10694_/B VPWR VGND sg13cmos5l_nand2_1
XFILLER_12_165 VPWR VGND sg13cmos5l_fill_2
XFILLER_32_94 VPWR VGND sg13cmos5l_decap_4
X_11315_ _11315_/Q _11347_/CLK _11315_/D _11315_/RESET_B VPWR VGND sg13cmos5l_dfrbpq_1
XFILLER_5_887 VPWR VGND sg13cmos5l_decap_4
XFILLER_5_876 VPWR VGND sg13cmos5l_fill_1
XFILLER_4_375 VPWR VGND sg13cmos5l_decap_8
X_11246_ _11246_/Q _11668_/CLK _11246_/D _11246_/RESET_B VPWR VGND sg13cmos5l_dfrbpq_1
X_11177_ _11177_/Q clkload50/A _11177_/D _11177_/RESET_B VPWR VGND sg13cmos5l_dfrbpq_1
XFILLER_95_625 VPWR VGND sg13cmos5l_decap_8
XFILLER_79_165 VPWR VGND sg13cmos5l_fill_1
X_10128_ _11509_/D _10126_/Y _10127_/Y _10125_/Y VPWR VGND sg13cmos5l_o21ai_1
X_10059_ _10059_/Y _06523_/A hold2774/X _10062_/A2 VPWR VGND sg13cmos5l_a21oi_1
XFILLER_48_552 VPWR VGND sg13cmos5l_fill_1
XFILLER_36_736 VPWR VGND sg13cmos5l_decap_8
XFILLER_35_202 VPWR VGND sg13cmos5l_decap_4
XFILLER_35_213 VPWR VGND sg13cmos5l_fill_1
XFILLER_73_90 VPWR VGND sg13cmos5l_fill_2
XFILLER_50_238 VPWR VGND sg13cmos5l_fill_1
X_07270_ _07270_/Y _07359_/B _07268_/Y _07269_/Y VPWR VGND sg13cmos5l_a21oi_1
X_06221_ _06223_/B _10267_/A _10242_/B VPWR VGND sg13cmos5l_nand2_1
X_06152_ _06681_/A _06682_/A _06687_/A VPWR VGND sg13cmos5l_nand2_1
X_06083_ _11555_/D _06083_/A VPWR VGND sg13cmos5l_inv_1
X_11179__1722 _11179_/RESET_B VPWR VGND sg13cmos5l_tiehi
X_09911_ _09915_/C _10591_/A _09911_/B VPWR VGND sg13cmos5l_and2_1
Xclkbuf_leaf_7_clk _11528_/CLK clkload0/A VPWR VGND sg13cmos5l_buf_8
XFILLER_99_953 VPWR VGND sg13cmos5l_decap_8
Xfanout605 _09013_/B1 _08739_/B2 VPWR VGND sg13cmos5l_buf_1
Xfanout638 _10640_/A _05861_/Y VPWR VGND sg13cmos5l_buf_1
Xfanout627 _09131_/A _05939_/Y VPWR VGND sg13cmos5l_buf_1
XFILLER_59_806 VPWR VGND sg13cmos5l_decap_8
Xfanout616 _09755_/A _10032_/A VPWR VGND sg13cmos5l_buf_1
X_09842_ _09842_/Y _10913_/Q _09840_/S _09842_/B1 VPWR VGND sg13cmos5l_a21oi_1
Xfanout649 _06571_/B2 _11762_/Q VPWR VGND sg13cmos5l_buf_1
XFILLER_101_947 VPWR VGND sg13cmos5l_fill_2
X_09773_ _09773_/Y _09773_/A _09773_/B VPWR VGND sg13cmos5l_nor2_1
X_08724_ _08725_/A hold2556/X _09004_/B _08992_/B _09013_/B1 VPWR VGND sg13cmos5l_a22oi_1
X_06985_ _06985_/X hold2496/X _08626_/A1 _06984_/Y VPWR VGND sg13cmos5l_a21o_1
XFILLER_27_703 VPWR VGND sg13cmos5l_decap_4
XFILLER_100_479 VPWR VGND sg13cmos5l_decap_8
X_11102__1799 _11102_/RESET_B VPWR VGND sg13cmos5l_tiehi
X_05936_ _05936_/Y _09104_/A VPWR VGND sg13cmos5l_inv_1
X_11708__1256 _11708_/RESET_B VPWR VGND sg13cmos5l_tiehi
XFILLER_27_725 VPWR VGND sg13cmos5l_decap_8
XFILLER_82_864 VPWR VGND sg13cmos5l_decap_4
X_08655_ _08817_/A _08778_/A _07453_/X _08671_/S VPWR VGND sg13cmos5l_mux2_1
X_05867_ _05867_/Y _11409_/Q VPWR VGND sg13cmos5l_inv_1
XFILLER_26_224 VPWR VGND sg13cmos5l_decap_8
X_08586_ _08586_/Y _10162_/A _06060_/A _11633_/Q _10164_/B _09858_/B2 VPWR VGND sg13cmos5l_a221oi_1
X_07606_ _07606_/Y _07650_/A _08741_/B _07605_/Y VPWR VGND sg13cmos5l_o21ai_1
XFILLER_54_588 VPWR VGND sg13cmos5l_decap_4
XFILLER_41_216 VPWR VGND sg13cmos5l_fill_2
X_07537_ _07537_/Y _07537_/A _07537_/B VPWR VGND sg13cmos5l_nor2_1
XFILLER_50_783 VPWR VGND sg13cmos5l_fill_2
XFILLER_10_636 VPWR VGND sg13cmos5l_decap_8
X_07468_ _07468_/Y _07468_/A _07482_/B VPWR VGND sg13cmos5l_nor2_1
X_06419_ _06420_/C _10642_/A _06419_/B VPWR VGND sg13cmos5l_nand2b_1
X_07399_ _07399_/Y _07397_/Y _08751_/A _07400_/A2 VPWR VGND sg13cmos5l_a21oi_1
X_09207_ _09208_/C _09198_/A _10837_/Q _10838_/Q _09205_/A VPWR VGND sg13cmos5l_a22oi_1
X_09138_ _09148_/B _09150_/A _09138_/B VPWR VGND sg13cmos5l_xnor2_1
X_11626__1340 _11626_/RESET_B VPWR VGND sg13cmos5l_tiehi
X_09069_ _09072_/B _09069_/A _09069_/B _09069_/C _09069_/D VPWR VGND sg13cmos5l_nor4_1
X_11100_ _11100_/Q _11356_/CLK _11100_/D _11100_/RESET_B VPWR VGND sg13cmos5l_dfrbpq_1
X_11031_ _11031_/Q clkload17/A _11031_/D _11031_/RESET_B VPWR VGND sg13cmos5l_dfrbpq_1
XFILLER_76_102 VPWR VGND sg13cmos5l_fill_2
Xhold2060 _08224_/A _11199_/Q VPWR VGND sg13cmos5l_dlygate4sd3_1
XFILLER_77_669 VPWR VGND sg13cmos5l_decap_8
XFILLER_40_1012 VPWR VGND sg13cmos5l_decap_8
X_10968__1014 _10968_/RESET_B VPWR VGND sg13cmos5l_tiehi
Xhold2071 _07018_/A _11666_/Q VPWR VGND sg13cmos5l_dlygate4sd3_1
XFILLER_94_78 VPWR VGND sg13cmos5l_fill_2
XFILLER_94_56 VPWR VGND sg13cmos5l_decap_8
Xhold2082 _09145_/A _11453_/Q VPWR VGND sg13cmos5l_dlygate4sd3_1
Xhold2093 _07684_/A _10936_/Q VPWR VGND sg13cmos5l_dlygate4sd3_1
XFILLER_18_725 VPWR VGND sg13cmos5l_decap_8
XFILLER_27_61 VPWR VGND sg13cmos5l_fill_2
XFILLER_33_717 VPWR VGND sg13cmos5l_decap_8
XFILLER_60_536 VPWR VGND sg13cmos5l_fill_1
X_10815_ _10815_/Q clkload37/A _10815_/D _10815_/RESET_B VPWR VGND sg13cmos5l_dfrbpq_1
XFILLER_32_227 VPWR VGND sg13cmos5l_decap_8
X_11257__1644 _11257_/RESET_B VPWR VGND sg13cmos5l_tiehi
X_10746_ _11566_/D _10748_/B _10751_/B _10745_/X VPWR VGND sg13cmos5l_o21ai_1
XFILLER_43_71 VPWR VGND sg13cmos5l_fill_1
XFILLER_41_783 VPWR VGND sg13cmos5l_decap_4
XFILLER_9_423 VPWR VGND sg13cmos5l_fill_2
XFILLER_9_434 VPWR VGND sg13cmos5l_fill_2
X_10677_ _10677_/Y _10670_/Y _10674_/Y _10676_/Y VPWR VGND sg13cmos5l_a21oi_1
XFILLER_9_456 VPWR VGND sg13cmos5l_fill_1
XFILLER_99_249 VPWR VGND sg13cmos5l_fill_1
XFILLER_4_161 VPWR VGND sg13cmos5l_fill_2
XFILLER_4_21 VPWR VGND sg13cmos5l_decap_8
XFILLER_4_65 VPWR VGND sg13cmos5l_decap_8
X_11229_ _11229_/Q _11361_/CLK _11229_/D _11229_/RESET_B VPWR VGND sg13cmos5l_dfrbpq_1
XFILLER_68_625 VPWR VGND sg13cmos5l_fill_1
XFILLER_67_124 VPWR VGND sg13cmos5l_decap_8
XFILLER_96_978 VPWR VGND sg13cmos5l_fill_2
XFILLER_83_606 VPWR VGND sg13cmos5l_fill_1
X_06770_ _06770_/Y _06264_/A _06444_/C _06773_/B1 _06768_/Y VPWR VGND sg13cmos5l_a22oi_1
XFILLER_36_500 VPWR VGND sg13cmos5l_decap_8
XFILLER_36_522 VPWR VGND sg13cmos5l_fill_2
X_08440_ _11305_/D fanout49/X _08439_/B _08439_/Y VPWR VGND sg13cmos5l_a21oi_1
XFILLER_64_897 VPWR VGND sg13cmos5l_fill_2
XFILLER_23_238 VPWR VGND sg13cmos5l_decap_8
X_08371_ _11271_/D fanout54/X _08372_/B _08370_/Y VPWR VGND sg13cmos5l_o21ai_1
XFILLER_90_0 VPWR VGND sg13cmos5l_decap_8
XFILLER_104_1006 VPWR VGND sg13cmos5l_decap_8
X_10839__1164 _10839_/RESET_B VPWR VGND sg13cmos5l_tiehi
X_11425__1440 _11425_/RESET_B VPWR VGND sg13cmos5l_tiehi
X_11389__1509 _11389_/RESET_B VPWR VGND sg13cmos5l_tiehi
X_07322_ _07322_/Y _09480_/A _07340_/A2 _07321_/Y VPWR VGND sg13cmos5l_a21oi_1
X_07253_ _07253_/Y _11521_/Q _08671_/S VPWR VGND sg13cmos5l_nand2_1
X_07184_ _07184_/X _11709_/Q _07190_/C VPWR VGND sg13cmos5l_and2_1
X_11476__1231 _11476_/RESET_B VPWR VGND sg13cmos5l_tiehi
X_06204_ _06597_/A _06603_/B _06204_/B VPWR VGND sg13cmos5l_or2_1
XFILLER_20_978 VPWR VGND sg13cmos5l_decap_8
X_06135_ _06141_/C _11392_/Q _11570_/Q _11571_/Q _11574_/Q VPWR VGND sg13cmos5l_nand4_1
XFILLER_105_516 VPWR VGND sg13cmos5l_decap_8
X_06066_ _06066_/Y _10703_/A _10691_/B _06066_/C VPWR VGND sg13cmos5l_nand3_1
Xfanout402 _10016_/C1 _06459_/Y VPWR VGND sg13cmos5l_buf_1
Xfanout413 _09659_/S1 fanout422/X VPWR VGND sg13cmos5l_buf_1
XFILLER_100_210 VPWR VGND sg13cmos5l_decap_8
Xfanout457 _08588_/B _08573_/S VPWR VGND sg13cmos5l_buf_1
X_09825_ _09825_/Y _09822_/Y _09824_/Y _09994_/A1 VPWR VGND sg13cmos5l_o21ai_1
XFILLER_86_411 VPWR VGND sg13cmos5l_fill_2
Xfanout446 _09981_/B fanout451/X VPWR VGND sg13cmos5l_buf_1
Xfanout435 _06512_/B fanout451/X VPWR VGND sg13cmos5l_buf_1
Xfanout424 _09553_/B1 fanout432/X VPWR VGND sg13cmos5l_buf_1
Xfanout479 _09870_/B _09824_/A2 VPWR VGND sg13cmos5l_buf_1
X_11335__1566 _11335_/RESET_B VPWR VGND sg13cmos5l_tiehi
XFILLER_58_135 VPWR VGND sg13cmos5l_fill_1
XFILLER_47_809 VPWR VGND sg13cmos5l_decap_8
Xfanout468 _09593_/B _09363_/B VPWR VGND sg13cmos5l_buf_1
X_09756_ _09756_/Y _11006_/Q _09823_/B VPWR VGND sg13cmos5l_nand2_1
XFILLER_74_628 VPWR VGND sg13cmos5l_fill_1
XFILLER_74_617 VPWR VGND sg13cmos5l_decap_8
XFILLER_67_680 VPWR VGND sg13cmos5l_decap_8
X_06968_ _06968_/Y _07024_/A _07026_/B _06967_/Y VPWR VGND sg13cmos5l_o21ai_1
XFILLER_104_77 VPWR VGND sg13cmos5l_decap_8
XFILLER_73_138 VPWR VGND sg13cmos5l_fill_2
X_09687_ _09687_/Y _09989_/A _09687_/B _09687_/C VPWR VGND sg13cmos5l_nor3_1
X_08707_ _11407_/D _08707_/A VPWR VGND sg13cmos5l_inv_1
X_05919_ _09378_/A _09205_/A VPWR VGND sg13cmos5l_inv_1
XFILLER_82_672 VPWR VGND sg13cmos5l_fill_1
X_06899_ _11634_/D _11705_/D hold2809/X _08640_/A VPWR VGND sg13cmos5l_mux2_1
X_08638_ _08638_/Y _08642_/S _11696_/D VPWR VGND sg13cmos5l_nor2_1
XFILLER_42_547 VPWR VGND sg13cmos5l_fill_1
X_08569_ _08569_/Y _08569_/A _08569_/B VPWR VGND sg13cmos5l_nor2_1
Xfanout64 fanout64/X _07606_/Y VPWR VGND sg13cmos5l_buf_1
Xfanout53 fanout53/X _07639_/Y VPWR VGND sg13cmos5l_buf_1
X_11580_ _11580_/Q clkload21/A _11580_/D _11580_/RESET_B VPWR VGND sg13cmos5l_dfrbpq_1
X_10600_ _10600_/Y _10613_/A _10599_/Y _10594_/Y VPWR VGND sg13cmos5l_a21oi_1
Xfanout75 fanout75/X _07586_/Y VPWR VGND sg13cmos5l_buf_1
X_10531_ _10536_/C _11413_/Q _10850_/Q VPWR VGND sg13cmos5l_xor2_1
XFILLER_50_591 VPWR VGND sg13cmos5l_decap_8
Xfanout86 _09460_/A _09540_/A VPWR VGND sg13cmos5l_buf_1
XFILLER_13_30 VPWR VGND sg13cmos5l_fill_1
Xfanout97 fanout97/X _07552_/Y VPWR VGND sg13cmos5l_buf_1
XFILLER_6_415 VPWR VGND sg13cmos5l_fill_1
X_10462_ _10464_/A _10462_/A _10462_/B VPWR VGND sg13cmos5l_xnor2_1
X_10393_ _10394_/B hold2901/X _10414_/A2 _07067_/B VPWR VGND sg13cmos5l_a21oi_1
XFILLER_97_709 VPWR VGND sg13cmos5l_decap_4
XFILLER_2_632 VPWR VGND sg13cmos5l_decap_8
XFILLER_2_643 VPWR VGND sg13cmos5l_fill_2
X_11014_ _11014_/Q clkload54/A _11014_/D _11014_/RESET_B VPWR VGND sg13cmos5l_dfrbpq_1
XFILLER_78_978 VPWR VGND sg13cmos5l_fill_1
XFILLER_65_606 VPWR VGND sg13cmos5l_decap_8
XFILLER_92_403 VPWR VGND sg13cmos5l_decap_8
XFILLER_77_499 VPWR VGND sg13cmos5l_fill_1
XFILLER_77_488 VPWR VGND sg13cmos5l_decap_8
XFILLER_18_500 VPWR VGND sg13cmos5l_decap_8
XFILLER_46_842 VPWR VGND sg13cmos5l_fill_1
XFILLER_45_341 VPWR VGND sg13cmos5l_decap_8
XFILLER_61_845 VPWR VGND sg13cmos5l_decap_8
XFILLER_54_81 VPWR VGND sg13cmos5l_fill_1
X_10729_ _10729_/Y _10729_/A _10729_/B VPWR VGND sg13cmos5l_nand2_1
XFILLER_9_286 VPWR VGND sg13cmos5l_decap_8
Xclkload23 clkload23/Y clkload23/A VPWR VGND sg13cmos5l_inv_1
XFILLER_62_4 VPWR VGND sg13cmos5l_fill_2
Xclkload34 clkload34/X clkload34/A VPWR VGND sg13cmos5l_buf_8
Xclkload12 clkload12/Y clkload12/A VPWR VGND sg13cmos5l_inv_1
Xclkload56 clkload56/Y clkload56/A VPWR VGND sg13cmos5l_inv_1
Xclkload45 clkload45/X clkload45/A VPWR VGND sg13cmos5l_buf_8
XFILLER_102_508 VPWR VGND sg13cmos5l_decap_8
X_11018__964 _11018_/RESET_B VPWR VGND sg13cmos5l_tiehi
XFILLER_88_709 VPWR VGND sg13cmos5l_fill_1
X_07940_ _07940_/Y _07940_/A _07940_/B VPWR VGND sg13cmos5l_nand2_1
XFILLER_96_731 VPWR VGND sg13cmos5l_fill_2
Xhold2829 _11512_/D _10138_/Y VPWR VGND sg13cmos5l_dlygate4sd3_1
Xhold2818 _10562_/A _11415_/Q VPWR VGND sg13cmos5l_dlygate4sd3_1
Xhold2807 hold2807/X _11412_/Q VPWR VGND sg13cmos5l_dlygate4sd3_1
X_07871_ _07871_/Y _07871_/A _07881_/B VPWR VGND sg13cmos5l_nor2_1
X_06822_ _06822_/Y _06818_/Y _06820_/Y _06821_/Y VPWR VGND sg13cmos5l_o21ai_1
XFILLER_56_639 VPWR VGND sg13cmos5l_decap_4
X_09610_ _09610_/X _09610_/A _09610_/B VPWR VGND sg13cmos5l_or2_1
X_06753_ _06753_/Y _10268_/A _10433_/A _06679_/A VPWR VGND sg13cmos5l_a21oi_1
X_09541_ _09541_/Y _09431_/A _09540_/A _09515_/Y _09540_/Y VPWR VGND sg13cmos5l_a22oi_1
XFILLER_70_108 VPWR VGND sg13cmos5l_decap_8
X_09472_ _09472_/X _11251_/Q _11219_/Q _11187_/Q _11155_/Q _09551_/S0 _09551_/S1 VPWR
+ VGND sg13cmos5l_mux4_1
X_06684_ _10808_/D _06744_/A1 _06681_/Y _06683_/Y VPWR VGND sg13cmos5l_o21ai_1
XFILLER_24_514 VPWR VGND sg13cmos5l_fill_2
XFILLER_52_856 VPWR VGND sg13cmos5l_decap_8
X_08423_ _08423_/Y _08423_/A _08423_/B VPWR VGND sg13cmos5l_nor2_1
XFILLER_24_569 VPWR VGND sg13cmos5l_fill_1
X_08354_ _08354_/Y _08354_/A _08372_/B VPWR VGND sg13cmos5l_nand2_1
XFILLER_51_388 VPWR VGND sg13cmos5l_fill_2
X_07305_ _07305_/Y _07305_/A _07407_/B VPWR VGND sg13cmos5l_nor2_1
Xclkload6 clkload6/X clkload6/A VPWR VGND sg13cmos5l_buf_8
X_08285_ _08285_/Y _08285_/A _08285_/B VPWR VGND sg13cmos5l_nor2_1
X_07236_ _10852_/D _07244_/A _07236_/B VPWR VGND sg13cmos5l_nand2_1
X_07167_ _07167_/Y _09063_/A1 _08645_/A1 _07185_/A _07210_/B _07225_/C1 VPWR VGND
+ sg13cmos5l_a221oi_1
XFILLER_106_847 VPWR VGND sg13cmos5l_decap_8
XFILLER_105_335 VPWR VGND sg13cmos5l_decap_8
X_06118_ _11764_/D _06118_/A _06118_/B VPWR VGND sg13cmos5l_nand2_1
XFILLER_78_208 VPWR VGND sg13cmos5l_decap_8
X_07098_ _07098_/Y _07098_/A _07098_/B VPWR VGND sg13cmos5l_nor2_1
XFILLER_59_37 VPWR VGND sg13cmos5l_fill_1
Xfanout232 _07911_/B _07917_/B VPWR VGND sg13cmos5l_buf_1
X_06049_ _06082_/B _10698_/A _06066_/C VPWR VGND sg13cmos5l_nor2_1
Xfanout210 _08145_/B _08153_/B VPWR VGND sg13cmos5l_buf_1
XFILLER_8_1012 VPWR VGND sg13cmos5l_decap_8
Xfanout221 _08013_/B _07984_/Y VPWR VGND sg13cmos5l_buf_1
Xfanout243 _07770_/B _07778_/B VPWR VGND sg13cmos5l_buf_1
Xfanout254 _07712_/B fanout256/X VPWR VGND sg13cmos5l_buf_1
Xfanout265 _07566_/B _07537_/B VPWR VGND sg13cmos5l_buf_1
XFILLER_101_574 VPWR VGND sg13cmos5l_decap_8
Xfanout287 _08374_/B _08311_/Y VPWR VGND sg13cmos5l_buf_1
XFILLER_87_797 VPWR VGND sg13cmos5l_fill_2
XFILLER_86_263 VPWR VGND sg13cmos5l_fill_1
XFILLER_75_948 VPWR VGND sg13cmos5l_fill_1
X_09808_ _11477_/D _10307_/A _09807_/A _09784_/Y _09807_/Y VPWR VGND sg13cmos5l_a22oi_1
Xfanout276 _08328_/B _08338_/B VPWR VGND sg13cmos5l_buf_1
Xfanout298 _07808_/B _07814_/B VPWR VGND sg13cmos5l_buf_1
XFILLER_75_69 VPWR VGND sg13cmos5l_fill_2
X_09739_ _09739_/X _11261_/Q _11229_/Q _11197_/Q _11165_/Q _09840_/S _09848_/B1 VPWR
+ VGND sg13cmos5l_mux4_1
XFILLER_55_661 VPWR VGND sg13cmos5l_fill_2
XFILLER_61_119 VPWR VGND sg13cmos5l_decap_8
XFILLER_42_300 VPWR VGND sg13cmos5l_fill_1
XFILLER_27_385 VPWR VGND sg13cmos5l_decap_8
XFILLER_28_897 VPWR VGND sg13cmos5l_decap_4
XFILLER_91_35 VPWR VGND sg13cmos5l_decap_8
XFILLER_70_653 VPWR VGND sg13cmos5l_fill_1
X_11701_ _11701_/Q clkload31/A _11701_/D _11701_/RESET_B VPWR VGND sg13cmos5l_dfrbpq_1
XFILLER_54_193 VPWR VGND sg13cmos5l_fill_2
XFILLER_54_182 VPWR VGND sg13cmos5l_decap_8
X_11632_ _11632_/Q clkload31/A _11632_/D _11632_/RESET_B VPWR VGND sg13cmos5l_dfrbpq_1
XFILLER_11_742 VPWR VGND sg13cmos5l_decap_4
XFILLER_24_62 VPWR VGND sg13cmos5l_decap_4
X_11563_ _11563_/Q clkload29/A _11563_/D _11563_/RESET_B VPWR VGND sg13cmos5l_dfrbpq_1
XFILLER_7_724 VPWR VGND sg13cmos5l_fill_2
X_10514_ _10515_/B _11410_/Q _09231_/B _10499_/Y VPWR VGND sg13cmos5l_a21oi_1
X_11494_ _11494_/Q _11671_/CLK _11494_/D _11494_/RESET_B VPWR VGND sg13cmos5l_dfrbpq_1
X_10445_ _10445_/Y _10445_/A _10445_/B VPWR VGND sg13cmos5l_nand2_1
XFILLER_6_278 VPWR VGND sg13cmos5l_fill_2
XFILLER_6_245 VPWR VGND sg13cmos5l_fill_1
XFILLER_10_296 VPWR VGND sg13cmos5l_fill_1
X_11703__1261 _11703_/RESET_B VPWR VGND sg13cmos5l_tiehi
X_10376_ _11530_/D _10488_/A _10376_/B _10376_/C VPWR VGND sg13cmos5l_and3_1
XFILLER_2_495 VPWR VGND sg13cmos5l_decap_8
XFILLER_66_937 VPWR VGND sg13cmos5l_decap_4
XFILLER_65_403 VPWR VGND sg13cmos5l_decap_8
XFILLER_38_617 VPWR VGND sg13cmos5l_decap_4
XFILLER_37_127 VPWR VGND sg13cmos5l_fill_2
XFILLER_18_330 VPWR VGND sg13cmos5l_decap_4
X_11493__1197 _11493_/RESET_B VPWR VGND sg13cmos5l_tiehi
XFILLER_65_91 VPWR VGND sg13cmos5l_decap_8
XFILLER_46_683 VPWR VGND sg13cmos5l_decap_8
XFILLER_33_344 VPWR VGND sg13cmos5l_decap_8
XFILLER_34_889 VPWR VGND sg13cmos5l_fill_1
X_11585__1447 _11585_/RESET_B VPWR VGND sg13cmos5l_tiehi
XFILLER_14_1028 VPWR VGND sg13cmos5l_fill_1
XFILLER_101_1009 VPWR VGND sg13cmos5l_decap_8
X_08070_ _08070_/Y _08070_/A _08074_/B VPWR VGND sg13cmos5l_nand2_1
X_07021_ _07021_/Y _11506_/Q _07024_/B _07020_/Y VPWR VGND sg13cmos5l_a21oi_1
X_11762__923 _11762_/RESET_B VPWR VGND sg13cmos5l_tiehi
Xhold2604 hold2604/X _08624_/Y VPWR VGND sg13cmos5l_dlygate4sd3_1
X_08972_ _08972_/Y _08967_/Y _08970_/Y _09061_/A VPWR VGND sg13cmos5l_a21oi_1
X_07923_ _11051_/D _08053_/A1 _07978_/B _07922_/Y VPWR VGND sg13cmos5l_o21ai_1
Xhold2626 _06809_/A _11603_/Q VPWR VGND sg13cmos5l_dlygate4sd3_1
Xhold2615 _11574_/D _10757_/X VPWR VGND sg13cmos5l_dlygate4sd3_1
Xhold2637 _11752_/D _06090_/Y VPWR VGND sg13cmos5l_dlygate4sd3_1
Xhold1936 _08240_/A _11207_/Q VPWR VGND sg13cmos5l_dlygate4sd3_1
Xhold2648 _06072_/B _11569_/Q VPWR VGND sg13cmos5l_dlygate4sd3_1
X_07854_ _07854_/Y _08376_/C _07984_/B VPWR VGND sg13cmos5l_nor2_1
Xhold1925 _08238_/A _11206_/Q VPWR VGND sg13cmos5l_dlygate4sd3_1
XFILLER_69_786 VPWR VGND sg13cmos5l_decap_4
XFILLER_68_263 VPWR VGND sg13cmos5l_fill_2
Xhold2659 _07238_/B _07237_/Y VPWR VGND sg13cmos5l_dlygate4sd3_1
Xhold1903 _07816_/A _11000_/Q VPWR VGND sg13cmos5l_dlygate4sd3_1
Xhold1914 _07948_/A _11064_/Q VPWR VGND sg13cmos5l_dlygate4sd3_1
X_06805_ _06805_/Y _06790_/Y _06840_/A _06803_/Y VPWR VGND sg13cmos5l_o21ai_1
Xhold1969 _07836_/A _11010_/Q VPWR VGND sg13cmos5l_dlygate4sd3_1
XFILLER_84_734 VPWR VGND sg13cmos5l_fill_2
Xhold1947 _08882_/A _11434_/Q VPWR VGND sg13cmos5l_dlygate4sd3_1
Xhold1958 _07928_/A _11054_/Q VPWR VGND sg13cmos5l_dlygate4sd3_1
X_07785_ _10985_/D fanout49/X _07784_/B _07784_/Y VPWR VGND sg13cmos5l_a21oi_1
XFILLER_72_929 VPWR VGND sg13cmos5l_decap_4
XFILLER_28_149 VPWR VGND sg13cmos5l_fill_1
XFILLER_83_288 VPWR VGND sg13cmos5l_decap_4
XFILLER_71_428 VPWR VGND sg13cmos5l_fill_1
X_06736_ _06736_/Y _06727_/A _06727_/B _06732_/A VPWR VGND sg13cmos5l_a21oi_1
X_09524_ _09524_/Y _11029_/Q _09593_/B _09842_/B1 VPWR VGND sg13cmos5l_a21oi_1
X_06667_ _06667_/Y _06664_/A _06732_/B _06666_/Y VPWR VGND sg13cmos5l_a21oi_1
X_09455_ _09455_/Y _09376_/Y _09455_/B _09506_/A VPWR VGND sg13cmos5l_nand3b_1
XFILLER_101_56 VPWR VGND sg13cmos5l_decap_8
XFILLER_12_517 VPWR VGND sg13cmos5l_fill_1
X_08406_ _11288_/D _08471_/A1 _08405_/B _08405_/Y VPWR VGND sg13cmos5l_a21oi_1
XFILLER_61_27 VPWR VGND sg13cmos5l_decap_8
X_06598_ _06599_/B _06603_/B _06628_/B VPWR VGND sg13cmos5l_nor2_1
X_09386_ _09386_/Y _09175_/X _09195_/Y _09385_/Y VPWR VGND sg13cmos5l_o21ai_1
X_08337_ _11254_/D _08337_/A1 _08338_/B _08336_/Y VPWR VGND sg13cmos5l_o21ai_1
X_08268_ _11220_/D _08333_/A1 _08267_/B _08267_/Y VPWR VGND sg13cmos5l_a21oi_1
X_07219_ _07219_/Y _07225_/A1 _11630_/Q _07227_/B1 hold2687/X _07225_/C1 VPWR VGND
+ sg13cmos5l_a221oi_1
X_10230_ _10232_/C _11399_/Q _10836_/Q VPWR VGND sg13cmos5l_xor2_1
XFILLER_4_738 VPWR VGND sg13cmos5l_decap_4
XFILLER_3_226 VPWR VGND sg13cmos5l_fill_1
XFILLER_3_215 VPWR VGND sg13cmos5l_decap_4
X_08199_ _11186_/D _08329_/A1 _08202_/B _08198_/Y VPWR VGND sg13cmos5l_o21ai_1
XFILLER_106_644 VPWR VGND sg13cmos5l_decap_8
XFILLER_105_154 VPWR VGND sg13cmos5l_decap_8
X_10161_ _10162_/B _10703_/A _10161_/B _10161_/C VPWR VGND sg13cmos5l_nor3_1
XFILLER_10_75 VPWR VGND sg13cmos5l_fill_1
XFILLER_0_922 VPWR VGND sg13cmos5l_decap_8
XFILLER_86_46 VPWR VGND sg13cmos5l_fill_2
XFILLER_86_35 VPWR VGND sg13cmos5l_decap_8
X_10092_ _10092_/Y _10330_/B _05965_/A _10092_/B1 VPWR VGND sg13cmos5l_o21ai_1
XFILLER_75_701 VPWR VGND sg13cmos5l_fill_2
XFILLER_0_999 VPWR VGND sg13cmos5l_decap_8
XFILLER_19_138 VPWR VGND sg13cmos5l_fill_2
X_11384__1514 _11384_/RESET_B VPWR VGND sg13cmos5l_tiehi
XFILLER_43_620 VPWR VGND sg13cmos5l_decap_8
X_10994_ _10994_/Q clkload17/A _10994_/D _10994_/RESET_B VPWR VGND sg13cmos5l_dfrbpq_1
XFILLER_43_642 VPWR VGND sg13cmos5l_fill_1
X_11008__974 _11008_/RESET_B VPWR VGND sg13cmos5l_tiehi
XFILLER_37_1028 VPWR VGND sg13cmos5l_fill_1
XFILLER_16_889 VPWR VGND sg13cmos5l_fill_1
X_11115__1786 _11115_/RESET_B VPWR VGND sg13cmos5l_tiehi
X_11615_ _11615_/Q clkload27/A _11615_/D _11615_/RESET_B VPWR VGND sg13cmos5l_dfrbpq_1
X_11546_ _11546_/Q clkload47/A _11546_/D _11546_/RESET_B VPWR VGND sg13cmos5l_dfrbpq_1
XFILLER_100_1020 VPWR VGND sg13cmos5l_decap_8
X_11294__1607 _11294_/RESET_B VPWR VGND sg13cmos5l_tiehi
X_11477_ _11477_/Q clkload48/A _11477_/D _11477_/RESET_B VPWR VGND sg13cmos5l_dfrbpq_1
XFILLER_7_598 VPWR VGND sg13cmos5l_decap_4
XFILLER_7_587 VPWR VGND sg13cmos5l_fill_2
X_11330__1571 _11330_/RESET_B VPWR VGND sg13cmos5l_tiehi
XFILLER_83_1015 VPWR VGND sg13cmos5l_decap_8
X_10428_ _10429_/A _10525_/A _10427_/Y _10408_/A VPWR VGND sg13cmos5l_o21ai_1
XFILLER_98_826 VPWR VGND sg13cmos5l_decap_8
X_10359_ _10360_/B _10357_/Y _10358_/Y _10443_/B1 VPWR VGND sg13cmos5l_o21ai_1
X_11015__967 _11015_/RESET_B VPWR VGND sg13cmos5l_tiehi
XFILLER_97_369 VPWR VGND sg13cmos5l_fill_2
XFILLER_39_915 VPWR VGND sg13cmos5l_decap_4
XFILLER_25_4 VPWR VGND sg13cmos5l_decap_4
XFILLER_65_233 VPWR VGND sg13cmos5l_fill_2
XFILLER_26_609 VPWR VGND sg13cmos5l_fill_1
X_10811__948 _10811_/RESET_B VPWR VGND sg13cmos5l_tiehi
X_07570_ _07570_/Y _10513_/A _07575_/C _07569_/Y VPWR VGND sg13cmos5l_a21oi_1
XFILLER_19_672 VPWR VGND sg13cmos5l_fill_1
XFILLER_62_940 VPWR VGND sg13cmos5l_decap_4
X_06521_ _06521_/Y _06515_/Y _06516_/Y _06520_/Y _09579_/B2 VPWR VGND sg13cmos5l_a22oi_1
XFILLER_34_620 VPWR VGND sg13cmos5l_decap_4
XFILLER_34_631 VPWR VGND sg13cmos5l_decap_8
XFILLER_90_1019 VPWR VGND sg13cmos5l_fill_1
X_09240_ _09240_/Y _09229_/Y _09729_/B _09239_/X VPWR VGND sg13cmos5l_o21ai_1
X_06452_ _06452_/Y _06451_/A _06452_/B VPWR VGND sg13cmos5l_nand2b_1
X_09171_ _09171_/Y _09837_/A _09171_/B _09754_/A _09171_/D VPWR VGND sg13cmos5l_nor4_1
X_06383_ _06383_/Y _10581_/A _10282_/A VPWR VGND sg13cmos5l_nand2_1
X_08122_ _11148_/D _08317_/A1 _08163_/B _08121_/Y VPWR VGND sg13cmos5l_a21oi_1
X_08053_ _11115_/D _08053_/A1 _08102_/B _08052_/Y VPWR VGND sg13cmos5l_o21ai_1
X_11549__1475 _11549_/RESET_B VPWR VGND sg13cmos5l_tiehi
X_10904__1078 _10904_/RESET_B VPWR VGND sg13cmos5l_tiehi
X_07004_ _07004_/Y _07002_/Y _07003_/Y _07059_/B1 VPWR VGND sg13cmos5l_a21oi_1
Xhold2412 _08175_/A _11175_/Q VPWR VGND sg13cmos5l_dlygate4sd3_1
X_08955_ _08955_/Y _08955_/A _08973_/B VPWR VGND sg13cmos5l_nor2_1
Xhold2401 _10861_/D _07264_/Y VPWR VGND sg13cmos5l_dlygate4sd3_1
XFILLER_102_168 VPWR VGND sg13cmos5l_decap_8
X_07906_ _11043_/D fanout62/X _07911_/B _07905_/Y VPWR VGND sg13cmos5l_a21oi_1
Xhold2434 hold2434/X _11628_/Q VPWR VGND sg13cmos5l_dlygate4sd3_1
XFILLER_76_509 VPWR VGND sg13cmos5l_fill_2
Xhold2423 _08397_/A _11284_/Q VPWR VGND sg13cmos5l_dlygate4sd3_1
Xhold2445 hold2445/X _07317_/Y VPWR VGND sg13cmos5l_dlygate4sd3_1
Xhold2467 _06855_/A _11618_/Q VPWR VGND sg13cmos5l_dlygate4sd3_1
Xhold2489 _11608_/D _06824_/Y VPWR VGND sg13cmos5l_dlygate4sd3_1
Xhold2456 _11610_/D _06829_/Y VPWR VGND sg13cmos5l_dlygate4sd3_1
X_08886_ _08888_/C _08886_/A _08910_/B VPWR VGND sg13cmos5l_nor2b_1
XFILLER_5_1015 VPWR VGND sg13cmos5l_decap_8
Xhold2478 _11663_/D _07005_/X VPWR VGND sg13cmos5l_dlygate4sd3_1
XFILLER_29_414 VPWR VGND sg13cmos5l_decap_8
X_07837_ _11010_/D fanout64/X _07836_/B _07836_/Y VPWR VGND sg13cmos5l_o21ai_1
XFILLER_72_704 VPWR VGND sg13cmos5l_decap_8
XFILLER_17_609 VPWR VGND sg13cmos5l_decap_8
XFILLER_72_715 VPWR VGND sg13cmos5l_fill_2
XFILLER_71_214 VPWR VGND sg13cmos5l_decap_8
XFILLER_38_992 VPWR VGND sg13cmos5l_fill_1
X_07768_ _07768_/Y _07768_/A _07768_/B VPWR VGND sg13cmos5l_nor2_1
XFILLER_71_225 VPWR VGND sg13cmos5l_fill_2
XFILLER_37_491 VPWR VGND sg13cmos5l_fill_2
XFILLER_25_642 VPWR VGND sg13cmos5l_decap_8
X_06719_ _06719_/Y _06739_/A _06719_/B VPWR VGND sg13cmos5l_nor2_1
X_09507_ _09508_/B _09507_/A _09536_/B VPWR VGND sg13cmos5l_nor2_1
X_07699_ _10943_/D fanout75/X _07704_/B _07698_/Y VPWR VGND sg13cmos5l_a21oi_1
XFILLER_80_770 VPWR VGND sg13cmos5l_fill_2
X_11372__1529 _11372_/RESET_B VPWR VGND sg13cmos5l_tiehi
XFILLER_24_141 VPWR VGND sg13cmos5l_fill_2
XFILLER_13_859 VPWR VGND sg13cmos5l_decap_8
XFILLER_24_196 VPWR VGND sg13cmos5l_decap_4
X_09438_ _09438_/Y _09199_/A _09206_/A _09345_/A VPWR VGND sg13cmos5l_a21oi_1
X_09369_ _09369_/X _11247_/Q _11215_/Q _11183_/Q _11151_/Q _09363_/B _09688_/S1 VPWR
+ VGND sg13cmos5l_mux4_1
X_11400_ _11400_/Q _11528_/CLK _11400_/D _11400_/RESET_B VPWR VGND sg13cmos5l_dfrbpq_1
X_11331_ _11331_/Q clkload46/A _11331_/D _11331_/RESET_B VPWR VGND sg13cmos5l_dfrbpq_1
XFILLER_106_441 VPWR VGND sg13cmos5l_decap_8
X_11262_ _11262_/Q clkload52/A _11262_/D _11262_/RESET_B VPWR VGND sg13cmos5l_dfrbpq_1
XFILLER_97_56 VPWR VGND sg13cmos5l_decap_8
X_10213_ _10213_/Y _10222_/A _10212_/C _10212_/A VPWR VGND sg13cmos5l_o21ai_1
X_11193_ _11193_/Q _11265_/CLK _11193_/D _11193_/RESET_B VPWR VGND sg13cmos5l_dfrbpq_1
XFILLER_79_336 VPWR VGND sg13cmos5l_decap_8
X_10144_ _10144_/Y _10157_/A1 _09967_/B _10143_/Y VPWR VGND sg13cmos5l_a21oi_1
XFILLER_0_730 VPWR VGND sg13cmos5l_decap_8
XFILLER_88_881 VPWR VGND sg13cmos5l_fill_1
XFILLER_47_211 VPWR VGND sg13cmos5l_decap_4
X_10075_ _10075_/Y _10070_/A _10835_/Q _10074_/Y VPWR VGND sg13cmos5l_o21ai_1
XFILLER_63_704 VPWR VGND sg13cmos5l_fill_1
XFILLER_48_756 VPWR VGND sg13cmos5l_decap_4
XFILLER_63_737 VPWR VGND sg13cmos5l_fill_1
XFILLER_36_929 VPWR VGND sg13cmos5l_decap_8
XFILLER_29_992 VPWR VGND sg13cmos5l_decap_4
XFILLER_90_545 VPWR VGND sg13cmos5l_fill_1
X_10977_ _10977_/Q clkload42/A _10977_/D _10977_/RESET_B VPWR VGND sg13cmos5l_dfrbpq_1
XFILLER_31_601 VPWR VGND sg13cmos5l_fill_1
XFILLER_94_7 VPWR VGND sg13cmos5l_decap_8
XFILLER_43_483 VPWR VGND sg13cmos5l_decap_8
XFILLER_15_174 VPWR VGND sg13cmos5l_fill_1
X_11348__1553 _11348_/RESET_B VPWR VGND sg13cmos5l_tiehi
XFILLER_31_623 VPWR VGND sg13cmos5l_fill_1
XFILLER_31_678 VPWR VGND sg13cmos5l_decap_8
XFILLER_50_1014 VPWR VGND sg13cmos5l_decap_8
XFILLER_50_1003 VPWR VGND sg13cmos5l_fill_2
XFILLER_7_21 VPWR VGND sg13cmos5l_decap_8
XFILLER_30_188 VPWR VGND sg13cmos5l_fill_1
XFILLER_7_87 VPWR VGND sg13cmos5l_decap_8
X_11529_ _11529_/Q clkload20/A _11529_/D _11529_/RESET_B VPWR VGND sg13cmos5l_dfrbpq_1
Xfanout809 _08774_/B _08921_/A VPWR VGND sg13cmos5l_buf_1
XFILLER_30_2 VPWR VGND sg13cmos5l_fill_1
XFILLER_98_678 VPWR VGND sg13cmos5l_fill_2
X_11578__1371 _11578_/RESET_B VPWR VGND sg13cmos5l_tiehi
X_05952_ _05952_/Y _10830_/Q VPWR VGND sg13cmos5l_inv_1
X_08740_ _11415_/D _08740_/A VPWR VGND sg13cmos5l_inv_1
X_05883_ _05883_/Y input15/X VPWR VGND sg13cmos5l_inv_1
X_08671_ _08841_/A _08834_/A _07484_/X _08671_/S VPWR VGND sg13cmos5l_mux2_1
X_07622_ _08754_/B _11546_/Q _10821_/Q _07642_/S VPWR VGND sg13cmos5l_mux2_1
XFILLER_53_214 VPWR VGND sg13cmos5l_decap_8
XFILLER_81_556 VPWR VGND sg13cmos5l_fill_2
X_07553_ _10906_/D _07595_/B fanout97/X _07547_/Y VPWR VGND sg13cmos5l_a21oi_1
X_06504_ _06505_/B _06504_/A VPWR VGND sg13cmos5l_inv_1
X_07484_ _07484_/X _11526_/Q _10801_/Q _07497_/A VPWR VGND sg13cmos5l_mux2_1
X_06435_ _06435_/Y _06436_/A _06758_/B1 _06758_/A2 VPWR VGND sg13cmos5l_a21oi_1
XFILLER_50_987 VPWR VGND sg13cmos5l_decap_8
X_11662__1302 _11662_/RESET_B VPWR VGND sg13cmos5l_tiehi
X_09223_ _09223_/Y _09542_/B _09225_/A _09223_/C VPWR VGND sg13cmos5l_nor3_1
X_09154_ _09154_/Y _09154_/A1 _09150_/B _09154_/B1 VPWR VGND sg13cmos5l_o21ai_1
XFILLER_50_998 VPWR VGND sg13cmos5l_fill_1
X_08105_ _11141_/D fanout57/X _08104_/B _08104_/Y VPWR VGND sg13cmos5l_o21ai_1
X_06366_ _06366_/Y _06664_/A _06673_/A _06366_/C VPWR VGND sg13cmos5l_nand3_1
X_09085_ _09097_/B _09109_/A _09102_/A VPWR VGND sg13cmos5l_xnor2_1
X_06297_ _06297_/Y _06657_/A _06297_/B VPWR VGND sg13cmos5l_nor2_1
X_08036_ _11107_/D fanout62/X _08047_/B _08035_/Y VPWR VGND sg13cmos5l_a21oi_1
XFILLER_104_901 VPWR VGND sg13cmos5l_decap_8
X_11695__1269 _11695_/RESET_B VPWR VGND sg13cmos5l_tiehi
XFILLER_103_411 VPWR VGND sg13cmos5l_decap_8
XFILLER_104_978 VPWR VGND sg13cmos5l_decap_8
X_09987_ _09987_/Y _11046_/Q _09984_/B _09987_/B1 VPWR VGND sg13cmos5l_a21oi_1
Xhold2220 _08531_/A _11350_/Q VPWR VGND sg13cmos5l_dlygate4sd3_1
X_08938_ _08960_/A _11630_/Q _08943_/B VPWR VGND sg13cmos5l_xnor2_1
Xhold2264 _07881_/A _11031_/Q VPWR VGND sg13cmos5l_dlygate4sd3_1
Xhold2253 _08423_/A _11297_/Q VPWR VGND sg13cmos5l_dlygate4sd3_1
Xhold2242 _08163_/A _11169_/Q VPWR VGND sg13cmos5l_dlygate4sd3_1
Xhold2231 _07885_/A _11033_/Q VPWR VGND sg13cmos5l_dlygate4sd3_1
X_11505__1173 _11505_/RESET_B VPWR VGND sg13cmos5l_tiehi
XFILLER_85_862 VPWR VGND sg13cmos5l_fill_1
X_08869_ _08869_/Y _08880_/A1 _08876_/A _06078_/A VPWR VGND sg13cmos5l_o21ai_1
Xhold2275 _10867_/D _07300_/Y VPWR VGND sg13cmos5l_dlygate4sd3_1
Xhold2297 _08275_/A _11224_/Q VPWR VGND sg13cmos5l_dlygate4sd3_1
Xhold2286 _08001_/A _11090_/Q VPWR VGND sg13cmos5l_dlygate4sd3_1
XFILLER_18_918 VPWR VGND sg13cmos5l_fill_2
XFILLER_29_244 VPWR VGND sg13cmos5l_fill_2
XFILLER_85_884 VPWR VGND sg13cmos5l_decap_8
XFILLER_84_361 VPWR VGND sg13cmos5l_fill_2
XFILLER_83_14 VPWR VGND sg13cmos5l_decap_4
X_11459__1354 _11459_/RESET_B VPWR VGND sg13cmos5l_tiehi
X_10900_ _10900_/Q clkload16/A _10900_/D _10900_/RESET_B VPWR VGND sg13cmos5l_dfrbpq_1
XFILLER_18_929 VPWR VGND sg13cmos5l_fill_1
XFILLER_83_69 VPWR VGND sg13cmos5l_fill_1
XFILLER_45_759 VPWR VGND sg13cmos5l_decap_8
XFILLER_72_578 VPWR VGND sg13cmos5l_decap_8
X_10831_ _10831_/Q clkload28/A _10831_/D _10831_/RESET_B VPWR VGND sg13cmos5l_dfrbpq_1
XFILLER_60_718 VPWR VGND sg13cmos5l_fill_1
XFILLER_26_973 VPWR VGND sg13cmos5l_fill_2
X_10762_ _11578_/D _06820_/B hold2563/X _10762_/S VPWR VGND sg13cmos5l_mux2_1
X_11587__1439 _11587_/RESET_B VPWR VGND sg13cmos5l_tiehi
XFILLER_73_1014 VPWR VGND sg13cmos5l_decap_8
XFILLER_12_111 VPWR VGND sg13cmos5l_fill_1
XFILLER_40_431 VPWR VGND sg13cmos5l_fill_2
X_10693_ _10695_/C _10707_/A _10709_/A _10693_/C VPWR VGND sg13cmos5l_nor3_1
X_11005__977 _11005_/RESET_B VPWR VGND sg13cmos5l_tiehi
XFILLER_12_188 VPWR VGND sg13cmos5l_fill_2
XFILLER_5_811 VPWR VGND sg13cmos5l_decap_8
X_11314_ _11314_/Q _11671_/CLK _11314_/D _11314_/RESET_B VPWR VGND sg13cmos5l_dfrbpq_1
X_11245_ _11245_/Q clkload10/A _11245_/D _11245_/RESET_B VPWR VGND sg13cmos5l_dfrbpq_1
X_11176_ _11176_/Q clkload51/A _11176_/D _11176_/RESET_B VPWR VGND sg13cmos5l_dfrbpq_1
XFILLER_68_829 VPWR VGND sg13cmos5l_fill_2
XFILLER_68_818 VPWR VGND sg13cmos5l_decap_8
XFILLER_67_306 VPWR VGND sg13cmos5l_fill_1
XFILLER_95_648 VPWR VGND sg13cmos5l_decap_8
X_10127_ _10127_/Y _10644_/B1 _09827_/Y _10123_/A VPWR VGND sg13cmos5l_o21ai_1
X_10058_ _10058_/Y _11753_/Q _10713_/A _10783_/B VPWR VGND sg13cmos5l_o21ai_1
XFILLER_76_884 VPWR VGND sg13cmos5l_fill_1
XFILLER_36_715 VPWR VGND sg13cmos5l_fill_1
XFILLER_35_236 VPWR VGND sg13cmos5l_decap_8
XFILLER_63_578 VPWR VGND sg13cmos5l_decap_8
XFILLER_51_707 VPWR VGND sg13cmos5l_decap_8
XFILLER_50_206 VPWR VGND sg13cmos5l_decap_4
XFILLER_17_951 VPWR VGND sg13cmos5l_decap_8
XFILLER_50_217 VPWR VGND sg13cmos5l_decap_8
X_06220_ _10252_/B _10267_/A _10242_/B VPWR VGND sg13cmos5l_and2_1
XFILLER_31_486 VPWR VGND sg13cmos5l_decap_4
XFILLER_89_1021 VPWR VGND sg13cmos5l_decap_8
X_06151_ _06685_/A _06682_/A _06687_/A VPWR VGND sg13cmos5l_and2_1
X_06082_ _06083_/A _09303_/D _06082_/B VPWR VGND sg13cmos5l_nand2_1
X_09910_ _09910_/Y _09910_/A _09910_/B VPWR VGND sg13cmos5l_nand2_1
Xfanout606 _09064_/B1 _08739_/B2 VPWR VGND sg13cmos5l_buf_1
XFILLER_99_998 VPWR VGND sg13cmos5l_decap_8
Xfanout628 _09061_/A _09153_/A1 VPWR VGND sg13cmos5l_buf_1
Xfanout617 _10032_/A _06008_/Y VPWR VGND sg13cmos5l_buf_1
X_09841_ _09841_/Y _10945_/Q _09841_/B VPWR VGND sg13cmos5l_nand2_1
Xfanout639 _06531_/A _06133_/B VPWR VGND sg13cmos5l_buf_1
X_09772_ _09773_/B _09902_/A _09767_/X _09771_/Y VPWR VGND sg13cmos5l_o21ai_1
X_10817__954 _10817_/RESET_B VPWR VGND sg13cmos5l_tiehi
X_06984_ _06984_/Y _06982_/Y _06983_/Y _07050_/B1 VPWR VGND sg13cmos5l_a21oi_1
X_05935_ _05935_/Y _05935_/A VPWR VGND sg13cmos5l_inv_1
X_08723_ _08997_/B _08992_/B VPWR VGND sg13cmos5l_inv_1
XFILLER_67_884 VPWR VGND sg13cmos5l_fill_2
XFILLER_2_1018 VPWR VGND sg13cmos5l_decap_8
X_11110__1791 _11110_/RESET_B VPWR VGND sg13cmos5l_tiehi
X_08654_ _11393_/D _07786_/A _08653_/Y _08650_/Y VPWR VGND sg13cmos5l_o21ai_1
X_05866_ _07584_/A _11413_/Q VPWR VGND sg13cmos5l_inv_1
XFILLER_39_597 VPWR VGND sg13cmos5l_decap_8
XFILLER_27_759 VPWR VGND sg13cmos5l_decap_4
X_08585_ _08585_/Y _08584_/Y _10161_/B VPWR VGND sg13cmos5l_nand2b_1
X_07605_ _07605_/Y _07617_/C _07604_/X _07650_/A VPWR VGND sg13cmos5l_o21ai_1
XFILLER_26_269 VPWR VGND sg13cmos5l_decap_8
XFILLER_53_28 VPWR VGND sg13cmos5l_fill_2
XFILLER_41_228 VPWR VGND sg13cmos5l_decap_4
X_07536_ _07536_/Y _07530_/A _08699_/B _07543_/B _07535_/Y VPWR VGND sg13cmos5l_a22oi_1
XFILLER_22_420 VPWR VGND sg13cmos5l_decap_8
XFILLER_22_442 VPWR VGND sg13cmos5l_decap_8
X_07467_ _07467_/Y _07515_/A _07463_/X _07466_/Y VPWR VGND sg13cmos5l_o21ai_1
XFILLER_23_998 VPWR VGND sg13cmos5l_decap_4
X_09206_ _09206_/X _09206_/A _09208_/A _09206_/C VPWR VGND sg13cmos5l_or3_1
X_06418_ _10822_/D _06421_/B _06415_/Y _06417_/Y VPWR VGND sg13cmos5l_o21ai_1
X_07398_ _08751_/A _09084_/A _07416_/B VPWR VGND sg13cmos5l_nand2_1
X_09137_ _09137_/Y _09137_/A _09137_/B VPWR VGND sg13cmos5l_nor2_1
X_06349_ _06618_/C _06610_/B _06610_/C _06201_/B VPWR VGND sg13cmos5l_a21oi_1
X_09068_ _09103_/A _09068_/A _09068_/B _09077_/B _09068_/D VPWR VGND sg13cmos5l_nand4_1
X_08019_ _08019_/Y _08019_/A _08041_/B VPWR VGND sg13cmos5l_nor2_1
XFILLER_89_431 VPWR VGND sg13cmos5l_decap_8
XFILLER_78_58 VPWR VGND sg13cmos5l_decap_4
XFILLER_78_47 VPWR VGND sg13cmos5l_fill_1
XFILLER_2_836 VPWR VGND sg13cmos5l_decap_4
XFILLER_104_764 VPWR VGND sg13cmos5l_fill_1
XFILLER_103_252 VPWR VGND sg13cmos5l_decap_8
XFILLER_89_464 VPWR VGND sg13cmos5l_decap_8
X_11030_ _11030_/Q clkload33/A _11030_/D _11030_/RESET_B VPWR VGND sg13cmos5l_dfrbpq_1
XFILLER_89_486 VPWR VGND sg13cmos5l_decap_8
XFILLER_94_35 VPWR VGND sg13cmos5l_decap_8
XFILLER_76_136 VPWR VGND sg13cmos5l_decap_8
Xhold2061 _06959_/A _11648_/Q VPWR VGND sg13cmos5l_dlygate4sd3_1
Xhold2050 _06961_/A _11649_/Q VPWR VGND sg13cmos5l_dlygate4sd3_1
Xhold2072 _11666_/D _07019_/Y VPWR VGND sg13cmos5l_dlygate4sd3_1
XFILLER_91_106 VPWR VGND sg13cmos5l_fill_2
Xhold2083 _10723_/A _11598_/Q VPWR VGND sg13cmos5l_dlygate4sd3_1
Xhold2094 _09084_/A _11449_/Q VPWR VGND sg13cmos5l_dlygate4sd3_1
XFILLER_58_895 VPWR VGND sg13cmos5l_decap_8
XFILLER_100_992 VPWR VGND sg13cmos5l_decap_8
XFILLER_73_865 VPWR VGND sg13cmos5l_decap_8
XFILLER_60_504 VPWR VGND sg13cmos5l_fill_1
XFILLER_73_898 VPWR VGND sg13cmos5l_fill_2
XFILLER_45_589 VPWR VGND sg13cmos5l_decap_8
XFILLER_14_921 VPWR VGND sg13cmos5l_decap_4
X_10863__1119 _10863_/RESET_B VPWR VGND sg13cmos5l_tiehi
XFILLER_26_792 VPWR VGND sg13cmos5l_decap_8
X_10814_ _10814_/Q clkload39/A _10814_/D _10814_/RESET_B VPWR VGND sg13cmos5l_dfrbpq_1
XFILLER_13_442 VPWR VGND sg13cmos5l_fill_2
XFILLER_14_954 VPWR VGND sg13cmos5l_decap_8
X_10745_ _10745_/X _10749_/A _10745_/B VPWR VGND sg13cmos5l_and2_1
XFILLER_13_453 VPWR VGND sg13cmos5l_fill_2
XFILLER_13_486 VPWR VGND sg13cmos5l_fill_1
XFILLER_14_998 VPWR VGND sg13cmos5l_decap_8
X_10676_ _10676_/Y fanout85/X _10675_/X _10630_/B VPWR VGND sg13cmos5l_o21ai_1
XFILLER_9_468 VPWR VGND sg13cmos5l_decap_4
XFILLER_4_140 VPWR VGND sg13cmos5l_decap_8
X_11152__1749 _11152_/RESET_B VPWR VGND sg13cmos5l_tiehi
X_11228_ _11228_/Q _11356_/CLK _11228_/D _11228_/RESET_B VPWR VGND sg13cmos5l_dfrbpq_1
XFILLER_68_648 VPWR VGND sg13cmos5l_fill_1
X_11159_ _11159_/Q clkload9/A _11159_/D _11159_/RESET_B VPWR VGND sg13cmos5l_dfrbpq_1
XFILLER_95_434 VPWR VGND sg13cmos5l_fill_1
XFILLER_64_854 VPWR VGND sg13cmos5l_fill_2
XFILLER_48_372 VPWR VGND sg13cmos5l_fill_2
XFILLER_64_865 VPWR VGND sg13cmos5l_decap_8
X_08370_ _08370_/Y _08370_/A _08372_/B VPWR VGND sg13cmos5l_nand2_1
XFILLER_17_781 VPWR VGND sg13cmos5l_fill_2
X_07321_ _07321_/Y _07319_/Y _08695_/A _07340_/A2 VPWR VGND sg13cmos5l_a21oi_1
XFILLER_83_0 VPWR VGND sg13cmos5l_decap_8
X_07252_ _07252_/Y _11558_/Q _11556_/Q VPWR VGND sg13cmos5l_nand2_1
XFILLER_31_272 VPWR VGND sg13cmos5l_decap_8
X_07183_ _07183_/Y _05957_/Y _07212_/A2 _07181_/Y _07182_/Y VPWR VGND sg13cmos5l_a22oi_1
X_06203_ _06204_/B _06203_/A _09180_/A VPWR VGND sg13cmos5l_nor2_1
X_06134_ _12768_/A _06134_/A _06134_/B _06134_/C VPWR VGND sg13cmos5l_or3_1
XFILLER_9_991 VPWR VGND sg13cmos5l_decap_8
XFILLER_99_740 VPWR VGND sg13cmos5l_decap_8
X_06065_ _06065_/Y _06933_/A _06065_/B _06065_/C VPWR VGND sg13cmos5l_nor3_1
X_11128__1773 _11128_/RESET_B VPWR VGND sg13cmos5l_tiehi
Xfanout414 _09605_/B1 _09688_/S1 VPWR VGND sg13cmos5l_buf_1
Xfanout403 _09551_/S1 _09495_/A1 VPWR VGND sg13cmos5l_buf_1
XFILLER_101_723 VPWR VGND sg13cmos5l_fill_2
XFILLER_99_784 VPWR VGND sg13cmos5l_fill_1
X_09824_ _09824_/Y _11360_/Q _09824_/A2 _10035_/B1 _09823_/Y VPWR VGND sg13cmos5l_a22oi_1
Xfanout447 _10039_/B _10041_/B VPWR VGND sg13cmos5l_buf_1
XFILLER_86_401 VPWR VGND sg13cmos5l_fill_2
XFILLER_59_626 VPWR VGND sg13cmos5l_fill_2
XFILLER_48_39 VPWR VGND sg13cmos5l_fill_2
Xfanout436 _09841_/B _09419_/B VPWR VGND sg13cmos5l_buf_1
Xfanout425 _09842_/B1 _09601_/B1 VPWR VGND sg13cmos5l_buf_1
Xfanout458 _09934_/B _08573_/S VPWR VGND sg13cmos5l_buf_1
XFILLER_87_968 VPWR VGND sg13cmos5l_decap_4
Xfanout469 _09363_/B _06468_/B VPWR VGND sg13cmos5l_buf_1
XFILLER_24_1019 VPWR VGND sg13cmos5l_decap_8
XFILLER_101_778 VPWR VGND sg13cmos5l_fill_2
X_09755_ _09755_/Y _09755_/A _09755_/B VPWR VGND sg13cmos5l_nor2_1
X_06967_ _06967_/Y _06967_/A _07026_/B VPWR VGND sg13cmos5l_nand2_1
XFILLER_104_56 VPWR VGND sg13cmos5l_decap_8
X_06898_ _11705_/D hold2738/X _07172_/A _07091_/S VPWR VGND sg13cmos5l_mux2_1
XFILLER_64_16 VPWR VGND sg13cmos5l_fill_1
X_09686_ _09687_/C _09682_/Y _09683_/Y _09684_/Y _09685_/Y _09983_/C1 VPWR VGND sg13cmos5l_a221oi_1
XFILLER_55_832 VPWR VGND sg13cmos5l_decap_8
X_08706_ _08707_/A _09645_/A _08936_/B _08943_/B _08946_/B1 VPWR VGND sg13cmos5l_a22oi_1
XFILLER_39_383 VPWR VGND sg13cmos5l_decap_8
X_05918_ _09402_/A _09202_/A VPWR VGND sg13cmos5l_inv_1
X_08637_ _11384_/D _11714_/D _07206_/B _08645_/S VPWR VGND sg13cmos5l_mux2_1
XFILLER_70_846 VPWR VGND sg13cmos5l_fill_2
X_08568_ _11368_/D fanout51/X _08569_/B _08567_/Y VPWR VGND sg13cmos5l_a21oi_1
Xfanout54 fanout54/X _07639_/Y VPWR VGND sg13cmos5l_buf_1
X_08499_ _11334_/D fanout55/X _08498_/B _08498_/Y VPWR VGND sg13cmos5l_o21ai_1
XFILLER_70_1028 VPWR VGND sg13cmos5l_fill_1
XFILLER_70_1017 VPWR VGND sg13cmos5l_decap_8
Xfanout65 _10539_/A _10407_/A VPWR VGND sg13cmos5l_buf_1
X_07519_ _07519_/Y _07519_/A _07566_/B VPWR VGND sg13cmos5l_nor2_1
Xfanout76 fanout76/X fanout77/X VPWR VGND sg13cmos5l_buf_1
X_10530_ _11539_/D _10528_/Y _10529_/X _10522_/Y VPWR VGND sg13cmos5l_o21ai_1
Xfanout87 _09354_/B _09540_/A VPWR VGND sg13cmos5l_buf_1
Xfanout98 fanout98/X _07544_/Y VPWR VGND sg13cmos5l_buf_1
XFILLER_22_283 VPWR VGND sg13cmos5l_fill_1
X_10461_ _10461_/Y _10474_/A _10461_/B _10537_/A VPWR VGND sg13cmos5l_nand3b_1
XFILLER_7_939 VPWR VGND sg13cmos5l_fill_2
XFILLER_13_53 VPWR VGND sg13cmos5l_fill_1
XFILLER_89_35 VPWR VGND sg13cmos5l_decap_8
X_10392_ _10392_/Y _09583_/A _10495_/A2 _10385_/X _10537_/A _10508_/B1 VPWR VGND sg13cmos5l_a221oi_1
X_11013_ _11013_/Q _11355_/CLK _11013_/D _11013_/RESET_B VPWR VGND sg13cmos5l_dfrbpq_1
X_10917__1065 _10917_/RESET_B VPWR VGND sg13cmos5l_tiehi
XFILLER_64_106 VPWR VGND sg13cmos5l_fill_1
XFILLER_49_158 VPWR VGND sg13cmos5l_fill_1
XFILLER_73_651 VPWR VGND sg13cmos5l_decap_8
XFILLER_33_504 VPWR VGND sg13cmos5l_decap_8
XFILLER_61_824 VPWR VGND sg13cmos5l_fill_1
XFILLER_33_515 VPWR VGND sg13cmos5l_fill_2
XFILLER_61_868 VPWR VGND sg13cmos5l_decap_8
XFILLER_33_559 VPWR VGND sg13cmos5l_fill_1
X_11206__1695 _11206_/RESET_B VPWR VGND sg13cmos5l_tiehi
X_10728_ _10729_/B _11560_/Q _10728_/B _10728_/C VPWR VGND sg13cmos5l_nand3_1
X_11690__1274 _11690_/RESET_B VPWR VGND sg13cmos5l_tiehi
XFILLER_13_283 VPWR VGND sg13cmos5l_decap_4
XFILLER_9_276 VPWR VGND sg13cmos5l_fill_2
Xclkload24 clkload24/Y clkload24/A VPWR VGND sg13cmos5l_inv_4
X_10659_ _10673_/A _10659_/A _10659_/B VPWR VGND sg13cmos5l_nand2_1
XFILLER_70_92 VPWR VGND sg13cmos5l_fill_2
XFILLER_70_81 VPWR VGND sg13cmos5l_decap_8
Xclkload13 clkload13/Y clkload13/A VPWR VGND sg13cmos5l_inv_8
XFILLER_10_990 VPWR VGND sg13cmos5l_decap_8
Xclkload35 clkload35/Y clkload35/A VPWR VGND sg13cmos5l_inv_2
Xclkload57 clkload57/Y clkload57/A VPWR VGND sg13cmos5l_inv_2
XFILLER_86_1013 VPWR VGND sg13cmos5l_decap_8
Xclkload46 clkload46/Y clkload46/A VPWR VGND sg13cmos5l_inv_1
XFILLER_55_4 VPWR VGND sg13cmos5l_decap_4
XFILLER_6_983 VPWR VGND sg13cmos5l_decap_8
X_11428__1434 _11428_/RESET_B VPWR VGND sg13cmos5l_tiehi
Xhold2808 hold2808/X _11554_/Q VPWR VGND sg13cmos5l_dlygate4sd3_1
XFILLER_69_946 VPWR VGND sg13cmos5l_fill_2
XFILLER_68_412 VPWR VGND sg13cmos5l_fill_1
Xhold2819 hold2819/X _11733_/Q VPWR VGND sg13cmos5l_dlygate4sd3_1
X_11479__1225 _11479_/RESET_B VPWR VGND sg13cmos5l_tiehi
XFILLER_96_743 VPWR VGND sg13cmos5l_decap_4
XFILLER_95_220 VPWR VGND sg13cmos5l_fill_2
X_07870_ _11025_/D _08522_/A1 _07901_/B _07869_/Y VPWR VGND sg13cmos5l_a21oi_1
XFILLER_96_798 VPWR VGND sg13cmos5l_fill_2
XFILLER_95_275 VPWR VGND sg13cmos5l_fill_2
X_06821_ _06821_/Y _06821_/A _06861_/B VPWR VGND sg13cmos5l_nand2_1
XFILLER_56_618 VPWR VGND sg13cmos5l_decap_8
XFILLER_37_810 VPWR VGND sg13cmos5l_fill_2
XFILLER_28_309 VPWR VGND sg13cmos5l_fill_1
X_09540_ _09540_/Y _09540_/A _09540_/B _09540_/C VPWR VGND sg13cmos5l_nor3_1
X_06752_ _06752_/Y _06752_/A _06752_/B VPWR VGND sg13cmos5l_nand2_1
XFILLER_48_191 VPWR VGND sg13cmos5l_decap_8
X_09471_ _09471_/Y _09572_/B1 _09470_/X _09574_/B1 VPWR VGND sg13cmos5l_a21oi_1
X_08422_ _11296_/D fanout72/X _08433_/B _08421_/Y VPWR VGND sg13cmos5l_a21oi_1
XFILLER_93_1028 VPWR VGND sg13cmos5l_fill_1
XFILLER_64_684 VPWR VGND sg13cmos5l_fill_1
XFILLER_63_172 VPWR VGND sg13cmos5l_decap_4
XFILLER_63_161 VPWR VGND sg13cmos5l_fill_1
XFILLER_51_301 VPWR VGND sg13cmos5l_fill_1
X_06683_ _06683_/Y _06687_/A _06758_/A2 _06732_/B _06685_/A _06682_/Y VPWR VGND sg13cmos5l_a221oi_1
XFILLER_36_397 VPWR VGND sg13cmos5l_decap_8
X_08353_ _11262_/D fanout76/X _08366_/B _08352_/Y VPWR VGND sg13cmos5l_o21ai_1
XFILLER_11_209 VPWR VGND sg13cmos5l_fill_2
X_07304_ _07304_/Y _09202_/A _07304_/A2 _07303_/Y VPWR VGND sg13cmos5l_a21oi_1
X_08284_ _11228_/D fanout81/X _08283_/B _08283_/Y VPWR VGND sg13cmos5l_a21oi_1
X_07235_ _07235_/Y _10852_/Q _07237_/A2 _07243_/B1 hold2667/X VPWR VGND sg13cmos5l_a22oi_1
Xclkload7 clkload7/Y clkload7/A VPWR VGND sg13cmos5l_inv_2
XFILLER_106_826 VPWR VGND sg13cmos5l_decap_8
X_07166_ _07166_/X _07210_/B _07185_/B VPWR VGND sg13cmos5l_and2_1
XFILLER_105_314 VPWR VGND sg13cmos5l_decap_8
X_07097_ _11713_/D hold2753/X _07201_/A _07098_/B VPWR VGND sg13cmos5l_mux2_1
X_06117_ _06117_/Y _06117_/A _12766_/A _06117_/C VPWR VGND sg13cmos5l_nand3_1
XFILLER_3_419 VPWR VGND sg13cmos5l_fill_1
X_06048_ _10696_/B _10709_/A _06790_/A _06064_/B VPWR VGND sg13cmos5l_nand3_1
Xfanout222 _08047_/B _08041_/B VPWR VGND sg13cmos5l_buf_1
Xfanout211 _08153_/B _08116_/Y VPWR VGND sg13cmos5l_buf_1
Xfanout200 _08283_/B _08246_/Y VPWR VGND sg13cmos5l_buf_1
Xfanout233 _07899_/B _07917_/B VPWR VGND sg13cmos5l_buf_1
Xfanout244 _07778_/B fanout246/X VPWR VGND sg13cmos5l_buf_1
Xfanout255 _07714_/B fanout256/X VPWR VGND sg13cmos5l_buf_1
XFILLER_59_423 VPWR VGND sg13cmos5l_decap_4
XFILLER_87_776 VPWR VGND sg13cmos5l_fill_2
X_09807_ _09807_/Y _09807_/A _09807_/B _09807_/C VPWR VGND sg13cmos5l_nor3_1
Xfanout299 _07814_/B _07813_/A2 VPWR VGND sg13cmos5l_buf_1
Xfanout277 _08332_/B _08338_/B VPWR VGND sg13cmos5l_buf_1
Xfanout288 _08076_/B _08074_/B VPWR VGND sg13cmos5l_buf_1
Xfanout266 _07537_/B fanout271/X VPWR VGND sg13cmos5l_buf_1
X_07999_ _07999_/Y _07999_/A _08031_/B VPWR VGND sg13cmos5l_nor2_1
X_09738_ _09738_/Y _09738_/A1 _09732_/X _09633_/A VPWR VGND sg13cmos5l_a21oi_1
XFILLER_28_821 VPWR VGND sg13cmos5l_decap_4
XFILLER_91_14 VPWR VGND sg13cmos5l_decap_8
XFILLER_70_610 VPWR VGND sg13cmos5l_decap_8
XFILLER_61_109 VPWR VGND sg13cmos5l_fill_1
XFILLER_55_695 VPWR VGND sg13cmos5l_decap_8
X_09669_ _09669_/Y _09669_/A _09669_/B VPWR VGND sg13cmos5l_nor2_1
X_11700_ _11700_/Q clkload31/A _11700_/D _11700_/RESET_B VPWR VGND sg13cmos5l_dfrbpq_1
XFILLER_43_857 VPWR VGND sg13cmos5l_decap_8
X_11631_ _11631_/Q clkload31/A _11631_/D _11631_/RESET_B VPWR VGND sg13cmos5l_dfrbpq_1
XFILLER_42_367 VPWR VGND sg13cmos5l_fill_2
XFILLER_24_41 VPWR VGND sg13cmos5l_decap_8
XFILLER_30_529 VPWR VGND sg13cmos5l_decap_8
X_11562_ _11562_/Q clkload29/A _11562_/D _11562_/RESET_B VPWR VGND sg13cmos5l_dfrbpq_1
XFILLER_11_721 VPWR VGND sg13cmos5l_decap_8
XFILLER_24_85 VPWR VGND sg13cmos5l_fill_2
X_10513_ _10568_/B _10513_/A _10848_/Q VPWR VGND sg13cmos5l_xnor2_1
XFILLER_24_96 VPWR VGND sg13cmos5l_fill_2
X_11493_ _11493_/Q _11671_/CLK _11493_/D _11493_/RESET_B VPWR VGND sg13cmos5l_dfrbpq_1
XFILLER_40_40 VPWR VGND sg13cmos5l_decap_8
X_10444_ _10445_/B _10439_/Y _10440_/Y _10560_/A VPWR VGND sg13cmos5l_a21oi_1
X_10375_ _10376_/C _10373_/Y _10374_/Y _10443_/B1 VPWR VGND sg13cmos5l_o21ai_1
XFILLER_3_997 VPWR VGND sg13cmos5l_decap_8
XFILLER_2_452 VPWR VGND sg13cmos5l_fill_2
XFILLER_2_474 VPWR VGND sg13cmos5l_decap_8
XFILLER_78_743 VPWR VGND sg13cmos5l_decap_8
XFILLER_27_8 VPWR VGND sg13cmos5l_fill_2
XFILLER_93_713 VPWR VGND sg13cmos5l_decap_8
XFILLER_66_949 VPWR VGND sg13cmos5l_fill_1
XFILLER_37_139 VPWR VGND sg13cmos5l_decap_4
XFILLER_92_256 VPWR VGND sg13cmos5l_fill_1
XFILLER_61_610 VPWR VGND sg13cmos5l_decap_8
XFILLER_33_301 VPWR VGND sg13cmos5l_decap_8
XFILLER_34_857 VPWR VGND sg13cmos5l_fill_1
XFILLER_60_175 VPWR VGND sg13cmos5l_fill_2
XFILLER_33_389 VPWR VGND sg13cmos5l_decap_8
X_07020_ _07020_/Y _07020_/A _07024_/B VPWR VGND sg13cmos5l_nor2_1
XFILLER_102_306 VPWR VGND sg13cmos5l_fill_1
XFILLER_88_529 VPWR VGND sg13cmos5l_fill_2
X_08971_ _08983_/B _08967_/A _08967_/B _09022_/A VPWR VGND sg13cmos5l_o21ai_1
X_07922_ _07922_/Y _07922_/A _07978_/B VPWR VGND sg13cmos5l_nand2_1
Xhold2616 _06859_/A _11620_/Q VPWR VGND sg13cmos5l_dlygate4sd3_1
Xhold2627 _11603_/D _06810_/Y VPWR VGND sg13cmos5l_dlygate4sd3_1
XFILLER_69_754 VPWR VGND sg13cmos5l_decap_8
Xhold2638 _07175_/A _11706_/Q VPWR VGND sg13cmos5l_dlygate4sd3_1
Xhold2605 _11376_/D _08626_/Y VPWR VGND sg13cmos5l_dlygate4sd3_1
X_07853_ _07984_/B _08376_/B _08376_/A VPWR VGND sg13cmos5l_nand2b_1
XFILLER_84_713 VPWR VGND sg13cmos5l_decap_8
Xhold1904 _10774_/A _11588_/Q VPWR VGND sg13cmos5l_dlygate4sd3_1
Xhold2649 _08648_/B _08647_/Y VPWR VGND sg13cmos5l_dlygate4sd3_1
XFILLER_57_938 VPWR VGND sg13cmos5l_fill_1
XFILLER_57_927 VPWR VGND sg13cmos5l_decap_8
Xhold1926 _08190_/A _11182_/Q VPWR VGND sg13cmos5l_dlygate4sd3_1
Xhold1915 _07814_/A _10999_/Q VPWR VGND sg13cmos5l_dlygate4sd3_1
XFILLER_29_607 VPWR VGND sg13cmos5l_fill_2
Xhold1948 _08102_/A _11140_/Q VPWR VGND sg13cmos5l_dlygate4sd3_1
Xhold1959 _08094_/A _11136_/Q VPWR VGND sg13cmos5l_dlygate4sd3_1
XFILLER_84_746 VPWR VGND sg13cmos5l_fill_2
X_06804_ _06840_/A _06825_/A _06804_/B VPWR VGND sg13cmos5l_nand2_1
Xhold1937 _08058_/A _11118_/Q VPWR VGND sg13cmos5l_dlygate4sd3_1
X_07784_ _07784_/Y _07784_/A _07784_/B VPWR VGND sg13cmos5l_nor2_1
XFILLER_84_768 VPWR VGND sg13cmos5l_decap_8
XFILLER_83_256 VPWR VGND sg13cmos5l_fill_1
XFILLER_37_651 VPWR VGND sg13cmos5l_fill_2
X_06735_ _10814_/D _06735_/A _06735_/B _06735_/C VPWR VGND sg13cmos5l_nand3_1
X_09523_ _09523_/Y _11061_/Q _09630_/B VPWR VGND sg13cmos5l_nand2_1
XFILLER_51_120 VPWR VGND sg13cmos5l_fill_2
X_06666_ _06666_/Y _06670_/A _06733_/B _06665_/Y VPWR VGND sg13cmos5l_o21ai_1
X_09454_ _09455_/B _09454_/A _09536_/B VPWR VGND sg13cmos5l_nand2_1
XFILLER_101_35 VPWR VGND sg13cmos5l_decap_8
XFILLER_52_676 VPWR VGND sg13cmos5l_decap_8
XFILLER_51_153 VPWR VGND sg13cmos5l_fill_2
XFILLER_40_805 VPWR VGND sg13cmos5l_decap_8
XFILLER_24_378 VPWR VGND sg13cmos5l_fill_2
XFILLER_25_879 VPWR VGND sg13cmos5l_fill_2
X_09385_ _09385_/Y _09175_/X _09195_/Y _09345_/A VPWR VGND sg13cmos5l_a21oi_1
X_08405_ _08405_/Y _08405_/A _08405_/B VPWR VGND sg13cmos5l_nor2_1
XFILLER_61_39 VPWR VGND sg13cmos5l_fill_1
X_06597_ _06597_/X _06597_/A _06597_/B VPWR VGND sg13cmos5l_xor2_1
XFILLER_40_838 VPWR VGND sg13cmos5l_fill_2
X_08336_ _08336_/Y _08336_/A _08338_/B VPWR VGND sg13cmos5l_nand2_1
XFILLER_33_890 VPWR VGND sg13cmos5l_fill_2
X_08267_ _08267_/Y _08267_/A _08267_/B VPWR VGND sg13cmos5l_nor2_1
XFILLER_20_562 VPWR VGND sg13cmos5l_fill_1
X_07218_ _10843_/D _10456_/B _07239_/A2 _07226_/B1 _07217_/Y VPWR VGND sg13cmos5l_a22oi_1
X_08198_ _08198_/Y _08198_/A _08198_/B VPWR VGND sg13cmos5l_nand2_1
XFILLER_106_623 VPWR VGND sg13cmos5l_decap_8
X_07149_ _07149_/Y hold2754/X _07150_/A2 _07071_/A VPWR VGND sg13cmos5l_o21ai_1
XFILLER_105_133 VPWR VGND sg13cmos5l_decap_8
XFILLER_10_32 VPWR VGND sg13cmos5l_decap_8
X_10160_ _10161_/C _11716_/Q _07065_/B _10159_/X _10171_/B VPWR VGND sg13cmos5l_a22oi_1
XFILLER_0_901 VPWR VGND sg13cmos5l_decap_8
XFILLER_86_14 VPWR VGND sg13cmos5l_decap_8
X_10091_ _10091_/X hold2860/X _10115_/A2 _10090_/Y VPWR VGND sg13cmos5l_a21o_1
XFILLER_102_873 VPWR VGND sg13cmos5l_fill_1
XFILLER_59_264 VPWR VGND sg13cmos5l_fill_2
XFILLER_59_253 VPWR VGND sg13cmos5l_decap_8
XFILLER_0_978 VPWR VGND sg13cmos5l_decap_8
XFILLER_101_383 VPWR VGND sg13cmos5l_fill_2
XFILLER_101_372 VPWR VGND sg13cmos5l_decap_8
XFILLER_87_584 VPWR VGND sg13cmos5l_decap_8
XFILLER_75_746 VPWR VGND sg13cmos5l_decap_4
XFILLER_75_735 VPWR VGND sg13cmos5l_fill_1
XFILLER_19_128 VPWR VGND sg13cmos5l_fill_2
XFILLER_75_779 VPWR VGND sg13cmos5l_fill_2
X_11412__1466 _11412_/RESET_B VPWR VGND sg13cmos5l_tiehi
XFILLER_47_459 VPWR VGND sg13cmos5l_decap_8
XFILLER_56_971 VPWR VGND sg13cmos5l_decap_4
X_10993_ _10993_/Q _11356_/CLK _10993_/D _10993_/RESET_B VPWR VGND sg13cmos5l_dfrbpq_1
XFILLER_55_492 VPWR VGND sg13cmos5l_fill_2
XFILLER_43_687 VPWR VGND sg13cmos5l_decap_8
XFILLER_43_665 VPWR VGND sg13cmos5l_decap_4
XFILLER_30_304 VPWR VGND sg13cmos5l_fill_1
XFILLER_70_484 VPWR VGND sg13cmos5l_fill_1
X_11087__1814 _11087_/RESET_B VPWR VGND sg13cmos5l_tiehi
XFILLER_43_698 VPWR VGND sg13cmos5l_fill_1
XFILLER_42_175 VPWR VGND sg13cmos5l_decap_8
X_11614_ _11614_/Q _11622_/CLK _11614_/D _11614_/RESET_B VPWR VGND sg13cmos5l_dfrbpq_1
X_11545_ _11545_/Q clkload47/A _11545_/D _11545_/RESET_B VPWR VGND sg13cmos5l_dfrbpq_1
X_11581__1465 _11581_/RESET_B VPWR VGND sg13cmos5l_tiehi
X_11476_ _11476_/Q clkload37/A _11476_/D _11476_/RESET_B VPWR VGND sg13cmos5l_dfrbpq_1
X_10427_ _10427_/Y _10427_/A _10427_/B _10427_/C _10427_/D VPWR VGND sg13cmos5l_nand4_1
X_11616__1359 _11616_/RESET_B VPWR VGND sg13cmos5l_tiehi
X_10358_ _10358_/Y _10180_/A _10166_/B _10323_/Y VPWR VGND sg13cmos5l_o21ai_1
XFILLER_97_326 VPWR VGND sg13cmos5l_decap_8
X_10289_ _10289_/X _10289_/A _10307_/B VPWR VGND sg13cmos5l_and2_1
XFILLER_78_573 VPWR VGND sg13cmos5l_fill_1
XFILLER_66_757 VPWR VGND sg13cmos5l_decap_8
XFILLER_19_651 VPWR VGND sg13cmos5l_decap_8
XFILLER_53_429 VPWR VGND sg13cmos5l_fill_1
XFILLER_80_248 VPWR VGND sg13cmos5l_decap_8
XFILLER_74_790 VPWR VGND sg13cmos5l_decap_4
XFILLER_46_481 VPWR VGND sg13cmos5l_fill_2
X_06520_ _06520_/Y _11278_/Q _09578_/A2 _06519_/Y VPWR VGND sg13cmos5l_o21ai_1
X_06451_ _06451_/Y _06451_/A _06452_/B VPWR VGND sg13cmos5l_nor2b_1
XFILLER_33_164 VPWR VGND sg13cmos5l_fill_2
X_09170_ _09171_/D _10424_/A _10850_/Q VPWR VGND sg13cmos5l_xnor2_1
XFILLER_21_359 VPWR VGND sg13cmos5l_fill_2
X_06382_ _06382_/X _06756_/A _06748_/A _06382_/C VPWR VGND sg13cmos5l_and3_1
X_08121_ _08121_/Y _08121_/A _08163_/B VPWR VGND sg13cmos5l_nor2_1
XFILLER_30_871 VPWR VGND sg13cmos5l_decap_8
X_08052_ _08052_/Y _08052_/A _08102_/B VPWR VGND sg13cmos5l_nand2_1
X_10876__1106 _10876_/RESET_B VPWR VGND sg13cmos5l_tiehi
X_10912__1070 _10912_/RESET_B VPWR VGND sg13cmos5l_tiehi
X_07003_ _07003_/Y _07006_/B _11502_/Q VPWR VGND sg13cmos5l_nand2b_1
XFILLER_88_326 VPWR VGND sg13cmos5l_fill_1
X_08954_ _08973_/B _08954_/A _08954_/B _08954_/C VPWR VGND sg13cmos5l_nor3_1
Xhold2402 _08527_/A _11348_/Q VPWR VGND sg13cmos5l_dlygate4sd3_1
Xhold2413 _08381_/A _11276_/Q VPWR VGND sg13cmos5l_dlygate4sd3_1
XFILLER_102_147 VPWR VGND sg13cmos5l_decap_8
X_07905_ _07905_/Y _07905_/A _07911_/B VPWR VGND sg13cmos5l_nor2_1
Xhold2435 _10737_/B _10736_/Y VPWR VGND sg13cmos5l_dlygate4sd3_1
Xhold2424 _07323_/A _10871_/Q VPWR VGND sg13cmos5l_dlygate4sd3_1
Xhold2446 _10870_/D _07318_/Y VPWR VGND sg13cmos5l_dlygate4sd3_1
XFILLER_99_1012 VPWR VGND sg13cmos5l_decap_8
XFILLER_97_882 VPWR VGND sg13cmos5l_fill_2
Xhold2468 _11646_/D _06947_/Y VPWR VGND sg13cmos5l_dlygate4sd3_1
Xhold2479 hold2479/X _11585_/Q VPWR VGND sg13cmos5l_dlygate4sd3_1
Xhold2457 _06865_/A _11623_/Q VPWR VGND sg13cmos5l_dlygate4sd3_1
XFILLER_84_521 VPWR VGND sg13cmos5l_fill_2
X_08885_ _08910_/B _11383_/Q _08876_/A _08890_/B _11384_/Q VPWR VGND sg13cmos5l_a22oi_1
X_11165__1736 _11165_/RESET_B VPWR VGND sg13cmos5l_tiehi
XFILLER_29_404 VPWR VGND sg13cmos5l_fill_2
X_07836_ _07836_/Y _07836_/A _07836_/B VPWR VGND sg13cmos5l_nand2_1
XFILLER_84_543 VPWR VGND sg13cmos5l_fill_1
XFILLER_56_234 VPWR VGND sg13cmos5l_fill_2
X_07767_ _10976_/D fanout72/X _07770_/B _07766_/Y VPWR VGND sg13cmos5l_a21oi_1
XFILLER_65_790 VPWR VGND sg13cmos5l_decap_8
X_06718_ _06718_/Y _06714_/A _06718_/B VPWR VGND sg13cmos5l_nand2b_1
X_09506_ _09506_/Y _09506_/A _09506_/B VPWR VGND sg13cmos5l_nand2_1
X_07698_ _07698_/Y _07698_/A _07704_/B VPWR VGND sg13cmos5l_nor2_1
XFILLER_71_259 VPWR VGND sg13cmos5l_fill_1
XFILLER_52_451 VPWR VGND sg13cmos5l_decap_8
XFILLER_9_809 VPWR VGND sg13cmos5l_fill_2
XFILLER_13_827 VPWR VGND sg13cmos5l_decap_4
XFILLER_13_849 VPWR VGND sg13cmos5l_decap_4
X_06649_ _06649_/Y _06649_/A _06649_/B VPWR VGND sg13cmos5l_xnor2_1
X_09437_ _11463_/D _06185_/B _09460_/A _09411_/Y _09436_/Y VPWR VGND sg13cmos5l_a22oi_1
X_09368_ _09375_/A _10017_/A _09368_/B _09368_/C VPWR VGND sg13cmos5l_nor3_1
XFILLER_12_337 VPWR VGND sg13cmos5l_fill_2
X_09299_ _10051_/A _09303_/A _09303_/C _10032_/A VPWR VGND sg13cmos5l_nand3b_1
X_08319_ _11245_/D _08319_/A1 _08328_/B _08318_/Y VPWR VGND sg13cmos5l_o21ai_1
XFILLER_21_882 VPWR VGND sg13cmos5l_fill_2
XFILLER_21_893 VPWR VGND sg13cmos5l_decap_8
X_11330_ _11330_/Q _11362_/CLK _11330_/D _11330_/RESET_B VPWR VGND sg13cmos5l_dfrbpq_1
XFILLER_106_420 VPWR VGND sg13cmos5l_decap_8
X_11261_ _11261_/Q clkload42/A _11261_/D _11261_/RESET_B VPWR VGND sg13cmos5l_dfrbpq_1
XFILLER_97_35 VPWR VGND sg13cmos5l_decap_8
X_10212_ _10214_/B _10212_/A _10222_/A _10212_/C VPWR VGND sg13cmos5l_nor3_1
X_11192_ _11192_/Q _11352_/CLK _11192_/D _11192_/RESET_B VPWR VGND sg13cmos5l_dfrbpq_1
XFILLER_106_497 VPWR VGND sg13cmos5l_decap_8
X_10143_ _10143_/Y _10157_/A1 _10856_/Q _10123_/A VPWR VGND sg13cmos5l_o21ai_1
XFILLER_0_720 VPWR VGND sg13cmos5l_fill_1
XFILLER_88_871 VPWR VGND sg13cmos5l_fill_2
X_11612__1365 _11612_/RESET_B VPWR VGND sg13cmos5l_tiehi
XFILLER_102_692 VPWR VGND sg13cmos5l_fill_2
XFILLER_75_510 VPWR VGND sg13cmos5l_fill_1
X_10074_ _10074_/Y _09401_/B _09401_/C _10070_/A VPWR VGND sg13cmos5l_o21ai_1
XFILLER_35_429 VPWR VGND sg13cmos5l_fill_1
X_10954__1028 _10954_/RESET_B VPWR VGND sg13cmos5l_tiehi
XFILLER_56_790 VPWR VGND sg13cmos5l_decap_8
XFILLER_28_481 VPWR VGND sg13cmos5l_decap_8
X_10976_ _10976_/Q clkload57/A _10976_/D _10976_/RESET_B VPWR VGND sg13cmos5l_dfrbpq_1
XFILLER_44_963 VPWR VGND sg13cmos5l_decap_8
XFILLER_71_793 VPWR VGND sg13cmos5l_fill_2
XFILLER_71_782 VPWR VGND sg13cmos5l_decap_8
XFILLER_15_164 VPWR VGND sg13cmos5l_fill_1
XFILLER_87_7 VPWR VGND sg13cmos5l_decap_8
XFILLER_31_646 VPWR VGND sg13cmos5l_decap_8
XFILLER_30_167 VPWR VGND sg13cmos5l_decap_8
X_11243__1658 _11243_/RESET_B VPWR VGND sg13cmos5l_tiehi
X_11528_ _11528_/Q _11528_/CLK _11528_/D _11528_/RESET_B VPWR VGND sg13cmos5l_dfrbpq_1
X_11459_ _11459_/Q clkload18/A _11459_/D _11459_/RESET_B VPWR VGND sg13cmos5l_dfrbpq_1
XFILLER_7_385 VPWR VGND sg13cmos5l_decap_8
XFILLER_97_145 VPWR VGND sg13cmos5l_decap_8
X_05951_ _05951_/Y _10954_/Q VPWR VGND sg13cmos5l_inv_1
XFILLER_79_893 VPWR VGND sg13cmos5l_decap_8
XFILLER_66_521 VPWR VGND sg13cmos5l_fill_1
XFILLER_39_735 VPWR VGND sg13cmos5l_decap_8
XFILLER_94_852 VPWR VGND sg13cmos5l_fill_2
XFILLER_94_841 VPWR VGND sg13cmos5l_decap_8
X_05882_ _05882_/Y input16/X VPWR VGND sg13cmos5l_inv_1
X_08670_ _11398_/D _08670_/A VPWR VGND sg13cmos5l_inv_1
X_07621_ _10916_/D _07640_/B fanout59/X _07615_/Y VPWR VGND sg13cmos5l_a21oi_1
XFILLER_54_738 VPWR VGND sg13cmos5l_fill_2
XFILLER_26_407 VPWR VGND sg13cmos5l_decap_8
X_07552_ _07552_/Y _07577_/A _07551_/X _07550_/Y VPWR VGND sg13cmos5l_o21ai_1
X_06503_ _06504_/A _09395_/A _06498_/X _06502_/Y VPWR VGND sg13cmos5l_o21ai_1
XFILLER_62_782 VPWR VGND sg13cmos5l_decap_8
XFILLER_62_771 VPWR VGND sg13cmos5l_fill_2
XFILLER_50_933 VPWR VGND sg13cmos5l_fill_1
X_07483_ _10896_/D _07482_/B _08063_/A1 _07482_/Y VPWR VGND sg13cmos5l_a21oi_1
X_06434_ _06434_/Y _10672_/A _06434_/B VPWR VGND sg13cmos5l_xnor2_1
X_09222_ _09223_/C _09480_/A _10842_/Q VPWR VGND sg13cmos5l_xnor2_1
X_09153_ _09153_/Y _09153_/A1 _09147_/Y _09151_/X _09152_/Y _05939_/Y VPWR VGND sg13cmos5l_a221oi_1
X_06365_ _06366_/C _06690_/A _06681_/A VPWR VGND sg13cmos5l_nor2_1
X_08104_ _08104_/Y _08104_/A _08104_/B VPWR VGND sg13cmos5l_nand2_1
X_09084_ _09084_/Y _09084_/A _09093_/B VPWR VGND sg13cmos5l_nand2_1
X_06296_ _06297_/B _11497_/Q _09202_/A VPWR VGND sg13cmos5l_nand2b_1
X_08035_ _08035_/Y _08035_/A _08047_/B VPWR VGND sg13cmos5l_nor2_1
X_11219__1682 _11219_/RESET_B VPWR VGND sg13cmos5l_tiehi
XFILLER_104_957 VPWR VGND sg13cmos5l_decap_8
XFILLER_103_467 VPWR VGND sg13cmos5l_fill_1
Xhold2221 _07782_/A _10984_/Q VPWR VGND sg13cmos5l_dlygate4sd3_1
XFILLER_88_145 VPWR VGND sg13cmos5l_fill_2
X_09986_ _09986_/Y _11078_/Q _09986_/B VPWR VGND sg13cmos5l_nand2_1
XFILLER_77_808 VPWR VGND sg13cmos5l_decap_8
Xhold2210 _07686_/A _10937_/Q VPWR VGND sg13cmos5l_dlygate4sd3_1
Xhold2243 _08551_/A _11360_/Q VPWR VGND sg13cmos5l_dlygate4sd3_1
Xhold2254 _09093_/A _11450_/Q VPWR VGND sg13cmos5l_dlygate4sd3_1
X_08937_ _08937_/Y _11630_/Q _08943_/B VPWR VGND sg13cmos5l_nand2_1
Xhold2232 _07545_/A _10905_/Q VPWR VGND sg13cmos5l_dlygate4sd3_1
XFILLER_29_201 VPWR VGND sg13cmos5l_fill_2
Xhold2276 _08161_/A _11168_/Q VPWR VGND sg13cmos5l_dlygate4sd3_1
XFILLER_85_852 VPWR VGND sg13cmos5l_fill_1
XFILLER_57_554 VPWR VGND sg13cmos5l_fill_1
X_08868_ _08868_/Y _08867_/A _08864_/X _08877_/B _08867_/Y _10719_/C VPWR VGND sg13cmos5l_a221oi_1
Xhold2287 _07993_/A _11086_/Q VPWR VGND sg13cmos5l_dlygate4sd3_1
Xhold2265 _08409_/A _11290_/Q VPWR VGND sg13cmos5l_dlygate4sd3_1
XFILLER_29_234 VPWR VGND sg13cmos5l_fill_1
XFILLER_45_727 VPWR VGND sg13cmos5l_decap_8
XFILLER_45_705 VPWR VGND sg13cmos5l_fill_2
Xhold2298 _08537_/A _11353_/Q VPWR VGND sg13cmos5l_dlygate4sd3_1
X_07819_ _11001_/D fanout99/X _07826_/B _07818_/Y VPWR VGND sg13cmos5l_o21ai_1
XFILLER_29_278 VPWR VGND sg13cmos5l_decap_4
XFILLER_83_59 VPWR VGND sg13cmos5l_fill_1
XFILLER_83_37 VPWR VGND sg13cmos5l_decap_4
XFILLER_57_598 VPWR VGND sg13cmos5l_fill_1
X_08799_ _08799_/Y _08817_/B _08780_/Y _08856_/B1 VPWR VGND sg13cmos5l_o21ai_1
XFILLER_45_738 VPWR VGND sg13cmos5l_fill_1
XFILLER_73_1004 VPWR VGND sg13cmos5l_fill_1
XFILLER_72_568 VPWR VGND sg13cmos5l_fill_1
X_10830_ _10830_/Q clkload28/A _10830_/D _10830_/RESET_B VPWR VGND sg13cmos5l_dfrbpq_1
X_10761_ _10761_/X _11696_/Q hold2557/X _10762_/S VPWR VGND sg13cmos5l_mux2_1
XFILLER_40_410 VPWR VGND sg13cmos5l_decap_8
XFILLER_25_484 VPWR VGND sg13cmos5l_fill_1
X_10692_ _10704_/C _10709_/A _10693_/C VPWR VGND sg13cmos5l_nor2_1
XFILLER_9_617 VPWR VGND sg13cmos5l_fill_1
XFILLER_16_97 VPWR VGND sg13cmos5l_fill_1
XFILLER_9_639 VPWR VGND sg13cmos5l_decap_8
XFILLER_12_156 VPWR VGND sg13cmos5l_fill_1
XFILLER_32_30 VPWR VGND sg13cmos5l_fill_1
XFILLER_4_311 VPWR VGND sg13cmos5l_decap_4
X_11313_ _11313_/Q clkload35/A _11313_/D _11313_/RESET_B VPWR VGND sg13cmos5l_dfrbpq_1
X_11244_ _11244_/Q _11265_/CLK _11244_/D _11244_/RESET_B VPWR VGND sg13cmos5l_dfrbpq_1
XFILLER_106_294 VPWR VGND sg13cmos5l_decap_8
X_11175_ _11175_/Q _11364_/CLK _11175_/D _11175_/RESET_B VPWR VGND sg13cmos5l_dfrbpq_1
XFILLER_95_605 VPWR VGND sg13cmos5l_fill_2
X_10126_ _10126_/Y _10584_/A _10126_/B VPWR VGND sg13cmos5l_nor2_1
XFILLER_94_159 VPWR VGND sg13cmos5l_fill_2
X_10057_ _10057_/Y _05934_/Y _06523_/A _08648_/A VPWR VGND sg13cmos5l_a21oi_1
XFILLER_48_532 VPWR VGND sg13cmos5l_fill_2
XFILLER_0_594 VPWR VGND sg13cmos5l_decap_8
XFILLER_48_565 VPWR VGND sg13cmos5l_fill_2
XFILLER_17_941 VPWR VGND sg13cmos5l_fill_1
XFILLER_44_782 VPWR VGND sg13cmos5l_decap_8
X_10959_ _10959_/Q clkload44/A _10959_/D _10959_/RESET_B VPWR VGND sg13cmos5l_dfrbpq_1
XFILLER_31_421 VPWR VGND sg13cmos5l_fill_2
XFILLER_31_432 VPWR VGND sg13cmos5l_decap_8
XFILLER_31_443 VPWR VGND sg13cmos5l_fill_1
XFILLER_12_690 VPWR VGND sg13cmos5l_fill_1
XFILLER_8_672 VPWR VGND sg13cmos5l_decap_8
X_06150_ _06687_/A _11501_/Q _06150_/B VPWR VGND sg13cmos5l_or2_1
X_06081_ _06089_/A _10691_/B _06066_/C _10694_/A VPWR VGND sg13cmos5l_a21oi_1
XFILLER_7_160 VPWR VGND sg13cmos5l_fill_2
XFILLER_98_421 VPWR VGND sg13cmos5l_fill_2
XFILLER_99_977 VPWR VGND sg13cmos5l_decap_8
Xfanout629 _09153_/A1 _10719_/B VPWR VGND sg13cmos5l_buf_1
Xfanout618 _06917_/B _08615_/A VPWR VGND sg13cmos5l_buf_1
Xfanout607 _08739_/B2 _08957_/B1 VPWR VGND sg13cmos5l_buf_1
X_09840_ _09840_/X _11009_/Q _10977_/Q _09840_/S VPWR VGND sg13cmos5l_mux2_1
XFILLER_100_426 VPWR VGND sg13cmos5l_fill_1
XFILLER_98_498 VPWR VGND sg13cmos5l_decap_8
X_09771_ _09771_/Y _09768_/Y _09770_/Y _09994_/A1 VPWR VGND sg13cmos5l_o21ai_1
XFILLER_86_638 VPWR VGND sg13cmos5l_decap_4
XFILLER_86_627 VPWR VGND sg13cmos5l_fill_2
XFILLER_58_329 VPWR VGND sg13cmos5l_fill_2
XFILLER_58_318 VPWR VGND sg13cmos5l_decap_8
X_06983_ _06983_/Y _06982_/B1 _11497_/Q VPWR VGND sg13cmos5l_nand2b_1
XFILLER_79_690 VPWR VGND sg13cmos5l_decap_4
X_05934_ _05934_/Y _10709_/A VPWR VGND sg13cmos5l_inv_1
XFILLER_39_543 VPWR VGND sg13cmos5l_decap_8
X_08722_ _08992_/B _08722_/A _08722_/B VPWR VGND sg13cmos5l_nand2_1
XFILLER_94_671 VPWR VGND sg13cmos5l_fill_2
XFILLER_82_800 VPWR VGND sg13cmos5l_fill_2
XFILLER_67_896 VPWR VGND sg13cmos5l_decap_8
XFILLER_96_1026 VPWR VGND sg13cmos5l_fill_2
X_08653_ _08653_/Y _08653_/A _08653_/B VPWR VGND sg13cmos5l_nor2_1
X_05865_ _07604_/A _11416_/Q VPWR VGND sg13cmos5l_inv_1
X_08584_ _08584_/Y _08584_/A _08584_/B _08584_/C VPWR VGND sg13cmos5l_nor3_1
X_07604_ _07604_/X _07604_/A _07604_/B VPWR VGND sg13cmos5l_and2_1
XFILLER_26_248 VPWR VGND sg13cmos5l_decap_8
XFILLER_35_771 VPWR VGND sg13cmos5l_decap_8
X_07535_ _07535_/Y _10456_/A _07528_/Y _07530_/A VPWR VGND sg13cmos5l_a21oi_1
X_11508__1167 _11508_/RESET_B VPWR VGND sg13cmos5l_tiehi
XFILLER_50_730 VPWR VGND sg13cmos5l_fill_1
X_07466_ _07466_/Y _07464_/Y _07471_/B _07515_/A VPWR VGND sg13cmos5l_o21ai_1
X_06417_ _06417_/Y _06252_/A _06444_/C _06643_/B1 _06416_/Y VPWR VGND sg13cmos5l_a22oi_1
XFILLER_50_785 VPWR VGND sg13cmos5l_fill_1
XFILLER_10_616 VPWR VGND sg13cmos5l_fill_1
X_09205_ _09206_/C _09205_/A _10838_/Q VPWR VGND sg13cmos5l_xnor2_1
X_11583__1457 _11583_/RESET_B VPWR VGND sg13cmos5l_tiehi
X_07397_ _07397_/Y _11545_/Q _08750_/A VPWR VGND sg13cmos5l_nand2_1
XFILLER_50_796 VPWR VGND sg13cmos5l_decap_8
X_09136_ _09147_/B _09138_/B _09136_/B VPWR VGND sg13cmos5l_nand2_1
X_06348_ _06610_/C _06603_/B _06603_/C _06182_/B VPWR VGND sg13cmos5l_o21ai_1
X_09067_ _09067_/X _09066_/A _09066_/B _09104_/A VPWR VGND sg13cmos5l_a21o_1
X_06279_ _06279_/X _06582_/A _06582_/B _06278_/Y VPWR VGND sg13cmos5l_a21o_1
XFILLER_2_804 VPWR VGND sg13cmos5l_decap_8
X_08018_ _11098_/D fanout97/X _08023_/B _08017_/Y VPWR VGND sg13cmos5l_a21oi_1
XFILLER_104_721 VPWR VGND sg13cmos5l_decap_8
XFILLER_1_325 VPWR VGND sg13cmos5l_fill_1
XFILLER_103_231 VPWR VGND sg13cmos5l_decap_8
XFILLER_89_476 VPWR VGND sg13cmos5l_decap_4
XFILLER_76_104 VPWR VGND sg13cmos5l_fill_1
X_09969_ _09969_/Y _09968_/A _09968_/B _09882_/Y VPWR VGND sg13cmos5l_o21ai_1
XFILLER_94_14 VPWR VGND sg13cmos5l_decap_8
Xhold2040 _09155_/A _11454_/Q VPWR VGND sg13cmos5l_dlygate4sd3_1
Xhold2062 _11648_/D _06960_/Y VPWR VGND sg13cmos5l_dlygate4sd3_1
Xhold2051 _11649_/D _06962_/Y VPWR VGND sg13cmos5l_dlygate4sd3_1
XFILLER_100_971 VPWR VGND sg13cmos5l_decap_8
X_11011__971 _11011_/RESET_B VPWR VGND sg13cmos5l_tiehi
Xhold2084 _11598_/D _06795_/Y VPWR VGND sg13cmos5l_dlygate4sd3_1
Xhold2073 _08959_/A _11440_/Q VPWR VGND sg13cmos5l_dlygate4sd3_1
Xhold2095 _07475_/A _10895_/Q VPWR VGND sg13cmos5l_dlygate4sd3_1
XFILLER_45_535 VPWR VGND sg13cmos5l_fill_2
XFILLER_17_215 VPWR VGND sg13cmos5l_fill_2
XFILLER_13_410 VPWR VGND sg13cmos5l_fill_1
XFILLER_26_771 VPWR VGND sg13cmos5l_decap_8
X_10813_ _10813_/Q clkload39/A _10813_/D _10813_/RESET_B VPWR VGND sg13cmos5l_dfrbpq_1
XFILLER_60_549 VPWR VGND sg13cmos5l_decap_8
XFILLER_41_730 VPWR VGND sg13cmos5l_decap_8
X_10871__1111 _10871_/RESET_B VPWR VGND sg13cmos5l_tiehi
X_10744_ _10745_/B _10744_/A _10744_/B VPWR VGND sg13cmos5l_nand2_1
XFILLER_40_251 VPWR VGND sg13cmos5l_decap_8
XFILLER_9_403 VPWR VGND sg13cmos5l_decap_8
XFILLER_14_988 VPWR VGND sg13cmos5l_fill_1
X_10675_ _10675_/X _11746_/Q _10675_/B VPWR VGND sg13cmos5l_and2_1
XFILLER_9_447 VPWR VGND sg13cmos5l_fill_1
X_10799__936 _10799_/RESET_B VPWR VGND sg13cmos5l_tiehi
XFILLER_99_207 VPWR VGND sg13cmos5l_fill_2
X_11160__1741 _11160_/RESET_B VPWR VGND sg13cmos5l_tiehi
XFILLER_4_163 VPWR VGND sg13cmos5l_fill_1
X_11227_ _11227_/Q clkload43/A _11227_/D _11227_/RESET_B VPWR VGND sg13cmos5l_dfrbpq_1
X_11158_ _11158_/Q clkload9/A _11158_/D _11158_/RESET_B VPWR VGND sg13cmos5l_dfrbpq_1
X_10109_ _11504_/D _10433_/B _10115_/A2 _10108_/Y VPWR VGND sg13cmos5l_a21o_1
XFILLER_49_863 VPWR VGND sg13cmos5l_decap_8
X_11089_ _11089_/Q _11265_/CLK _11089_/D _11089_/RESET_B VPWR VGND sg13cmos5l_dfrbpq_1
XFILLER_36_535 VPWR VGND sg13cmos5l_decap_8
XFILLER_36_513 VPWR VGND sg13cmos5l_decap_4
XFILLER_63_376 VPWR VGND sg13cmos5l_fill_1
XFILLER_51_516 VPWR VGND sg13cmos5l_decap_8
Xheichips26_RiMaX uio_oe[0] VPWR VGND sg13cmos5l_tielo
XFILLER_23_207 VPWR VGND sg13cmos5l_fill_2
X_07320_ _08695_/A _08905_/A _07326_/B VPWR VGND sg13cmos5l_nand2_1
X_07251_ _07251_/X _11558_/Q _11556_/Q VPWR VGND sg13cmos5l_and2_1
X_11719__1242 _11719_/RESET_B VPWR VGND sg13cmos5l_tiehi
XFILLER_20_947 VPWR VGND sg13cmos5l_fill_2
X_07182_ _07182_/Y _08889_/A _11378_/Q _07185_/A _11708_/Q _07182_/C1 VPWR VGND sg13cmos5l_a221oi_1
X_06202_ _06603_/B _06203_/A _09180_/A VPWR VGND sg13cmos5l_and2_1
XFILLER_9_970 VPWR VGND sg13cmos5l_decap_8
X_06133_ _06134_/C _06133_/A _06133_/B VPWR VGND sg13cmos5l_or2_1
X_06064_ _06065_/C _10713_/A _06064_/B VPWR VGND sg13cmos5l_nand2_1
Xfanout404 _09575_/S1 _09495_/A1 VPWR VGND sg13cmos5l_buf_1
XFILLER_99_796 VPWR VGND sg13cmos5l_fill_1
XFILLER_98_262 VPWR VGND sg13cmos5l_fill_2
XFILLER_98_251 VPWR VGND sg13cmos5l_decap_8
Xfanout448 _09823_/B _10041_/B VPWR VGND sg13cmos5l_buf_1
X_09823_ _09823_/Y _11328_/Q _09823_/B VPWR VGND sg13cmos5l_nand2b_1
XFILLER_86_413 VPWR VGND sg13cmos5l_fill_1
XFILLER_59_638 VPWR VGND sg13cmos5l_decap_8
Xfanout415 _09688_/S1 fanout422/X VPWR VGND sg13cmos5l_buf_1
Xfanout426 _09735_/B1 _09601_/B1 VPWR VGND sg13cmos5l_buf_1
Xfanout437 _09630_/B _09529_/B VPWR VGND sg13cmos5l_buf_1
XFILLER_101_735 VPWR VGND sg13cmos5l_fill_2
XFILLER_98_284 VPWR VGND sg13cmos5l_decap_8
Xfanout459 _08573_/S _06451_/Y VPWR VGND sg13cmos5l_buf_1
XFILLER_104_35 VPWR VGND sg13cmos5l_decap_8
X_09754_ _09754_/Y _09754_/A _09754_/B VPWR VGND sg13cmos5l_nand2_1
XFILLER_39_362 VPWR VGND sg13cmos5l_decap_8
XFILLER_39_351 VPWR VGND sg13cmos5l_fill_1
X_06966_ _06966_/Y _07020_/A _07026_/B _06965_/Y VPWR VGND sg13cmos5l_o21ai_1
X_06897_ _11633_/D _11704_/D hold2830/X _08640_/A VPWR VGND sg13cmos5l_mux2_1
X_09685_ _09685_/Y _10907_/Q _09955_/B _09982_/B1 VPWR VGND sg13cmos5l_a21oi_1
X_08705_ _08954_/A _08943_/B VPWR VGND sg13cmos5l_inv_1
X_05917_ _09431_/A _09559_/A VPWR VGND sg13cmos5l_inv_1
XFILLER_82_663 VPWR VGND sg13cmos5l_decap_8
X_08636_ _11383_/D _11713_/D _07202_/B _08645_/S VPWR VGND sg13cmos5l_mux2_1
XFILLER_55_899 VPWR VGND sg13cmos5l_decap_8
XFILLER_54_365 VPWR VGND sg13cmos5l_fill_2
X_08567_ _08567_/Y _08567_/A _08569_/B VPWR VGND sg13cmos5l_nor2_1
XFILLER_54_398 VPWR VGND sg13cmos5l_decap_4
XFILLER_80_27 VPWR VGND sg13cmos5l_fill_1
X_08498_ _08498_/Y _08498_/A _08498_/B VPWR VGND sg13cmos5l_nand2_1
Xfanout55 fanout55/X _07633_/Y VPWR VGND sg13cmos5l_buf_1
X_07518_ _10901_/D _07517_/B _08530_/A1 _07517_/Y VPWR VGND sg13cmos5l_a21oi_1
Xfanout77 fanout77/X _07578_/Y VPWR VGND sg13cmos5l_buf_1
X_07449_ _07449_/Y _11393_/Q _07652_/A1 _07448_/X VPWR VGND sg13cmos5l_a21oi_1
XFILLER_50_571 VPWR VGND sg13cmos5l_fill_2
Xfanout66 _10407_/A _10312_/Y VPWR VGND sg13cmos5l_buf_1
Xfanout88 _09540_/A fanout95/X VPWR VGND sg13cmos5l_buf_1
Xfanout99 fanout99/X _07544_/Y VPWR VGND sg13cmos5l_buf_1
X_10460_ _10461_/B _10460_/A _10460_/B _10460_/C VPWR VGND sg13cmos5l_nand3_1
XFILLER_6_406 VPWR VGND sg13cmos5l_decap_8
XFILLER_89_14 VPWR VGND sg13cmos5l_decap_8
X_09119_ _09131_/B _09137_/A _09119_/B _09136_/B VPWR VGND sg13cmos5l_nor3_1
XFILLER_13_98 VPWR VGND sg13cmos5l_decap_4
X_10391_ _10391_/Y _10408_/A _10391_/B _10391_/C VPWR VGND sg13cmos5l_nand3_1
XFILLER_104_540 VPWR VGND sg13cmos5l_decap_8
XFILLER_104_584 VPWR VGND sg13cmos5l_decap_8
XFILLER_104_573 VPWR VGND sg13cmos5l_decap_8
X_11012_ _11012_/Q _11594_/CLK _11012_/D _11012_/RESET_B VPWR VGND sg13cmos5l_dfrbpq_1
XFILLER_89_262 VPWR VGND sg13cmos5l_fill_1
XFILLER_77_413 VPWR VGND sg13cmos5l_fill_1
XFILLER_78_969 VPWR VGND sg13cmos5l_decap_4
XFILLER_93_928 VPWR VGND sg13cmos5l_fill_2
XFILLER_92_449 VPWR VGND sg13cmos5l_fill_2
XFILLER_18_568 VPWR VGND sg13cmos5l_decap_8
XFILLER_73_685 VPWR VGND sg13cmos5l_fill_1
X_11178__1723 _11178_/RESET_B VPWR VGND sg13cmos5l_tiehi
XFILLER_72_184 VPWR VGND sg13cmos5l_fill_2
XFILLER_60_346 VPWR VGND sg13cmos5l_decap_4
XFILLER_60_335 VPWR VGND sg13cmos5l_fill_1
XFILLER_54_72 VPWR VGND sg13cmos5l_fill_1
XFILLER_26_590 VPWR VGND sg13cmos5l_fill_1
XFILLER_33_549 VPWR VGND sg13cmos5l_decap_4
XFILLER_60_368 VPWR VGND sg13cmos5l_fill_2
XFILLER_14_763 VPWR VGND sg13cmos5l_fill_1
X_10727_ _10727_/Y _10727_/A _10727_/B VPWR VGND sg13cmos5l_nand2_1
XFILLER_41_582 VPWR VGND sg13cmos5l_decap_8
XFILLER_13_262 VPWR VGND sg13cmos5l_decap_8
XFILLER_9_255 VPWR VGND sg13cmos5l_fill_1
Xclkload25 clkload25/X clkload25/A VPWR VGND sg13cmos5l_buf_8
X_10658_ _10659_/B _10658_/A _10658_/B VPWR VGND sg13cmos5l_xor2_1
X_10835__1172 _10835_/RESET_B VPWR VGND sg13cmos5l_tiehi
XFILLER_62_6 VPWR VGND sg13cmos5l_fill_1
Xclkload14 clkload14/Y clkload14/A VPWR VGND sg13cmos5l_inv_4
Xclkload58 clkload58/Y clkload58/A VPWR VGND sg13cmos5l_inv_2
Xclkload47 clkload47/X clkload47/A VPWR VGND sg13cmos5l_buf_8
X_10589_ _10589_/Y _10591_/A _10854_/Q VPWR VGND sg13cmos5l_nand2_1
X_11707__1257 _11707_/RESET_B VPWR VGND sg13cmos5l_tiehi
Xclkload36 clkload36/Y clkload36/A VPWR VGND sg13cmos5l_inv_4
XFILLER_48_4 VPWR VGND sg13cmos5l_decap_8
XFILLER_5_494 VPWR VGND sg13cmos5l_fill_1
Xhold2809 hold2809/X _11634_/Q VPWR VGND sg13cmos5l_dlygate4sd3_1
XFILLER_96_733 VPWR VGND sg13cmos5l_fill_1
XFILLER_95_210 VPWR VGND sg13cmos5l_decap_4
X_06820_ _06820_/Y _06825_/A _06820_/B _06820_/C VPWR VGND sg13cmos5l_nand3b_1
XFILLER_83_405 VPWR VGND sg13cmos5l_fill_1
XFILLER_55_118 VPWR VGND sg13cmos5l_decap_8
XFILLER_49_693 VPWR VGND sg13cmos5l_decap_8
XFILLER_49_682 VPWR VGND sg13cmos5l_fill_1
X_06751_ _10816_/D _06759_/A1 _06748_/Y _06750_/Y VPWR VGND sg13cmos5l_o21ai_1
XFILLER_92_972 VPWR VGND sg13cmos5l_decap_4
XFILLER_92_950 VPWR VGND sg13cmos5l_decap_8
XFILLER_64_663 VPWR VGND sg13cmos5l_fill_2
XFILLER_64_652 VPWR VGND sg13cmos5l_decap_8
XFILLER_64_630 VPWR VGND sg13cmos5l_decap_8
XFILLER_37_855 VPWR VGND sg13cmos5l_decap_8
XFILLER_36_321 VPWR VGND sg13cmos5l_fill_2
X_09470_ _09470_/X _11123_/Q _11091_/Q _11059_/Q _11027_/Q _09440_/B _09575_/S1 VPWR
+ VGND sg13cmos5l_mux4_1
X_06682_ _06682_/Y _06682_/A _06722_/B VPWR VGND sg13cmos5l_nor2_1
X_08421_ _08421_/Y _08421_/A _08433_/B VPWR VGND sg13cmos5l_nor2_1
XFILLER_52_825 VPWR VGND sg13cmos5l_fill_2
XFILLER_36_365 VPWR VGND sg13cmos5l_decap_4
X_08352_ _08352_/Y _08352_/A _08366_/B VPWR VGND sg13cmos5l_nand2_1
XFILLER_51_379 VPWR VGND sg13cmos5l_fill_1
X_07303_ _07303_/Y _07301_/Y _07302_/Y _07304_/A2 VPWR VGND sg13cmos5l_a21oi_1
X_08283_ _08283_/Y _08283_/A _08283_/B VPWR VGND sg13cmos5l_nor2_1
XFILLER_32_593 VPWR VGND sg13cmos5l_fill_2
X_07234_ _10851_/D _07244_/A _07234_/B VPWR VGND sg13cmos5l_nand2_1
Xclkload8 clkload8/Y clkload8/A VPWR VGND sg13cmos5l_inv_1
X_10967__1015 _10967_/RESET_B VPWR VGND sg13cmos5l_tiehi
XFILLER_106_805 VPWR VGND sg13cmos5l_decap_8
X_07165_ _07185_/B _10691_/B _11641_/Q VPWR VGND sg13cmos5l_or2_1
X_11001__981 _11001_/RESET_B VPWR VGND sg13cmos5l_tiehi
X_07096_ _11712_/D hold2767/X _07197_/A _07100_/S VPWR VGND sg13cmos5l_mux2_1
X_06116_ _06118_/A _06134_/A _06121_/B VPWR VGND sg13cmos5l_nand2_1
X_06047_ _06080_/C _06064_/B VPWR VGND sg13cmos5l_inv_1
Xfanout223 _08033_/B _08041_/B VPWR VGND sg13cmos5l_buf_1
Xfanout201 _08307_/B _08309_/B VPWR VGND sg13cmos5l_buf_1
Xfanout212 _08177_/B _08179_/B VPWR VGND sg13cmos5l_buf_1
Xfanout234 _07917_/B _07909_/B VPWR VGND sg13cmos5l_buf_1
Xfanout245 _07780_/B fanout246/X VPWR VGND sg13cmos5l_buf_1
Xfanout256 fanout256/X _07655_/Y VPWR VGND sg13cmos5l_buf_1
X_11256__1645 _11256_/RESET_B VPWR VGND sg13cmos5l_tiehi
Xfanout267 _07648_/B _07629_/B VPWR VGND sg13cmos5l_buf_1
X_09806_ _09807_/C _09722_/C _09803_/Y _09805_/Y VPWR VGND sg13cmos5l_o21ai_1
Xfanout278 _08338_/B _08364_/B VPWR VGND sg13cmos5l_buf_1
Xfanout289 _08074_/B _08102_/B VPWR VGND sg13cmos5l_buf_1
X_07998_ _11088_/D _08063_/A1 _08011_/B _07997_/Y VPWR VGND sg13cmos5l_a21oi_1
X_06949_ _08611_/B _11552_/Q _11551_/Q VPWR VGND sg13cmos5l_or2_1
X_09737_ _09737_/Y _06477_/B _09733_/X _09736_/Y VPWR VGND sg13cmos5l_o21ai_1
Xclkbuf_leaf_66_clk clkload16/A clkbuf_4_2_0_clk/X VPWR VGND sg13cmos5l_buf_8
XFILLER_27_332 VPWR VGND sg13cmos5l_decap_8
XFILLER_28_855 VPWR VGND sg13cmos5l_decap_4
XFILLER_28_877 VPWR VGND sg13cmos5l_decap_8
XFILLER_15_505 VPWR VGND sg13cmos5l_fill_2
X_09668_ _09669_/B _10434_/A _09668_/B VPWR VGND sg13cmos5l_nor2_1
XFILLER_70_644 VPWR VGND sg13cmos5l_decap_8
X_08619_ _08624_/B _08625_/A _08625_/B VPWR VGND sg13cmos5l_nor2_1
X_09599_ _09599_/Y _10968_/Q _09593_/B _09605_/B1 VPWR VGND sg13cmos5l_a21oi_1
X_11630_ _11630_/Q clkload31/A _11630_/D _11630_/RESET_B VPWR VGND sg13cmos5l_dfrbpq_1
XFILLER_42_357 VPWR VGND sg13cmos5l_fill_2
X_11561_ _11561_/Q _11594_/CLK _11561_/D _11561_/RESET_B VPWR VGND sg13cmos5l_dfrbpq_1
XFILLER_70_699 VPWR VGND sg13cmos5l_decap_4
XFILLER_51_880 VPWR VGND sg13cmos5l_decap_8
XFILLER_23_593 VPWR VGND sg13cmos5l_fill_2
XFILLER_24_53 VPWR VGND sg13cmos5l_fill_2
X_10512_ _10570_/A _10513_/A _10848_/Q VPWR VGND sg13cmos5l_nor2_1
XFILLER_10_276 VPWR VGND sg13cmos5l_decap_8
XFILLER_7_726 VPWR VGND sg13cmos5l_fill_1
X_11492_ _11492_/Q clkload11/A _11492_/D _11492_/RESET_B VPWR VGND sg13cmos5l_dfrbpq_1
X_10443_ _10445_/A _10411_/A _10442_/Y _10443_/B1 VPWR VGND sg13cmos5l_o21ai_1
XFILLER_40_30 VPWR VGND sg13cmos5l_decap_4
X_10374_ _10374_/Y _11727_/Q _10166_/B _10323_/Y VPWR VGND sg13cmos5l_o21ai_1
XFILLER_6_0 VPWR VGND sg13cmos5l_decap_8
XFILLER_3_954 VPWR VGND sg13cmos5l_decap_4
XFILLER_3_976 VPWR VGND sg13cmos5l_decap_8
XFILLER_104_381 VPWR VGND sg13cmos5l_decap_8
XFILLER_49_72 VPWR VGND sg13cmos5l_decap_4
XFILLER_93_736 VPWR VGND sg13cmos5l_decap_4
Xfanout790 _10235_/B _11457_/Q VPWR VGND sg13cmos5l_buf_1
XFILLER_1_46 VPWR VGND sg13cmos5l_fill_2
XFILLER_1_35 VPWR VGND sg13cmos5l_decap_8
XFILLER_18_310 VPWR VGND sg13cmos5l_decap_8
XFILLER_46_641 VPWR VGND sg13cmos5l_decap_8
Xclkbuf_leaf_57_clk _11265_/CLK clkbuf_4_8_0_clk/X VPWR VGND sg13cmos5l_buf_8
XFILLER_19_877 VPWR VGND sg13cmos5l_fill_2
XFILLER_19_888 VPWR VGND sg13cmos5l_decap_8
X_11301__1600 _11301_/RESET_B VPWR VGND sg13cmos5l_tiehi
XFILLER_53_1002 VPWR VGND sg13cmos5l_fill_1
XFILLER_60_198 VPWR VGND sg13cmos5l_decap_8
XFILLER_14_582 VPWR VGND sg13cmos5l_decap_4
X_11759_ _11759_/Q _11767_/CLK _11759_/D _11759_/RESET_B VPWR VGND sg13cmos5l_dfrbpq_1
XFILLER_14_1019 VPWR VGND sg13cmos5l_decap_8
X_11334__1567 _11334_/RESET_B VPWR VGND sg13cmos5l_tiehi
X_08970_ _08970_/Y _11632_/Q _08973_/A VPWR VGND sg13cmos5l_xnor2_1
X_07921_ _11050_/D _08313_/A1 _07978_/B _07920_/Y VPWR VGND sg13cmos5l_o21ai_1
Xhold2606 _10180_/A _11726_/Q VPWR VGND sg13cmos5l_dlygate4sd3_1
Xhold2628 _07079_/A _11682_/Q VPWR VGND sg13cmos5l_dlygate4sd3_1
Xhold2617 _07083_/A _11683_/Q VPWR VGND sg13cmos5l_dlygate4sd3_1
XFILLER_39_0 VPWR VGND sg13cmos5l_fill_1
XFILLER_96_574 VPWR VGND sg13cmos5l_fill_1
XFILLER_96_563 VPWR VGND sg13cmos5l_fill_1
X_07852_ _08049_/B _08376_/B _08376_/A VPWR VGND sg13cmos5l_nor2b_1
Xhold1905 _11588_/D _10775_/Y VPWR VGND sg13cmos5l_dlygate4sd3_1
Xhold2639 _10831_/D _07177_/Y VPWR VGND sg13cmos5l_dlygate4sd3_1
Xhold1916 _07956_/A _11068_/Q VPWR VGND sg13cmos5l_dlygate4sd3_1
Xhold1927 _07802_/A _10993_/Q VPWR VGND sg13cmos5l_dlygate4sd3_1
Xinput1 input1/X rst_n VPWR VGND sg13cmos5l_buf_1
X_06803_ _06803_/Y _06803_/A _10763_/S VPWR VGND sg13cmos5l_nand2_1
XFILLER_84_736 VPWR VGND sg13cmos5l_fill_1
XFILLER_83_202 VPWR VGND sg13cmos5l_fill_2
Xhold1949 _08104_/A _11141_/Q VPWR VGND sg13cmos5l_dlygate4sd3_1
Xhold1938 _08460_/A _11315_/Q VPWR VGND sg13cmos5l_dlygate4sd3_1
X_07783_ _10984_/D fanout51/X _07784_/B _07782_/Y VPWR VGND sg13cmos5l_a21oi_1
Xclkbuf_leaf_48_clk clkload43/A clkload4/A VPWR VGND sg13cmos5l_buf_8
X_09522_ _09522_/Y _11125_/Q _09630_/B _09605_/B1 VPWR VGND sg13cmos5l_a21oi_1
XFILLER_37_663 VPWR VGND sg13cmos5l_fill_1
XFILLER_36_151 VPWR VGND sg13cmos5l_decap_8
X_06734_ _06735_/C _10270_/A _06665_/B _06733_/Y VPWR VGND sg13cmos5l_a21oi_1
XFILLER_101_14 VPWR VGND sg13cmos5l_decap_8
XFILLER_64_493 VPWR VGND sg13cmos5l_decap_8
X_09453_ _09453_/X _09453_/A _09453_/B VPWR VGND sg13cmos5l_or2_1
X_06665_ _06665_/Y _06362_/A _06665_/B VPWR VGND sg13cmos5l_nand2b_1
XFILLER_25_836 VPWR VGND sg13cmos5l_fill_2
XFILLER_51_132 VPWR VGND sg13cmos5l_decap_8
X_08404_ _11287_/D _08534_/A1 _08403_/B _08403_/Y VPWR VGND sg13cmos5l_a21oi_1
XFILLER_12_508 VPWR VGND sg13cmos5l_decap_8
XFILLER_24_357 VPWR VGND sg13cmos5l_decap_8
X_09384_ _11461_/D _06274_/B _09460_/A _09357_/Y _09383_/Y VPWR VGND sg13cmos5l_a22oi_1
XFILLER_51_198 VPWR VGND sg13cmos5l_decap_8
X_06596_ _06597_/B _06639_/A _06280_/Y _06595_/Y VPWR VGND sg13cmos5l_a21oi_1
X_08335_ _11253_/D _08530_/A1 _08358_/B _08334_/Y VPWR VGND sg13cmos5l_o21ai_1
X_08266_ _11219_/D _08331_/A1 _08263_/B _08265_/Y VPWR VGND sg13cmos5l_a21oi_1
X_07217_ _07217_/Y _08889_/A hold2710/X _07227_/B1 _06779_/D _07225_/C1 VPWR VGND
+ sg13cmos5l_a221oi_1
X_08197_ _11185_/D _08457_/A1 _08218_/B _08196_/Y VPWR VGND sg13cmos5l_o21ai_1
XFILLER_20_596 VPWR VGND sg13cmos5l_decap_8
XFILLER_106_602 VPWR VGND sg13cmos5l_decap_8
X_07148_ _11739_/D _05883_/Y _07148_/A2 _07147_/Y VPWR VGND sg13cmos5l_a21oi_1
XFILLER_10_11 VPWR VGND sg13cmos5l_decap_8
XFILLER_4_718 VPWR VGND sg13cmos5l_fill_1
XFILLER_105_112 VPWR VGND sg13cmos5l_decap_8
XFILLER_106_679 VPWR VGND sg13cmos5l_decap_8
X_07079_ _07079_/Y _07079_/A _07389_/B VPWR VGND sg13cmos5l_nor2_1
XFILLER_10_88 VPWR VGND sg13cmos5l_decap_4
XFILLER_105_189 VPWR VGND sg13cmos5l_decap_8
XFILLER_0_957 VPWR VGND sg13cmos5l_decap_8
X_10090_ _10090_/Y _10356_/A1 _09534_/B _10089_/Y VPWR VGND sg13cmos5l_a21oi_1
XFILLER_48_906 VPWR VGND sg13cmos5l_decap_8
XFILLER_75_714 VPWR VGND sg13cmos5l_fill_2
XFILLER_19_107 VPWR VGND sg13cmos5l_fill_2
XFILLER_19_118 VPWR VGND sg13cmos5l_fill_1
Xclkbuf_leaf_39_clk clkload52/A clkbuf_4_14_0_clk/X VPWR VGND sg13cmos5l_buf_8
XFILLER_74_224 VPWR VGND sg13cmos5l_decap_4
XFILLER_19_97 VPWR VGND sg13cmos5l_fill_1
XFILLER_28_652 VPWR VGND sg13cmos5l_fill_2
X_10992_ _10992_/Q _11671_/CLK _10992_/D _10992_/RESET_B VPWR VGND sg13cmos5l_dfrbpq_1
XFILLER_71_942 VPWR VGND sg13cmos5l_fill_1
XFILLER_42_121 VPWR VGND sg13cmos5l_fill_1
X_11613_ _11613_/Q clkload29/A _11613_/D _11613_/RESET_B VPWR VGND sg13cmos5l_dfrbpq_1
XFILLER_42_165 VPWR VGND sg13cmos5l_decap_4
XFILLER_30_349 VPWR VGND sg13cmos5l_fill_1
X_11544_ _11544_/Q clkload47/A _11544_/D _11544_/RESET_B VPWR VGND sg13cmos5l_dfrbpq_1
XFILLER_51_51 VPWR VGND sg13cmos5l_decap_4
X_11475_ _11475_/Q clkload36/A _11475_/D _11475_/RESET_B VPWR VGND sg13cmos5l_dfrbpq_1
XFILLER_7_567 VPWR VGND sg13cmos5l_fill_1
X_10426_ _10427_/D _10426_/A1 _06229_/B _10426_/B1 _10433_/A _10423_/Y VPWR VGND sg13cmos5l_a221oi_1
X_10357_ _10357_/Y _05879_/A _10414_/A2 _07067_/B VPWR VGND sg13cmos5l_a21oi_1
X_10288_ _10307_/B _10288_/A _10288_/B VPWR VGND sg13cmos5l_xnor2_1
XFILLER_2_261 VPWR VGND sg13cmos5l_fill_2
XFILLER_2_283 VPWR VGND sg13cmos5l_fill_2
XFILLER_39_906 VPWR VGND sg13cmos5l_decap_4
XFILLER_78_596 VPWR VGND sg13cmos5l_decap_8
XFILLER_66_725 VPWR VGND sg13cmos5l_decap_8
XFILLER_38_416 VPWR VGND sg13cmos5l_fill_2
XFILLER_65_235 VPWR VGND sg13cmos5l_fill_1
XFILLER_93_577 VPWR VGND sg13cmos5l_decap_8
XFILLER_65_279 VPWR VGND sg13cmos5l_fill_2
XFILLER_46_471 VPWR VGND sg13cmos5l_decap_4
X_06450_ _06452_/B _11633_/Q _10161_/B VPWR VGND sg13cmos5l_nand2b_1
XFILLER_34_666 VPWR VGND sg13cmos5l_decap_8
XFILLER_34_677 VPWR VGND sg13cmos5l_decap_4
X_06381_ _06382_/C _06374_/B _06379_/Y _06380_/Y VPWR VGND sg13cmos5l_o21ai_1
X_08120_ _11147_/D _08510_/A1 _08169_/B _08119_/Y VPWR VGND sg13cmos5l_a21oi_1
XFILLER_30_861 VPWR VGND sg13cmos5l_decap_4
XFILLER_30_883 VPWR VGND sg13cmos5l_decap_8
X_08051_ _11114_/D _08313_/A1 _08102_/B _08050_/Y VPWR VGND sg13cmos5l_o21ai_1
X_07002_ _07002_/Y _11502_/Q _07006_/A _07006_/B _11494_/Q VPWR VGND sg13cmos5l_a22oi_1
XFILLER_103_616 VPWR VGND sg13cmos5l_decap_8
XFILLER_0_209 VPWR VGND sg13cmos5l_fill_2
XFILLER_102_126 VPWR VGND sg13cmos5l_decap_8
Xhold2403 _08437_/A _11304_/Q VPWR VGND sg13cmos5l_dlygate4sd3_1
X_08953_ _08953_/Y _08954_/B _08953_/B VPWR VGND sg13cmos5l_nand2_1
X_07904_ _11042_/D fanout64/X _07911_/B _07903_/Y VPWR VGND sg13cmos5l_a21oi_1
XFILLER_69_552 VPWR VGND sg13cmos5l_fill_1
Xhold2414 _08846_/A _11431_/Q VPWR VGND sg13cmos5l_dlygate4sd3_1
Xhold2436 _07287_/A _10865_/Q VPWR VGND sg13cmos5l_dlygate4sd3_1
Xhold2425 _10871_/D _07324_/Y VPWR VGND sg13cmos5l_dlygate4sd3_1
Xhold2447 _06800_/A _11600_/Q VPWR VGND sg13cmos5l_dlygate4sd3_1
Xhold2458 _11623_/D _06866_/Y VPWR VGND sg13cmos5l_dlygate4sd3_1
XFILLER_69_574 VPWR VGND sg13cmos5l_fill_1
XFILLER_56_202 VPWR VGND sg13cmos5l_fill_1
X_08884_ _08906_/A _11633_/Q _08891_/A VPWR VGND sg13cmos5l_xnor2_1
Xhold2469 _08259_/A _11216_/Q VPWR VGND sg13cmos5l_dlygate4sd3_1
X_07835_ _11009_/D fanout67/X _07834_/B _07834_/Y VPWR VGND sg13cmos5l_o21ai_1
XFILLER_29_449 VPWR VGND sg13cmos5l_decap_8
X_07766_ _07766_/Y _07766_/A _07770_/B VPWR VGND sg13cmos5l_nor2_1
XFILLER_37_460 VPWR VGND sg13cmos5l_fill_1
XFILLER_25_622 VPWR VGND sg13cmos5l_fill_2
X_06717_ _06717_/Y _06713_/A _06710_/Y _06311_/Y VPWR VGND sg13cmos5l_o21ai_1
X_09505_ _09506_/B _09643_/A _09721_/B VPWR VGND sg13cmos5l_nand2_1
X_07697_ _10942_/D fanout76/X _07718_/B _07696_/Y VPWR VGND sg13cmos5l_a21oi_1
XFILLER_80_761 VPWR VGND sg13cmos5l_fill_1
XFILLER_53_964 VPWR VGND sg13cmos5l_fill_2
XFILLER_40_603 VPWR VGND sg13cmos5l_fill_2
X_09436_ _09436_/Y _09460_/A _09436_/B _09436_/C VPWR VGND sg13cmos5l_nor3_1
XFILLER_80_783 VPWR VGND sg13cmos5l_fill_2
XFILLER_80_772 VPWR VGND sg13cmos5l_fill_1
X_11702__1262 _11702_/RESET_B VPWR VGND sg13cmos5l_tiehi
XFILLER_52_496 VPWR VGND sg13cmos5l_decap_8
XFILLER_52_474 VPWR VGND sg13cmos5l_fill_2
XFILLER_40_614 VPWR VGND sg13cmos5l_fill_1
X_06648_ _06649_/B _06662_/A _06355_/Y _06647_/Y VPWR VGND sg13cmos5l_o21ai_1
X_06579_ _06580_/B hold2782/X _10691_/D _06401_/B _06187_/Y _06577_/Y VPWR VGND sg13cmos5l_a221oi_1
X_09367_ _09368_/C _09363_/Y _09364_/Y _09365_/Y _09366_/Y _06474_/A VPWR VGND sg13cmos5l_a221oi_1
X_09298_ _09298_/Y _09298_/A _09298_/B _09303_/D VPWR VGND sg13cmos5l_nor3_1
X_11395__1500 _11395_/RESET_B VPWR VGND sg13cmos5l_tiehi
X_08318_ _08318_/Y _08318_/A _08328_/B VPWR VGND sg13cmos5l_nand2_1
XFILLER_21_861 VPWR VGND sg13cmos5l_decap_8
X_08249_ _08249_/Y _08249_/A _08299_/B VPWR VGND sg13cmos5l_nor2_1
XFILLER_4_515 VPWR VGND sg13cmos5l_fill_2
XFILLER_97_14 VPWR VGND sg13cmos5l_decap_8
XFILLER_4_526 VPWR VGND sg13cmos5l_fill_1
X_11260_ _11260_/Q _11356_/CLK _11260_/D _11260_/RESET_B VPWR VGND sg13cmos5l_dfrbpq_1
XFILLER_21_87 VPWR VGND sg13cmos5l_fill_1
XFILLER_106_476 VPWR VGND sg13cmos5l_decap_8
X_10211_ _10212_/C _11397_/Q _10834_/Q VPWR VGND sg13cmos5l_and2_1
X_11191_ _11191_/Q clkload9/A _11191_/D _11191_/RESET_B VPWR VGND sg13cmos5l_dfrbpq_1
X_10142_ _10142_/Y _10140_/Y _10141_/Y _10139_/Y VPWR VGND sg13cmos5l_o21ai_1
XFILLER_0_765 VPWR VGND sg13cmos5l_fill_2
X_10073_ _10073_/Y _10073_/A _10073_/B VPWR VGND sg13cmos5l_nand2_1
XFILLER_47_235 VPWR VGND sg13cmos5l_decap_4
XFILLER_63_728 VPWR VGND sg13cmos5l_decap_8
XFILLER_90_536 VPWR VGND sg13cmos5l_decap_8
XFILLER_62_227 VPWR VGND sg13cmos5l_fill_2
X_10975_ _10975_/Q clkload58/A _10975_/D _10975_/RESET_B VPWR VGND sg13cmos5l_dfrbpq_1
XFILLER_90_558 VPWR VGND sg13cmos5l_fill_1
XFILLER_44_953 VPWR VGND sg13cmos5l_fill_1
X_10962__1020 _10962_/RESET_B VPWR VGND sg13cmos5l_tiehi
X_11752__913 _11752_/RESET_B VPWR VGND sg13cmos5l_tiehi
XFILLER_31_636 VPWR VGND sg13cmos5l_decap_4
XFILLER_31_669 VPWR VGND sg13cmos5l_decap_4
XFILLER_30_179 VPWR VGND sg13cmos5l_fill_1
X_11527_ _11527_/Q _11528_/CLK _11527_/D _11527_/RESET_B VPWR VGND sg13cmos5l_dfrbpq_1
XFILLER_11_360 VPWR VGND sg13cmos5l_decap_8
XFILLER_11_371 VPWR VGND sg13cmos5l_fill_2
XFILLER_11_382 VPWR VGND sg13cmos5l_decap_8
X_11251__1650 _11251_/RESET_B VPWR VGND sg13cmos5l_tiehi
X_11458_ _11458_/Q clkload18/A _11458_/D _11458_/RESET_B VPWR VGND sg13cmos5l_dfrbpq_1
X_11545__1483 _11545_/RESET_B VPWR VGND sg13cmos5l_tiehi
X_11389_ _11389_/Q clkload36/A _11389_/D _11389_/RESET_B VPWR VGND sg13cmos5l_dfrbpq_1
X_10409_ _10409_/Y _09611_/A _10495_/A2 _10402_/X _10537_/A _10508_/B1 VPWR VGND sg13cmos5l_a221oi_1
XFILLER_98_636 VPWR VGND sg13cmos5l_decap_4
XFILLER_97_124 VPWR VGND sg13cmos5l_decap_8
XFILLER_100_608 VPWR VGND sg13cmos5l_fill_2
XFILLER_85_308 VPWR VGND sg13cmos5l_decap_8
X_05950_ _05950_/Y _10794_/Q VPWR VGND sg13cmos5l_inv_1
XFILLER_39_725 VPWR VGND sg13cmos5l_decap_4
X_05881_ _05881_/Y input17/X VPWR VGND sg13cmos5l_inv_1
XFILLER_39_769 VPWR VGND sg13cmos5l_decap_8
XFILLER_81_503 VPWR VGND sg13cmos5l_fill_1
X_07620_ _07620_/Y _07638_/A _08750_/B _07623_/B _07619_/Y VPWR VGND sg13cmos5l_a22oi_1
XFILLER_66_577 VPWR VGND sg13cmos5l_decap_8
XFILLER_53_205 VPWR VGND sg13cmos5l_decap_4
XFILLER_93_385 VPWR VGND sg13cmos5l_fill_2
X_07551_ _07551_/X _10477_/A _07562_/D VPWR VGND sg13cmos5l_xor2_1
X_06502_ _06502_/Y _06495_/Y _06497_/Y _06501_/Y _09579_/B2 VPWR VGND sg13cmos5l_a22oi_1
XFILLER_34_430 VPWR VGND sg13cmos5l_fill_1
XFILLER_34_441 VPWR VGND sg13cmos5l_decap_8
X_07482_ _07482_/Y _07482_/A _07482_/B VPWR VGND sg13cmos5l_nor2_1
X_06433_ _06434_/B _06760_/S _06430_/Y _06432_/X VPWR VGND sg13cmos5l_a21oi_1
XFILLER_21_124 VPWR VGND sg13cmos5l_fill_1
X_09221_ _09225_/B _09480_/A _10842_/Q VPWR VGND sg13cmos5l_nor2_1
X_09152_ _09152_/Y _09151_/A _09151_/B _09153_/A1 VPWR VGND sg13cmos5l_a21oi_1
X_06364_ _06364_/Y _06364_/A VPWR VGND sg13cmos5l_inv_1
XFILLER_21_168 VPWR VGND sg13cmos5l_decap_4
X_08103_ _11140_/D fanout60/X _08102_/B _08102_/Y VPWR VGND sg13cmos5l_o21ai_1
X_09083_ _11448_/D hold2551/X _09093_/B _09082_/Y VPWR VGND sg13cmos5l_a21o_1
X_06295_ _06646_/A _06642_/A _06294_/Y _06293_/Y VPWR VGND sg13cmos5l_o21ai_1
X_08034_ _11106_/D fanout64/X _08033_/B _08033_/Y VPWR VGND sg13cmos5l_a21oi_1
X_11383__1515 _11383_/RESET_B VPWR VGND sg13cmos5l_tiehi
XFILLER_104_936 VPWR VGND sg13cmos5l_decap_8
XFILLER_27_1018 VPWR VGND sg13cmos5l_fill_2
Xhold2211 _07722_/A _10954_/Q VPWR VGND sg13cmos5l_dlygate4sd3_1
Xhold2200 _08295_/A _11234_/Q VPWR VGND sg13cmos5l_dlygate4sd3_1
X_09985_ _09985_/Y _11142_/Q _09986_/B _09990_/S1 VPWR VGND sg13cmos5l_a21oi_1
X_11114__1787 _11114_/RESET_B VPWR VGND sg13cmos5l_tiehi
Xhold2222 _08417_/A _11294_/Q VPWR VGND sg13cmos5l_dlygate4sd3_1
X_08936_ _08936_/Y _08936_/A _08936_/B VPWR VGND sg13cmos5l_nand2_1
Xhold2233 _08543_/A _11356_/Q VPWR VGND sg13cmos5l_dlygate4sd3_1
Xhold2244 _08017_/A _11098_/Q VPWR VGND sg13cmos5l_dlygate4sd3_1
Xhold2255 _08535_/A _11352_/Q VPWR VGND sg13cmos5l_dlygate4sd3_1
XFILLER_85_842 VPWR VGND sg13cmos5l_fill_2
XFILLER_57_533 VPWR VGND sg13cmos5l_decap_4
X_08867_ _08867_/Y _08867_/A _08867_/B VPWR VGND sg13cmos5l_nor2_1
Xhold2266 _08811_/A _11428_/Q VPWR VGND sg13cmos5l_dlygate4sd3_1
Xhold2288 _07901_/A _11041_/Q VPWR VGND sg13cmos5l_dlygate4sd3_1
Xhold2277 _08277_/A _11225_/Q VPWR VGND sg13cmos5l_dlygate4sd3_1
Xhold2299 _08439_/A _11305_/Q VPWR VGND sg13cmos5l_dlygate4sd3_1
XFILLER_84_363 VPWR VGND sg13cmos5l_fill_1
XFILLER_84_341 VPWR VGND sg13cmos5l_decap_8
XFILLER_57_577 VPWR VGND sg13cmos5l_decap_8
X_07818_ _07818_/Y _07818_/A _07826_/B VPWR VGND sg13cmos5l_nand2_1
X_08798_ _08798_/Y _08819_/A _08795_/Y _08797_/Y VPWR VGND sg13cmos5l_a21oi_1
XFILLER_44_238 VPWR VGND sg13cmos5l_decap_4
X_11293__1608 _11293_/RESET_B VPWR VGND sg13cmos5l_tiehi
XFILLER_26_942 VPWR VGND sg13cmos5l_decap_8
X_07749_ _10967_/D _08534_/A1 _07748_/B _07748_/Y VPWR VGND sg13cmos5l_a21oi_1
X_10760_ _10760_/X _11690_/Q hold2577/X _10760_/S VPWR VGND sg13cmos5l_mux2_1
XFILLER_12_102 VPWR VGND sg13cmos5l_fill_2
XFILLER_25_463 VPWR VGND sg13cmos5l_decap_8
X_10691_ _10691_/Y _10703_/A _10691_/B _10691_/C _10691_/D VPWR VGND sg13cmos5l_nand4_1
X_09419_ _09419_/Y _11057_/Q _09419_/B VPWR VGND sg13cmos5l_nand2_1
XFILLER_40_466 VPWR VGND sg13cmos5l_decap_8
XFILLER_9_629 VPWR VGND sg13cmos5l_decap_4
XFILLER_5_835 VPWR VGND sg13cmos5l_fill_2
XFILLER_10_1011 VPWR VGND sg13cmos5l_decap_8
X_11312_ _11312_/Q _11671_/CLK _11312_/D _11312_/RESET_B VPWR VGND sg13cmos5l_dfrbpq_1
X_10801__938 _10801_/RESET_B VPWR VGND sg13cmos5l_tiehi
XFILLER_106_0 VPWR VGND sg13cmos5l_decap_8
X_11243_ _11243_/Q _11339_/CLK _11243_/D _11243_/RESET_B VPWR VGND sg13cmos5l_dfrbpq_1
XFILLER_4_345 VPWR VGND sg13cmos5l_decap_8
XFILLER_106_273 VPWR VGND sg13cmos5l_decap_8
XFILLER_79_102 VPWR VGND sg13cmos5l_fill_1
XFILLER_4_389 VPWR VGND sg13cmos5l_fill_2
X_11174_ _11174_/Q _11362_/CLK _11174_/D _11174_/RESET_B VPWR VGND sg13cmos5l_dfrbpq_1
XFILLER_68_809 VPWR VGND sg13cmos5l_decap_4
X_10125_ _10125_/Y _10268_/A _10135_/B VPWR VGND sg13cmos5l_nand2_1
XFILLER_48_511 VPWR VGND sg13cmos5l_decap_8
X_10056_ _11486_/D _09940_/A _09915_/A _10033_/Y _10055_/Y VPWR VGND sg13cmos5l_a22oi_1
XFILLER_76_831 VPWR VGND sg13cmos5l_decap_4
XFILLER_76_875 VPWR VGND sg13cmos5l_decap_8
XFILLER_36_706 VPWR VGND sg13cmos5l_decap_8
XFILLER_91_856 VPWR VGND sg13cmos5l_fill_1
X_11269__1632 _11269_/RESET_B VPWR VGND sg13cmos5l_tiehi
X_10903__1079 _10903_/RESET_B VPWR VGND sg13cmos5l_tiehi
X_10958_ _10958_/Q clkload34/A _10958_/D _10958_/RESET_B VPWR VGND sg13cmos5l_dfrbpq_1
XFILLER_31_466 VPWR VGND sg13cmos5l_fill_2
X_10889_ _10889_/Q clkload12/A _10889_/D _10889_/RESET_B VPWR VGND sg13cmos5l_dfrbpq_1
XFILLER_78_4 VPWR VGND sg13cmos5l_fill_2
XFILLER_8_651 VPWR VGND sg13cmos5l_decap_8
X_06080_ _06080_/Y _10713_/A _06092_/A _06080_/C VPWR VGND sg13cmos5l_nand3_1
Xfanout608 _09106_/B1 _08772_/B2 VPWR VGND sg13cmos5l_buf_1
Xfanout619 _08615_/A _07093_/B VPWR VGND sg13cmos5l_buf_1
XFILLER_98_477 VPWR VGND sg13cmos5l_fill_2
X_09770_ _09770_/Y _11358_/Q _09814_/S _10035_/B1 _09769_/Y VPWR VGND sg13cmos5l_a22oi_1
X_06982_ _06982_/Y _11497_/Q _07072_/B _06982_/B1 _11489_/Q VPWR VGND sg13cmos5l_a22oi_1
XFILLER_39_511 VPWR VGND sg13cmos5l_decap_8
XFILLER_21_0 VPWR VGND sg13cmos5l_decap_8
X_05933_ _05933_/Y _10751_/A VPWR VGND sg13cmos5l_inv_1
XFILLER_67_853 VPWR VGND sg13cmos5l_fill_2
X_08721_ _08722_/B _08721_/A _08721_/B VPWR VGND sg13cmos5l_nand2_1
X_08652_ _08653_/B _08694_/A _08652_/B VPWR VGND sg13cmos5l_and2_1
XFILLER_94_683 VPWR VGND sg13cmos5l_decap_4
XFILLER_93_182 VPWR VGND sg13cmos5l_decap_8
X_05864_ _07623_/A _11419_/Q VPWR VGND sg13cmos5l_inv_1
X_07603_ _07617_/C _07604_/A _07604_/B VPWR VGND sg13cmos5l_nor2_1
XFILLER_26_205 VPWR VGND sg13cmos5l_decap_8
X_11501__1181 _11501_/RESET_B VPWR VGND sg13cmos5l_tiehi
X_08583_ _08584_/C _08580_/Y _08581_/Y _08582_/Y VPWR VGND sg13cmos5l_a21oi_1
XFILLER_82_889 VPWR VGND sg13cmos5l_decap_4
XFILLER_42_709 VPWR VGND sg13cmos5l_decap_8
XFILLER_26_238 VPWR VGND sg13cmos5l_decap_4
XFILLER_81_399 VPWR VGND sg13cmos5l_fill_2
X_11455__1362 _11455_/RESET_B VPWR VGND sg13cmos5l_tiehi
X_07534_ _07543_/B _11406_/Q _11405_/Q _07542_/D VPWR VGND sg13cmos5l_nand3_1
X_07465_ _07471_/B _11396_/Q _10191_/A _07472_/D VPWR VGND sg13cmos5l_and3_1
XFILLER_23_945 VPWR VGND sg13cmos5l_decap_8
X_06416_ _06416_/Y _10642_/A _06416_/B VPWR VGND sg13cmos5l_xnor2_1
XFILLER_50_764 VPWR VGND sg13cmos5l_decap_8
X_09204_ _09208_/B _09205_/A _10838_/Q VPWR VGND sg13cmos5l_nor2_1
X_07396_ _10883_/D _07401_/B _07394_/Y _07395_/Y VPWR VGND sg13cmos5l_a21oi_1
XFILLER_10_628 VPWR VGND sg13cmos5l_fill_2
XFILLER_22_499 VPWR VGND sg13cmos5l_decap_8
X_09135_ _09137_/B _09138_/B _09136_/B VPWR VGND sg13cmos5l_nor2_1
X_06347_ _06603_/C _06591_/A _06346_/X _06204_/B VPWR VGND sg13cmos5l_a21oi_1
X_09066_ _09118_/C _09066_/A _09066_/B VPWR VGND sg13cmos5l_nor2_1
X_06278_ _06278_/Y _11488_/Q _07077_/A VPWR VGND sg13cmos5l_nor2b_1
X_08017_ _08017_/Y _08017_/A _08023_/B VPWR VGND sg13cmos5l_nor2_1
XFILLER_78_38 VPWR VGND sg13cmos5l_decap_8
XFILLER_2_849 VPWR VGND sg13cmos5l_decap_8
XFILLER_103_210 VPWR VGND sg13cmos5l_decap_8
X_11347__1554 _11347_/RESET_B VPWR VGND sg13cmos5l_tiehi
XFILLER_104_799 VPWR VGND sg13cmos5l_fill_1
XFILLER_77_639 VPWR VGND sg13cmos5l_decap_8
X_09968_ _09968_/Y _09968_/A _09968_/B VPWR VGND sg13cmos5l_nor2_1
Xhold2030 _08858_/A _11432_/Q VPWR VGND sg13cmos5l_dlygate4sd3_1
Xhold2041 _07920_/A _11050_/Q VPWR VGND sg13cmos5l_dlygate4sd3_1
Xhold2063 _08312_/A _11242_/Q VPWR VGND sg13cmos5l_dlygate4sd3_1
X_08919_ _08919_/Y _10719_/B _08918_/Y _10719_/C VPWR VGND sg13cmos5l_a21oi_1
Xhold2052 _07030_/A _11669_/Q VPWR VGND sg13cmos5l_dlygate4sd3_1
XFILLER_92_609 VPWR VGND sg13cmos5l_decap_8
X_09899_ _09899_/X _11139_/Q _11107_/Q _11075_/Q _11043_/Q _09814_/S _10035_/B1 VPWR
+ VGND sg13cmos5l_mux4_1
XFILLER_85_650 VPWR VGND sg13cmos5l_decap_4
Xhold2085 _06806_/A _11602_/Q VPWR VGND sg13cmos5l_dlygate4sd3_1
XFILLER_57_352 VPWR VGND sg13cmos5l_decap_8
XFILLER_40_1026 VPWR VGND sg13cmos5l_fill_2
Xhold2096 _07666_/A _10927_/Q VPWR VGND sg13cmos5l_dlygate4sd3_1
Xhold2074 _07010_/A _11664_/Q VPWR VGND sg13cmos5l_dlygate4sd3_1
XFILLER_85_683 VPWR VGND sg13cmos5l_decap_8
XFILLER_73_845 VPWR VGND sg13cmos5l_decap_4
XFILLER_72_300 VPWR VGND sg13cmos5l_fill_2
XFILLER_57_385 VPWR VGND sg13cmos5l_fill_2
XFILLER_18_739 VPWR VGND sg13cmos5l_fill_2
X_10812_ _10812_/Q clkload39/A _10812_/D _10812_/RESET_B VPWR VGND sg13cmos5l_dfrbpq_1
XFILLER_26_761 VPWR VGND sg13cmos5l_decap_4
X_10743_ _10743_/Y _10744_/B _10751_/B _10749_/A VPWR VGND sg13cmos5l_o21ai_1
XFILLER_43_63 VPWR VGND sg13cmos5l_fill_2
XFILLER_40_241 VPWR VGND sg13cmos5l_decap_4
X_10674_ _10674_/Y hold2814/X _10656_/B _10673_/Y _10681_/B2 _10168_/B VPWR VGND sg13cmos5l_a221oi_1
XFILLER_4_186 VPWR VGND sg13cmos5l_decap_4
XFILLER_4_46 VPWR VGND sg13cmos5l_fill_2
X_11226_ _11226_/Q _11361_/CLK _11226_/D _11226_/RESET_B VPWR VGND sg13cmos5l_dfrbpq_1
XFILLER_95_403 VPWR VGND sg13cmos5l_fill_2
X_11157_ _11157_/Q clkload40/A _11157_/D _11157_/RESET_B VPWR VGND sg13cmos5l_dfrbpq_1
XFILLER_67_138 VPWR VGND sg13cmos5l_decap_8
XFILLER_49_842 VPWR VGND sg13cmos5l_fill_2
XFILLER_49_831 VPWR VGND sg13cmos5l_decap_4
X_10108_ _10108_/Y _10526_/A _09694_/B _10107_/Y VPWR VGND sg13cmos5l_a21oi_1
X_11661__1303 _11661_/RESET_B VPWR VGND sg13cmos5l_tiehi
X_11088_ _11088_/Q clkload8/A _11088_/D _11088_/RESET_B VPWR VGND sg13cmos5l_dfrbpq_1
X_10039_ _10039_/Y _11016_/Q _10039_/B VPWR VGND sg13cmos5l_nand2_1
XFILLER_76_683 VPWR VGND sg13cmos5l_decap_4
XFILLER_75_160 VPWR VGND sg13cmos5l_decap_8
XFILLER_64_823 VPWR VGND sg13cmos5l_decap_4
XFILLER_84_70 VPWR VGND sg13cmos5l_decap_4
XFILLER_64_856 VPWR VGND sg13cmos5l_fill_1
XFILLER_36_558 VPWR VGND sg13cmos5l_decap_8
XFILLER_24_709 VPWR VGND sg13cmos5l_decap_8
XFILLER_16_260 VPWR VGND sg13cmos5l_decap_4
XFILLER_17_1028 VPWR VGND sg13cmos5l_fill_1
XFILLER_31_230 VPWR VGND sg13cmos5l_fill_2
XFILLER_31_241 VPWR VGND sg13cmos5l_decap_8
XFILLER_32_753 VPWR VGND sg13cmos5l_decap_4
X_07250_ _10859_/D _07250_/A _07250_/B VPWR VGND sg13cmos5l_nand2_1
XFILLER_20_959 VPWR VGND sg13cmos5l_decap_4
XFILLER_32_786 VPWR VGND sg13cmos5l_decap_8
X_10823__960 _10823_/RESET_B VPWR VGND sg13cmos5l_tiehi
X_11745__1190 _11745_/RESET_B VPWR VGND sg13cmos5l_tiehi
X_07181_ _07181_/Y _07181_/A _07185_/B VPWR VGND sg13cmos5l_nand2_1
X_06201_ _06612_/A _06618_/B _06201_/B VPWR VGND sg13cmos5l_nor2_1
X_06132_ _06132_/X _06133_/A _06132_/B VPWR VGND sg13cmos5l_or2_1
XFILLER_99_720 VPWR VGND sg13cmos5l_decap_4
X_06063_ _06063_/Y _10694_/B _06062_/Y _06092_/B VPWR VGND sg13cmos5l_a21oi_1
XFILLER_98_230 VPWR VGND sg13cmos5l_fill_1
Xfanout405 _09495_/A1 _09573_/A1 VPWR VGND sg13cmos5l_buf_1
X_09822_ _09822_/Y _11296_/Q _09903_/B VPWR VGND sg13cmos5l_nor2_1
Xfanout416 _10021_/B1 _09791_/B1 VPWR VGND sg13cmos5l_buf_1
XFILLER_59_628 VPWR VGND sg13cmos5l_fill_1
Xfanout427 _09601_/B1 fanout432/X VPWR VGND sg13cmos5l_buf_1
Xfanout438 _09529_/B _09734_/B VPWR VGND sg13cmos5l_buf_1
Xfanout449 _09986_/B _10041_/B VPWR VGND sg13cmos5l_buf_1
XFILLER_86_447 VPWR VGND sg13cmos5l_decap_8
X_09753_ _09755_/B _09754_/A _09754_/B VPWR VGND sg13cmos5l_nor2_1
XFILLER_104_14 VPWR VGND sg13cmos5l_decap_8
XFILLER_86_469 VPWR VGND sg13cmos5l_fill_2
XFILLER_73_108 VPWR VGND sg13cmos5l_decap_4
XFILLER_58_149 VPWR VGND sg13cmos5l_decap_8
X_08704_ _08943_/B _07362_/B _07541_/B _07332_/Y VPWR VGND sg13cmos5l_o21ai_1
X_06965_ _06965_/Y _06965_/A _07026_/B VPWR VGND sg13cmos5l_nand2_1
X_06896_ _11704_/D hold2746/X _06905_/A _07091_/S VPWR VGND sg13cmos5l_mux2_1
X_09684_ _09684_/Y _10939_/Q _09957_/B VPWR VGND sg13cmos5l_nand2_1
X_05916_ _09454_/A _09583_/A VPWR VGND sg13cmos5l_inv_1
X_08635_ _11382_/D _11712_/D _07198_/B _08635_/S VPWR VGND sg13cmos5l_mux2_1
XFILLER_55_878 VPWR VGND sg13cmos5l_decap_8
XFILLER_54_333 VPWR VGND sg13cmos5l_decap_4
X_08566_ _11367_/D fanout53/X _08565_/B _08565_/Y VPWR VGND sg13cmos5l_a21oi_1
X_07517_ _07517_/Y _07517_/A _07517_/B VPWR VGND sg13cmos5l_nor2_1
Xfanout56 fanout56/X _07633_/Y VPWR VGND sg13cmos5l_buf_1
X_08497_ _11333_/D fanout58/X _08496_/B _08496_/Y VPWR VGND sg13cmos5l_o21ai_1
XFILLER_22_252 VPWR VGND sg13cmos5l_decap_8
XFILLER_23_753 VPWR VGND sg13cmos5l_fill_1
X_07448_ _07448_/X _07448_/A _08652_/B VPWR VGND sg13cmos5l_and2_1
Xfanout67 fanout67/X _07600_/Y VPWR VGND sg13cmos5l_buf_1
Xfanout78 fanout78/X _07571_/Y VPWR VGND sg13cmos5l_buf_1
Xfanout89 _09672_/A _09807_/A VPWR VGND sg13cmos5l_buf_1
X_07379_ _07379_/Y _11542_/Q _08750_/A VPWR VGND sg13cmos5l_nand2_1
XFILLER_13_44 VPWR VGND sg13cmos5l_decap_8
XFILLER_13_66 VPWR VGND sg13cmos5l_fill_1
X_09118_ _09136_/B _09118_/A _09127_/B _09118_/C _09118_/D VPWR VGND sg13cmos5l_and4_1
X_10390_ _10391_/C _10407_/A _10403_/B _10403_/C _10403_/D VPWR VGND sg13cmos5l_nand4_1
X_09049_ _09049_/Y _09069_/C _09047_/Y _09048_/Y VPWR VGND sg13cmos5l_a21oi_1
XFILLER_78_904 VPWR VGND sg13cmos5l_fill_1
XFILLER_8_4 VPWR VGND sg13cmos5l_decap_8
XFILLER_2_657 VPWR VGND sg13cmos5l_decap_8
XFILLER_104_552 VPWR VGND sg13cmos5l_decap_8
X_11011_ _11011_/Q clkload46/A _11011_/D _11011_/RESET_B VPWR VGND sg13cmos5l_dfrbpq_1
XFILLER_89_252 VPWR VGND sg13cmos5l_decap_4
XFILLER_78_948 VPWR VGND sg13cmos5l_fill_2
XFILLER_49_149 VPWR VGND sg13cmos5l_decap_8
XFILLER_73_620 VPWR VGND sg13cmos5l_fill_2
XFILLER_58_694 VPWR VGND sg13cmos5l_decap_8
XFILLER_58_672 VPWR VGND sg13cmos5l_decap_8
XFILLER_38_85 VPWR VGND sg13cmos5l_decap_8
XFILLER_18_514 VPWR VGND sg13cmos5l_fill_1
XFILLER_85_491 VPWR VGND sg13cmos5l_fill_1
XFILLER_45_333 VPWR VGND sg13cmos5l_fill_2
XFILLER_45_322 VPWR VGND sg13cmos5l_decap_8
XFILLER_18_536 VPWR VGND sg13cmos5l_decap_8
XFILLER_18_547 VPWR VGND sg13cmos5l_fill_1
XFILLER_72_174 VPWR VGND sg13cmos5l_fill_1
XFILLER_54_95 VPWR VGND sg13cmos5l_fill_2
XFILLER_13_230 VPWR VGND sg13cmos5l_fill_1
X_10726_ _10726_/Y _10726_/A _10726_/B VPWR VGND sg13cmos5l_nand2_1
XFILLER_13_274 VPWR VGND sg13cmos5l_decap_4
X_10807__944 _10807_/RESET_B VPWR VGND sg13cmos5l_tiehi
X_10657_ _10658_/B _10642_/A _10642_/B _06252_/A VPWR VGND sg13cmos5l_a21o_1
XFILLER_13_296 VPWR VGND sg13cmos5l_decap_8
Xclkload26 clkload26/X clkload26/A VPWR VGND sg13cmos5l_buf_8
Xclkload15 clkload15/X clkload15/A VPWR VGND sg13cmos5l_buf_8
XFILLER_86_1004 VPWR VGND sg13cmos5l_fill_1
X_10588_ _11543_/D _10739_/A _10588_/B _10588_/C VPWR VGND sg13cmos5l_nor3_1
Xclkload48 clkload48/X clkload48/A VPWR VGND sg13cmos5l_buf_8
Xclkload37 clkload37/Y clkload37/A VPWR VGND sg13cmos5l_inv_1
X_11209_ _11209_/Q clkload50/A _11209_/D _11209_/RESET_B VPWR VGND sg13cmos5l_dfrbpq_1
XFILLER_69_937 VPWR VGND sg13cmos5l_decap_4
XFILLER_95_222 VPWR VGND sg13cmos5l_fill_1
XFILLER_69_948 VPWR VGND sg13cmos5l_fill_1
XFILLER_95_255 VPWR VGND sg13cmos5l_decap_8
XFILLER_68_458 VPWR VGND sg13cmos5l_decap_8
XFILLER_95_288 VPWR VGND sg13cmos5l_fill_2
XFILLER_49_672 VPWR VGND sg13cmos5l_fill_1
XFILLER_37_823 VPWR VGND sg13cmos5l_decap_8
XFILLER_37_812 VPWR VGND sg13cmos5l_fill_1
X_06750_ _06750_/Y _06752_/A _06758_/A2 _06758_/B1 _06748_/A _06749_/Y VPWR VGND sg13cmos5l_a221oi_1
X_11625__1342 _11625_/RESET_B VPWR VGND sg13cmos5l_tiehi
X_06681_ _06681_/Y _06681_/A _06681_/B VPWR VGND sg13cmos5l_xnor2_1
XFILLER_91_461 VPWR VGND sg13cmos5l_decap_4
X_08420_ _11295_/D fanout74/X _08429_/B _08419_/Y VPWR VGND sg13cmos5l_a21oi_1
XFILLER_63_152 VPWR VGND sg13cmos5l_decap_8
XFILLER_36_355 VPWR VGND sg13cmos5l_fill_2
XFILLER_63_185 VPWR VGND sg13cmos5l_fill_2
XFILLER_51_336 VPWR VGND sg13cmos5l_decap_4
X_08351_ _11261_/D fanout78/X _08350_/B _08350_/Y VPWR VGND sg13cmos5l_o21ai_1
X_08282_ _11227_/D fanout83/X _08281_/B _08281_/Y VPWR VGND sg13cmos5l_a21oi_1
X_07302_ _07302_/Y _08871_/A _07326_/B VPWR VGND sg13cmos5l_nand2_1
XFILLER_20_701 VPWR VGND sg13cmos5l_decap_4
XFILLER_32_572 VPWR VGND sg13cmos5l_fill_2
X_07233_ _07234_/B _10126_/B _07237_/A2 _07243_/B1 _07175_/A VPWR VGND sg13cmos5l_a22oi_1
Xclkload9 clkload9/Y clkload9/A VPWR VGND sg13cmos5l_inv_2
XFILLER_20_745 VPWR VGND sg13cmos5l_fill_2
X_07164_ _11747_/D _05874_/Y _07164_/A2 _07163_/Y VPWR VGND sg13cmos5l_a21oi_1
X_07095_ _11711_/D hold2680/X _07193_/A _07098_/B VPWR VGND sg13cmos5l_mux2_1
X_06115_ _11765_/D _06133_/B _06121_/B _06114_/Y VPWR VGND sg13cmos5l_a21o_1
XFILLER_105_349 VPWR VGND sg13cmos5l_decap_8
X_06046_ _06064_/B _06046_/A _06046_/B _06046_/C _06046_/D VPWR VGND sg13cmos5l_nand4_1
Xfanout213 _08171_/B _08179_/B VPWR VGND sg13cmos5l_buf_1
Xfanout202 _08301_/B _08309_/B VPWR VGND sg13cmos5l_buf_1
Xfanout224 _08041_/B _07984_/Y VPWR VGND sg13cmos5l_buf_1
Xfanout235 _07909_/B _07854_/Y VPWR VGND sg13cmos5l_buf_1
XFILLER_101_522 VPWR VGND sg13cmos5l_fill_1
Xfanout246 fanout246/X _07721_/Y VPWR VGND sg13cmos5l_buf_1
XFILLER_59_447 VPWR VGND sg13cmos5l_fill_2
XFILLER_8_1026 VPWR VGND sg13cmos5l_fill_2
Xfanout279 _08364_/B _08311_/Y VPWR VGND sg13cmos5l_buf_1
Xfanout268 _07607_/B _07629_/B VPWR VGND sg13cmos5l_buf_1
XFILLER_87_778 VPWR VGND sg13cmos5l_fill_1
X_09805_ _09805_/Y hold2741/X _09805_/A2 _09804_/Y _09644_/A VPWR VGND sg13cmos5l_a22oi_1
X_07997_ _07997_/Y _07997_/A _08011_/B VPWR VGND sg13cmos5l_nor2_1
Xfanout257 _08063_/A1 _08520_/A1 VPWR VGND sg13cmos5l_buf_1
XFILLER_101_588 VPWR VGND sg13cmos5l_fill_2
X_06948_ _06948_/Y _11552_/Q _11551_/Q VPWR VGND sg13cmos5l_nor2_1
XFILLER_55_620 VPWR VGND sg13cmos5l_decap_8
X_09736_ _09736_/Y _09734_/Y _09735_/Y _09738_/A1 VPWR VGND sg13cmos5l_a21oi_1
XFILLER_27_311 VPWR VGND sg13cmos5l_decap_8
XFILLER_55_631 VPWR VGND sg13cmos5l_fill_1
XFILLER_39_171 VPWR VGND sg13cmos5l_decap_8
XFILLER_27_322 VPWR VGND sg13cmos5l_fill_1
X_09667_ _09667_/Y _09721_/A _09668_/B _09748_/A VPWR VGND sg13cmos5l_o21ai_1
X_06879_ _06879_/Y _11686_/Q _06879_/B _06879_/C _06879_/D VPWR VGND sg13cmos5l_nand4_1
X_08618_ _08625_/B _08621_/B _08628_/A _08617_/Y VPWR VGND sg13cmos5l_o21ai_1
XFILLER_27_366 VPWR VGND sg13cmos5l_decap_8
XFILLER_91_49 VPWR VGND sg13cmos5l_decap_8
XFILLER_82_483 VPWR VGND sg13cmos5l_fill_2
XFILLER_42_314 VPWR VGND sg13cmos5l_fill_1
X_09598_ _09598_/Y _11000_/Q _09600_/B VPWR VGND sg13cmos5l_nand2_1
XFILLER_27_399 VPWR VGND sg13cmos5l_fill_2
X_08549_ _08549_/Y _08549_/A _08559_/B VPWR VGND sg13cmos5l_nor2_1
X_11560_ _11560_/Q clkload27/A _11560_/D _11560_/RESET_B VPWR VGND sg13cmos5l_dfrbpq_1
XFILLER_51_870 VPWR VGND sg13cmos5l_fill_2
XFILLER_10_200 VPWR VGND sg13cmos5l_decap_8
XFILLER_23_572 VPWR VGND sg13cmos5l_decap_8
X_10511_ _10511_/Y _10509_/Y _10511_/B VPWR VGND sg13cmos5l_nand2b_1
XFILLER_10_233 VPWR VGND sg13cmos5l_decap_4
X_11491_ _11491_/Q clkload11/A _11491_/D _11491_/RESET_B VPWR VGND sg13cmos5l_dfrbpq_1
X_10442_ _10442_/Y _11731_/Q _10166_/B _10441_/X VPWR VGND sg13cmos5l_o21ai_1
X_10373_ _10373_/Y _11743_/Q _10414_/A2 _07067_/B VPWR VGND sg13cmos5l_a21oi_1
XFILLER_78_701 VPWR VGND sg13cmos5l_decap_8
XFILLER_2_454 VPWR VGND sg13cmos5l_fill_1
XFILLER_105_883 VPWR VGND sg13cmos5l_decap_8
XFILLER_77_222 VPWR VGND sg13cmos5l_fill_2
X_10838__1166 _10838_/RESET_B VPWR VGND sg13cmos5l_tiehi
XFILLER_49_62 VPWR VGND sg13cmos5l_fill_1
XFILLER_78_778 VPWR VGND sg13cmos5l_fill_2
XFILLER_78_767 VPWR VGND sg13cmos5l_decap_8
X_11424__1442 _11424_/RESET_B VPWR VGND sg13cmos5l_tiehi
XFILLER_1_14 VPWR VGND sg13cmos5l_decap_8
XFILLER_65_428 VPWR VGND sg13cmos5l_decap_8
XFILLER_65_417 VPWR VGND sg13cmos5l_fill_1
Xfanout791 _07077_/A _11457_/Q VPWR VGND sg13cmos5l_buf_1
Xfanout780 _09198_/A hold2930/X VPWR VGND sg13cmos5l_buf_1
X_11475__1233 _11475_/RESET_B VPWR VGND sg13cmos5l_tiehi
XFILLER_74_984 VPWR VGND sg13cmos5l_fill_1
XFILLER_73_461 VPWR VGND sg13cmos5l_fill_2
XFILLER_73_450 VPWR VGND sg13cmos5l_decap_8
XFILLER_46_697 VPWR VGND sg13cmos5l_decap_8
X_11127__1774 _11127_/RESET_B VPWR VGND sg13cmos5l_tiehi
XFILLER_18_399 VPWR VGND sg13cmos5l_decap_4
XFILLER_34_837 VPWR VGND sg13cmos5l_decap_8
XFILLER_33_358 VPWR VGND sg13cmos5l_decap_8
X_11758_ _11758_/Q clkload24/A _11758_/D _11758_/RESET_B VPWR VGND sg13cmos5l_dfrbpq_1
XFILLER_60_177 VPWR VGND sg13cmos5l_fill_1
X_10709_ _10709_/X _10709_/A _10709_/B _10709_/C VPWR VGND sg13cmos5l_or3_1
X_11689_ _11689_/Q clkload25/A _11689_/D _11689_/RESET_B VPWR VGND sg13cmos5l_dfrbpq_1
XFILLER_5_270 VPWR VGND sg13cmos5l_decap_4
X_07920_ _07920_/Y _07920_/A _07978_/B VPWR VGND sg13cmos5l_nand2_1
XFILLER_88_509 VPWR VGND sg13cmos5l_decap_8
XFILLER_69_712 VPWR VGND sg13cmos5l_decap_8
Xhold2607 _10748_/A _11567_/Q VPWR VGND sg13cmos5l_dlygate4sd3_1
XFILLER_69_723 VPWR VGND sg13cmos5l_fill_1
Xhold2629 _11682_/D _07080_/Y VPWR VGND sg13cmos5l_dlygate4sd3_1
Xhold2618 _11683_/D _07084_/Y VPWR VGND sg13cmos5l_dlygate4sd3_1
Xhold1906 _07830_/A _11007_/Q VPWR VGND sg13cmos5l_dlygate4sd3_1
Xhold1917 _07978_/A _11079_/Q VPWR VGND sg13cmos5l_dlygate4sd3_1
X_07851_ _11017_/D fanout50/X _07850_/B _07850_/Y VPWR VGND sg13cmos5l_o21ai_1
XFILLER_57_907 VPWR VGND sg13cmos5l_decap_4
XFILLER_96_586 VPWR VGND sg13cmos5l_decap_8
X_07782_ _07782_/Y _07782_/A _07784_/B VPWR VGND sg13cmos5l_nor2_1
X_06802_ _06802_/Y _06790_/Y _06801_/Y _06800_/Y VPWR VGND sg13cmos5l_o21ai_1
XFILLER_84_748 VPWR VGND sg13cmos5l_fill_1
Xhold1928 _08368_/A _11270_/Q VPWR VGND sg13cmos5l_dlygate4sd3_1
Xinput2 input2/X ui_in[0] VPWR VGND sg13cmos5l_buf_1
Xhold1939 _08194_/A _11184_/Q VPWR VGND sg13cmos5l_dlygate4sd3_1
XFILLER_49_491 VPWR VGND sg13cmos5l_decap_8
X_06733_ _06733_/Y _06738_/A _06733_/B VPWR VGND sg13cmos5l_nor2_1
X_09521_ _09521_/Y _11093_/Q _09593_/B VPWR VGND sg13cmos5l_nand2_1
XFILLER_37_653 VPWR VGND sg13cmos5l_fill_1
XFILLER_92_781 VPWR VGND sg13cmos5l_decap_8
XFILLER_52_645 VPWR VGND sg13cmos5l_decap_4
XFILLER_36_185 VPWR VGND sg13cmos5l_decap_8
X_09452_ _09453_/B _09395_/A _09447_/X _09451_/Y VPWR VGND sg13cmos5l_o21ai_1
X_06664_ _06664_/Y _06664_/A _06664_/B VPWR VGND sg13cmos5l_xnor2_1
XFILLER_91_291 VPWR VGND sg13cmos5l_decap_4
XFILLER_51_122 VPWR VGND sg13cmos5l_fill_1
X_06595_ _06595_/Y _06591_/A _06346_/X _06639_/A VPWR VGND sg13cmos5l_a21oi_1
X_08403_ _08403_/Y _08403_/A _08403_/B VPWR VGND sg13cmos5l_nor2_1
X_09383_ _09383_/Y _09316_/B _09375_/Y _09382_/Y VPWR VGND sg13cmos5l_a21oi_1
XFILLER_51_177 VPWR VGND sg13cmos5l_decap_8
X_08334_ _08334_/Y _08334_/A _08358_/B VPWR VGND sg13cmos5l_nand2_1
X_10916__1066 _10916_/RESET_B VPWR VGND sg13cmos5l_tiehi
X_08265_ _08265_/Y _08265_/A _08267_/B VPWR VGND sg13cmos5l_nor2_1
X_07216_ _07216_/Y _05967_/Y _07239_/A2 _07226_/B1 _07215_/Y VPWR VGND sg13cmos5l_a22oi_1
X_08196_ _08196_/Y _08196_/A _08218_/B VPWR VGND sg13cmos5l_nand2_1
X_07147_ _07147_/Y hold2752/X _07148_/A2 _07071_/A VPWR VGND sg13cmos5l_o21ai_1
XFILLER_106_658 VPWR VGND sg13cmos5l_decap_8
XFILLER_105_168 VPWR VGND sg13cmos5l_decap_8
X_07078_ _07078_/Y _07071_/Y _07077_/X _06952_/A VPWR VGND sg13cmos5l_o21ai_1
XFILLER_10_56 VPWR VGND sg13cmos5l_decap_8
XFILLER_102_820 VPWR VGND sg13cmos5l_fill_1
XFILLER_87_520 VPWR VGND sg13cmos5l_fill_1
X_11205__1696 _11205_/RESET_B VPWR VGND sg13cmos5l_tiehi
X_06029_ _07067_/A _10180_/B _07076_/B VPWR VGND sg13cmos5l_nor2_1
XFILLER_0_936 VPWR VGND sg13cmos5l_decap_8
XFILLER_102_853 VPWR VGND sg13cmos5l_decap_4
XFILLER_47_417 VPWR VGND sg13cmos5l_decap_8
XFILLER_19_54 VPWR VGND sg13cmos5l_decap_8
XFILLER_56_940 VPWR VGND sg13cmos5l_fill_1
XFILLER_28_620 VPWR VGND sg13cmos5l_decap_4
X_10991_ _10991_/Q clkload44/A _10991_/D _10991_/RESET_B VPWR VGND sg13cmos5l_dfrbpq_1
XFILLER_43_601 VPWR VGND sg13cmos5l_fill_2
X_09719_ _09720_/B _09852_/A1 _09714_/X _09718_/Y VPWR VGND sg13cmos5l_o21ai_1
XFILLER_55_472 VPWR VGND sg13cmos5l_fill_2
XFILLER_43_634 VPWR VGND sg13cmos5l_fill_2
XFILLER_15_314 VPWR VGND sg13cmos5l_decap_8
XFILLER_15_325 VPWR VGND sg13cmos5l_fill_2
XFILLER_27_174 VPWR VGND sg13cmos5l_decap_4
XFILLER_28_697 VPWR VGND sg13cmos5l_fill_2
XFILLER_42_144 VPWR VGND sg13cmos5l_decap_8
XFILLER_35_75 VPWR VGND sg13cmos5l_decap_8
X_11612_ _11612_/Q clkload29/A _11612_/D _11612_/RESET_B VPWR VGND sg13cmos5l_dfrbpq_1
XFILLER_23_380 VPWR VGND sg13cmos5l_fill_2
X_11543_ _11543_/Q clkload55/A _11543_/D _11543_/RESET_B VPWR VGND sg13cmos5l_dfrbpq_1
XFILLER_11_575 VPWR VGND sg13cmos5l_decap_4
XFILLER_51_96 VPWR VGND sg13cmos5l_fill_2
XFILLER_13_1020 VPWR VGND sg13cmos5l_decap_8
X_11474_ _11474_/Q clkload38/A _11474_/D _11474_/RESET_B VPWR VGND sg13cmos5l_dfrbpq_1
X_10425_ _10427_/C _10436_/B2 _10298_/A _11472_/Q _10268_/A VPWR VGND sg13cmos5l_a22oi_1
X_10356_ _10361_/A _10356_/A1 _10345_/Y _10355_/Y VPWR VGND sg13cmos5l_a21oi_1
X_10287_ _10287_/Y _10287_/A _10309_/B VPWR VGND sg13cmos5l_nor2_1
XFILLER_66_704 VPWR VGND sg13cmos5l_decap_4
XFILLER_65_203 VPWR VGND sg13cmos5l_fill_2
XFILLER_93_556 VPWR VGND sg13cmos5l_fill_2
XFILLER_18_152 VPWR VGND sg13cmos5l_decap_8
XFILLER_61_420 VPWR VGND sg13cmos5l_fill_2
XFILLER_46_483 VPWR VGND sg13cmos5l_fill_1
XFILLER_34_645 VPWR VGND sg13cmos5l_decap_8
XFILLER_61_475 VPWR VGND sg13cmos5l_decap_4
XFILLER_33_166 VPWR VGND sg13cmos5l_fill_1
XFILLER_33_188 VPWR VGND sg13cmos5l_decap_8
XFILLER_14_391 VPWR VGND sg13cmos5l_fill_1
X_06380_ _06380_/Y _10270_/A _06223_/A _10252_/B VPWR VGND sg13cmos5l_a21oi_1
XFILLER_33_199 VPWR VGND sg13cmos5l_fill_2
X_08050_ _08050_/Y _08050_/A _08102_/B VPWR VGND sg13cmos5l_nand2_1
X_07001_ _07001_/X hold2505/X _07030_/B _07000_/Y VPWR VGND sg13cmos5l_a21o_1
XFILLER_51_0 VPWR VGND sg13cmos5l_decap_8
XFILLER_88_306 VPWR VGND sg13cmos5l_fill_2
XFILLER_102_105 VPWR VGND sg13cmos5l_decap_8
X_08952_ _08952_/Y _08960_/B _08952_/B VPWR VGND sg13cmos5l_xnor2_1
Xhold2404 _08415_/A _11293_/Q VPWR VGND sg13cmos5l_dlygate4sd3_1
XFILLER_97_862 VPWR VGND sg13cmos5l_fill_1
X_07903_ _07903_/Y _07903_/A _07911_/B VPWR VGND sg13cmos5l_nor2_1
X_08883_ _08897_/A _11633_/Q _08891_/A VPWR VGND sg13cmos5l_nand2_1
Xhold2426 _08517_/A _11343_/Q VPWR VGND sg13cmos5l_dlygate4sd3_1
Xhold2415 _08539_/A _11354_/Q VPWR VGND sg13cmos5l_dlygate4sd3_1
Xhold2437 _10865_/D _07288_/Y VPWR VGND sg13cmos5l_dlygate4sd3_1
XFILLER_97_873 VPWR VGND sg13cmos5l_fill_1
Xhold2448 _11600_/D _06802_/Y VPWR VGND sg13cmos5l_dlygate4sd3_1
Xhold2459 _08125_/A _11150_/Q VPWR VGND sg13cmos5l_dlygate4sd3_1
X_07834_ _07834_/Y _07834_/A _07834_/B VPWR VGND sg13cmos5l_nand2_1
XFILLER_84_534 VPWR VGND sg13cmos5l_decap_8
X_07765_ _10975_/D fanout75/X _07770_/B _07764_/Y VPWR VGND sg13cmos5l_a21oi_1
XFILLER_65_770 VPWR VGND sg13cmos5l_decap_4
X_07696_ _07696_/Y _07696_/A _07718_/B VPWR VGND sg13cmos5l_nor2_1
XFILLER_52_420 VPWR VGND sg13cmos5l_decap_8
X_09504_ _09511_/B _09534_/A _09504_/B VPWR VGND sg13cmos5l_nor2_1
X_06716_ _10812_/D _06744_/A1 _06713_/Y _06715_/Y VPWR VGND sg13cmos5l_o21ai_1
X_06647_ _06647_/Y _06662_/A _06647_/B VPWR VGND sg13cmos5l_nand2_1
X_09435_ _09436_/C _09534_/A _09428_/Y _09434_/Y VPWR VGND sg13cmos5l_o21ai_1
XFILLER_53_998 VPWR VGND sg13cmos5l_decap_4
XFILLER_12_306 VPWR VGND sg13cmos5l_decap_4
X_06578_ _06580_/A _11487_/Q _10171_/A _06401_/C VPWR VGND sg13cmos5l_o21ai_1
X_09366_ _09366_/Y _11023_/Q _09363_/B _09601_/B1 VPWR VGND sg13cmos5l_a21oi_1
XFILLER_12_339 VPWR VGND sg13cmos5l_fill_1
XFILLER_21_840 VPWR VGND sg13cmos5l_decap_4
X_09297_ _09297_/Y _09902_/A _09292_/X _09296_/Y VPWR VGND sg13cmos5l_o21ai_1
XFILLER_21_884 VPWR VGND sg13cmos5l_fill_1
X_08317_ _11244_/D _08317_/A1 _08358_/B _08316_/Y VPWR VGND sg13cmos5l_o21ai_1
X_08248_ _11210_/D _08313_/A1 _08299_/B _08247_/Y VPWR VGND sg13cmos5l_a21oi_1
XFILLER_20_372 VPWR VGND sg13cmos5l_decap_8
XFILLER_21_11 VPWR VGND sg13cmos5l_decap_8
XFILLER_21_55 VPWR VGND sg13cmos5l_decap_4
X_08179_ _08179_/Y _08179_/A _08179_/B VPWR VGND sg13cmos5l_nor2_1
X_10210_ _10222_/A _11397_/Q _10834_/Q VPWR VGND sg13cmos5l_nor2_1
X_11492__1199 _11492_/RESET_B VPWR VGND sg13cmos5l_tiehi
XFILLER_106_455 VPWR VGND sg13cmos5l_decap_8
X_11190_ _11190_/Q clkload8/A _11190_/D _11190_/RESET_B VPWR VGND sg13cmos5l_dfrbpq_1
X_10141_ _10141_/Y _10644_/B1 _09937_/Y _10123_/A VPWR VGND sg13cmos5l_o21ai_1
XFILLER_88_862 VPWR VGND sg13cmos5l_decap_4
XFILLER_0_744 VPWR VGND sg13cmos5l_decap_8
X_10072_ _10072_/Y _10073_/B _10071_/Y _10069_/Y VPWR VGND sg13cmos5l_o21ai_1
XFILLER_48_704 VPWR VGND sg13cmos5l_decap_4
XFILLER_102_694 VPWR VGND sg13cmos5l_fill_1
XFILLER_101_182 VPWR VGND sg13cmos5l_decap_8
XFILLER_75_578 VPWR VGND sg13cmos5l_fill_1
XFILLER_46_41 VPWR VGND sg13cmos5l_fill_2
X_10974_ _10974_/Q clkload58/A _10974_/D _10974_/RESET_B VPWR VGND sg13cmos5l_dfrbpq_1
XFILLER_56_770 VPWR VGND sg13cmos5l_fill_2
XFILLER_44_921 VPWR VGND sg13cmos5l_decap_8
XFILLER_71_762 VPWR VGND sg13cmos5l_decap_8
XFILLER_43_453 VPWR VGND sg13cmos5l_decap_4
XFILLER_102_91 VPWR VGND sg13cmos5l_decap_8
XFILLER_62_62 VPWR VGND sg13cmos5l_decap_4
XFILLER_8_822 VPWR VGND sg13cmos5l_fill_1
XFILLER_50_1028 VPWR VGND sg13cmos5l_fill_1
XFILLER_7_35 VPWR VGND sg13cmos5l_decap_8
X_11526_ _11526_/Q clkload18/A _11526_/D _11526_/RESET_B VPWR VGND sg13cmos5l_dfrbpq_1
XFILLER_8_899 VPWR VGND sg13cmos5l_decap_4
X_11457_ _11457_/Q clkload14/A _11457_/D _11457_/RESET_B VPWR VGND sg13cmos5l_dfrbpq_1
X_11388_ _11388_/Q clkload31/A _11388_/D _11388_/RESET_B VPWR VGND sg13cmos5l_dfrbpq_1
X_10408_ _10408_/Y _10408_/A _10408_/B _10408_/C VPWR VGND sg13cmos5l_nand3_1
X_10339_ _10339_/Y hold2895/X _07007_/A _07067_/B VPWR VGND sg13cmos5l_a21oi_1
XFILLER_23_4 VPWR VGND sg13cmos5l_decap_4
X_05880_ _05880_/Y input3/X VPWR VGND sg13cmos5l_inv_1
XFILLER_53_228 VPWR VGND sg13cmos5l_decap_8
XFILLER_19_472 VPWR VGND sg13cmos5l_decap_8
X_07550_ _07550_/Y _07577_/A _07550_/B VPWR VGND sg13cmos5l_nand2_1
XFILLER_62_751 VPWR VGND sg13cmos5l_fill_1
XFILLER_35_954 VPWR VGND sg13cmos5l_fill_1
X_06501_ _06501_/Y _11277_/Q _09578_/A2 _06500_/Y VPWR VGND sg13cmos5l_o21ai_1
XFILLER_34_420 VPWR VGND sg13cmos5l_fill_1
XFILLER_62_773 VPWR VGND sg13cmos5l_fill_1
XFILLER_61_261 VPWR VGND sg13cmos5l_fill_1
XFILLER_35_998 VPWR VGND sg13cmos5l_decap_8
X_09220_ _09225_/A _09220_/A _09590_/A VPWR VGND sg13cmos5l_nand2_1
X_07481_ _07481_/Y _07493_/A _07477_/X _07478_/Y _07480_/Y VPWR VGND sg13cmos5l_a22oi_1
X_06432_ _06432_/X _06772_/S _06432_/B VPWR VGND sg13cmos5l_and2_1
X_09151_ _09151_/X _09151_/A _09151_/B VPWR VGND sg13cmos5l_or2_1
X_06363_ _06364_/A _06363_/A _06363_/B VPWR VGND sg13cmos5l_nor2_1
X_08102_ _08102_/Y _08102_/A _08102_/B VPWR VGND sg13cmos5l_nand2_1
X_09082_ _09082_/Y _09131_/A _09066_/A _09081_/Y VPWR VGND sg13cmos5l_a21oi_1
X_08033_ _08033_/Y _08033_/A _08033_/B VPWR VGND sg13cmos5l_nor2_1
X_06294_ _06294_/Y _11495_/Q _09198_/A VPWR VGND sg13cmos5l_nand2b_1
XFILLER_104_915 VPWR VGND sg13cmos5l_decap_8
XFILLER_89_604 VPWR VGND sg13cmos5l_decap_8
XFILLER_103_425 VPWR VGND sg13cmos5l_decap_4
XFILLER_88_147 VPWR VGND sg13cmos5l_fill_1
Xhold2201 _08427_/A _11299_/Q VPWR VGND sg13cmos5l_dlygate4sd3_1
X_09984_ _09984_/Y _11110_/Q _09984_/B VPWR VGND sg13cmos5l_nand2_1
Xhold2212 _08271_/A _11222_/Q VPWR VGND sg13cmos5l_dlygate4sd3_1
Xhold2245 _07985_/A _11082_/Q VPWR VGND sg13cmos5l_dlygate4sd3_1
Xhold2223 _08419_/A _11295_/Q VPWR VGND sg13cmos5l_dlygate4sd3_1
Xhold2234 _08547_/A _11358_/Q VPWR VGND sg13cmos5l_dlygate4sd3_1
XFILLER_76_309 VPWR VGND sg13cmos5l_decap_8
X_08935_ _08935_/Y _08933_/Y _08934_/Y _08924_/Y VPWR VGND sg13cmos5l_o21ai_1
X_11086__1815 _11086_/RESET_B VPWR VGND sg13cmos5l_tiehi
XFILLER_29_203 VPWR VGND sg13cmos5l_fill_1
XFILLER_85_832 VPWR VGND sg13cmos5l_decap_4
XFILLER_84_331 VPWR VGND sg13cmos5l_decap_4
Xhold2278 _08019_/A _11099_/Q VPWR VGND sg13cmos5l_dlygate4sd3_1
XFILLER_57_523 VPWR VGND sg13cmos5l_fill_1
Xhold2256 _06124_/B _11766_/Q VPWR VGND sg13cmos5l_dlygate4sd3_1
X_08866_ _08877_/B _08876_/A _08890_/D VPWR VGND sg13cmos5l_nand2_1
Xhold2267 _07726_/A _10956_/Q VPWR VGND sg13cmos5l_dlygate4sd3_1
X_08797_ _08797_/Y _08819_/A _08806_/B _08832_/A1 VPWR VGND sg13cmos5l_o21ai_1
X_07817_ _11000_/D _08536_/A1 _07820_/B _07816_/Y VPWR VGND sg13cmos5l_o21ai_1
Xhold2289 _08155_/A _11165_/Q VPWR VGND sg13cmos5l_dlygate4sd3_1
XFILLER_38_792 VPWR VGND sg13cmos5l_decap_4
X_07748_ _07748_/Y _07748_/A _07748_/B VPWR VGND sg13cmos5l_nor2_1
XFILLER_72_559 VPWR VGND sg13cmos5l_decap_8
XFILLER_73_1028 VPWR VGND sg13cmos5l_fill_1
XFILLER_53_784 VPWR VGND sg13cmos5l_decap_8
XFILLER_52_261 VPWR VGND sg13cmos5l_decap_8
XFILLER_40_401 VPWR VGND sg13cmos5l_decap_4
XFILLER_13_626 VPWR VGND sg13cmos5l_fill_2
X_07679_ _10933_/D _08073_/A1 _07694_/B _07678_/Y VPWR VGND sg13cmos5l_a21oi_1
X_10690_ _11551_/D _10690_/A _10690_/B VPWR VGND sg13cmos5l_nor2_1
X_09418_ _09418_/Y _11121_/Q _09841_/B _09707_/S1 VPWR VGND sg13cmos5l_a21oi_1
X_09349_ _09349_/Y _09506_/A _09349_/B _09349_/C VPWR VGND sg13cmos5l_nand3_1
X_11311_ _11311_/Q clkload43/A _11311_/D _11311_/RESET_B VPWR VGND sg13cmos5l_dfrbpq_1
XFILLER_32_98 VPWR VGND sg13cmos5l_fill_2
X_11242_ _11242_/Q _11646_/CLK _11242_/D _11242_/RESET_B VPWR VGND sg13cmos5l_dfrbpq_1
XFILLER_5_869 VPWR VGND sg13cmos5l_decap_8
XFILLER_106_252 VPWR VGND sg13cmos5l_decap_8
X_11173_ _11173_/Q clkload54/A _11173_/D _11173_/RESET_B VPWR VGND sg13cmos5l_dfrbpq_1
XFILLER_4_368 VPWR VGND sg13cmos5l_decap_8
XFILLER_95_607 VPWR VGND sg13cmos5l_fill_1
X_10124_ _11508_/D _10122_/Y _10123_/Y _10120_/Y VPWR VGND sg13cmos5l_o21ai_1
XFILLER_94_117 VPWR VGND sg13cmos5l_fill_1
XFILLER_0_563 VPWR VGND sg13cmos5l_decap_8
X_10055_ _10055_/Y _10055_/A _10055_/B _10055_/C VPWR VGND sg13cmos5l_nor3_1
XFILLER_75_320 VPWR VGND sg13cmos5l_decap_8
Xhold2790 hold2790/X _11689_/Q VPWR VGND sg13cmos5l_dlygate4sd3_1
XFILLER_57_84 VPWR VGND sg13cmos5l_fill_2
Xheichips26_RiMaX_840 uio_out[1] VPWR VGND sg13cmos5l_tielo
XFILLER_91_846 VPWR VGND sg13cmos5l_fill_1
X_11574__1391 _11574_/RESET_B VPWR VGND sg13cmos5l_tiehi
X_11548__1477 _11548_/RESET_B VPWR VGND sg13cmos5l_tiehi
XFILLER_36_729 VPWR VGND sg13cmos5l_decap_8
X_10875__1107 _10875_/RESET_B VPWR VGND sg13cmos5l_tiehi
XFILLER_29_792 VPWR VGND sg13cmos5l_fill_1
XFILLER_35_206 VPWR VGND sg13cmos5l_fill_1
X_10911__1071 _10911_/RESET_B VPWR VGND sg13cmos5l_tiehi
X_10957_ _10957_/Q clkload34/A _10957_/D _10957_/RESET_B VPWR VGND sg13cmos5l_dfrbpq_1
XFILLER_16_453 VPWR VGND sg13cmos5l_decap_8
XFILLER_92_7 VPWR VGND sg13cmos5l_decap_8
X_10888_ _10888_/Q clkload12/A _10888_/D _10888_/RESET_B VPWR VGND sg13cmos5l_dfrbpq_1
XFILLER_8_641 VPWR VGND sg13cmos5l_decap_4
X_11164__1737 _11164_/RESET_B VPWR VGND sg13cmos5l_tiehi
X_11509_ _11509_/Q clkload48/A _11509_/D _11509_/RESET_B VPWR VGND sg13cmos5l_dfrbpq_1
XFILLER_99_935 VPWR VGND sg13cmos5l_decap_4
XFILLER_98_423 VPWR VGND sg13cmos5l_fill_1
XFILLER_98_91 VPWR VGND sg13cmos5l_decap_8
Xfanout609 _09154_/B1 _08772_/B2 VPWR VGND sg13cmos5l_buf_1
XFILLER_98_489 VPWR VGND sg13cmos5l_decap_4
XFILLER_86_629 VPWR VGND sg13cmos5l_fill_1
X_06981_ _06981_/X hold2521/X _07050_/B1 _06980_/Y VPWR VGND sg13cmos5l_a21o_1
X_05932_ _09317_/A _07076_/B VPWR VGND sg13cmos5l_inv_1
X_08720_ _11410_/D _08720_/A VPWR VGND sg13cmos5l_inv_1
X_05863_ _05863_/Y _11422_/Q VPWR VGND sg13cmos5l_inv_1
X_08651_ _08653_/A _08651_/A _08651_/B VPWR VGND sg13cmos5l_and2_1
XFILLER_39_567 VPWR VGND sg13cmos5l_fill_2
XFILLER_27_718 VPWR VGND sg13cmos5l_fill_2
XFILLER_96_1028 VPWR VGND sg13cmos5l_fill_1
XFILLER_82_835 VPWR VGND sg13cmos5l_fill_2
X_07602_ _08741_/B _11543_/Q _10818_/Q _07642_/S VPWR VGND sg13cmos5l_mux2_1
X_08582_ _08582_/Y _11274_/Q _10019_/B _10049_/A1 VPWR VGND sg13cmos5l_o21ai_1
XFILLER_82_879 VPWR VGND sg13cmos5l_fill_1
XFILLER_82_857 VPWR VGND sg13cmos5l_decap_8
XFILLER_19_291 VPWR VGND sg13cmos5l_fill_1
XFILLER_22_401 VPWR VGND sg13cmos5l_decap_8
X_07533_ _08699_/B _11533_/Q _10808_/Q _07582_/S VPWR VGND sg13cmos5l_mux2_1
X_07464_ _07464_/Y _10191_/A _07472_/D _11396_/Q VPWR VGND sg13cmos5l_a21oi_1
X_11611__1366 _11611_/RESET_B VPWR VGND sg13cmos5l_tiehi
X_06415_ _06415_/Y _06429_/B _06758_/B1 _06758_/A2 VPWR VGND sg13cmos5l_a21oi_1
X_09203_ _09208_/A _09514_/A _09488_/A VPWR VGND sg13cmos5l_or2_1
X_09134_ _11452_/D _07416_/A _09155_/B _09133_/Y VPWR VGND sg13cmos5l_a21o_1
X_07395_ _07395_/Y _07395_/A _07401_/B VPWR VGND sg13cmos5l_nor2_1
XFILLER_31_990 VPWR VGND sg13cmos5l_fill_2
X_06346_ _06346_/X _06588_/B _06346_/B _06588_/C VPWR VGND sg13cmos5l_or3_1
X_09065_ _11447_/D _09063_/Y _09064_/Y _09055_/Y VPWR VGND sg13cmos5l_o21ai_1
X_06277_ _06582_/B _07076_/B _11487_/Q VPWR VGND sg13cmos5l_nand2b_1
X_08016_ _11097_/D fanout99/X _08023_/B _08015_/Y VPWR VGND sg13cmos5l_a21oi_1
X_10953__1029 _10953_/RESET_B VPWR VGND sg13cmos5l_tiehi
XFILLER_103_266 VPWR VGND sg13cmos5l_decap_8
Xhold2020 _08372_/A _11272_/Q VPWR VGND sg13cmos5l_dlygate4sd3_1
X_09967_ _09974_/B _09996_/A _09967_/B VPWR VGND sg13cmos5l_nor2_1
XFILLER_49_309 VPWR VGND sg13cmos5l_decap_4
XFILLER_98_990 VPWR VGND sg13cmos5l_fill_2
Xhold2042 _08236_/A _11205_/Q VPWR VGND sg13cmos5l_dlygate4sd3_1
X_08918_ _08918_/Y _08930_/B _08918_/B VPWR VGND sg13cmos5l_xnor2_1
Xhold2031 _08082_/A _11130_/Q VPWR VGND sg13cmos5l_dlygate4sd3_1
Xhold2053 _11669_/D _07031_/Y VPWR VGND sg13cmos5l_dlygate4sd3_1
Xhold2097 _07646_/A _10920_/Q VPWR VGND sg13cmos5l_dlygate4sd3_1
XFILLER_94_49 VPWR VGND sg13cmos5l_decap_8
Xhold2086 _11602_/D _06808_/Y VPWR VGND sg13cmos5l_dlygate4sd3_1
X_09898_ _09898_/Y _09894_/Y _09895_/Y _09896_/Y _09897_/Y _10043_/C1 VPWR VGND sg13cmos5l_a221oi_1
XFILLER_57_331 VPWR VGND sg13cmos5l_fill_1
Xhold2064 _08332_/A _11252_/Q VPWR VGND sg13cmos5l_dlygate4sd3_1
Xhold2075 _11664_/D _07011_/Y VPWR VGND sg13cmos5l_dlygate4sd3_1
XFILLER_18_718 VPWR VGND sg13cmos5l_fill_2
XFILLER_73_824 VPWR VGND sg13cmos5l_fill_1
X_08849_ _08861_/D _11382_/Q _08849_/B VPWR VGND sg13cmos5l_xnor2_1
XFILLER_17_217 VPWR VGND sg13cmos5l_fill_1
X_11242__1659 _11242_/RESET_B VPWR VGND sg13cmos5l_tiehi
XFILLER_84_194 VPWR VGND sg13cmos5l_fill_1
XFILLER_57_397 VPWR VGND sg13cmos5l_decap_4
X_10811_ _10811_/Q clkload37/A _10811_/D _10811_/RESET_B VPWR VGND sg13cmos5l_dfrbpq_1
X_10742_ _10751_/B _10747_/A _10748_/A _10748_/B VPWR VGND sg13cmos5l_nor3_1
XFILLER_43_31 VPWR VGND sg13cmos5l_decap_4
XFILLER_25_261 VPWR VGND sg13cmos5l_fill_2
XFILLER_41_776 VPWR VGND sg13cmos5l_decap_8
XFILLER_13_467 VPWR VGND sg13cmos5l_fill_1
X_10673_ _10673_/Y _10673_/A _10673_/B VPWR VGND sg13cmos5l_xnor2_1
XFILLER_41_787 VPWR VGND sg13cmos5l_fill_2
XFILLER_99_209 VPWR VGND sg13cmos5l_fill_1
XFILLER_4_121 VPWR VGND sg13cmos5l_decap_8
XFILLER_4_154 VPWR VGND sg13cmos5l_decap_8
XFILLER_4_14 VPWR VGND sg13cmos5l_decap_8
X_11225_ _11225_/Q _11265_/CLK _11225_/D _11225_/RESET_B VPWR VGND sg13cmos5l_dfrbpq_1
XFILLER_4_58 VPWR VGND sg13cmos5l_fill_2
X_10929__1053 _10929_/RESET_B VPWR VGND sg13cmos5l_tiehi
XFILLER_68_607 VPWR VGND sg13cmos5l_fill_2
X_11156_ _11156_/Q clkload9/A _11156_/D _11156_/RESET_B VPWR VGND sg13cmos5l_dfrbpq_1
XFILLER_95_448 VPWR VGND sg13cmos5l_fill_2
XFILLER_95_426 VPWR VGND sg13cmos5l_fill_1
XFILLER_68_94 VPWR VGND sg13cmos5l_fill_2
XFILLER_67_117 VPWR VGND sg13cmos5l_decap_8
X_11087_ _11087_/Q clkload44/A _11087_/D _11087_/RESET_B VPWR VGND sg13cmos5l_dfrbpq_1
X_10107_ _10107_/Y _10526_/A _09234_/B _10158_/A2 VPWR VGND sg13cmos5l_o21ai_1
XFILLER_0_371 VPWR VGND sg13cmos5l_fill_1
X_10038_ _10044_/B _10034_/Y _10035_/Y _10036_/Y _10037_/Y _10038_/C1 VPWR VGND sg13cmos5l_a221oi_1
XFILLER_76_662 VPWR VGND sg13cmos5l_fill_1
XFILLER_63_323 VPWR VGND sg13cmos5l_fill_2
XFILLER_36_548 VPWR VGND sg13cmos5l_fill_2
X_11218__1683 _11218_/RESET_B VPWR VGND sg13cmos5l_tiehi
XFILLER_16_250 VPWR VGND sg13cmos5l_decap_4
XFILLER_23_209 VPWR VGND sg13cmos5l_fill_1
XFILLER_90_197 VPWR VGND sg13cmos5l_fill_2
XFILLER_90_186 VPWR VGND sg13cmos5l_fill_2
XFILLER_32_732 VPWR VGND sg13cmos5l_decap_8
XFILLER_20_938 VPWR VGND sg13cmos5l_fill_1
X_06200_ _06201_/B _10069_/A _09405_/A VPWR VGND sg13cmos5l_nor2_1
X_07180_ _07180_/Y _05955_/Y _07182_/C1 _07178_/Y _07179_/Y VPWR VGND sg13cmos5l_a22oi_1
X_11504__1175 _11504_/RESET_B VPWR VGND sg13cmos5l_tiehi
X_06131_ _06131_/Y hold2463/X _06131_/B _08627_/C VPWR VGND sg13cmos5l_nand3b_1
XFILLER_105_509 VPWR VGND sg13cmos5l_decap_8
X_06062_ _06062_/Y _10709_/A _06924_/A VPWR VGND sg13cmos5l_nand2_1
X_11458__1356 _11458_/RESET_B VPWR VGND sg13cmos5l_tiehi
XFILLER_99_754 VPWR VGND sg13cmos5l_decap_8
XFILLER_87_905 VPWR VGND sg13cmos5l_decap_4
Xfanout406 _08599_/S1 _09573_/A1 VPWR VGND sg13cmos5l_buf_1
X_09821_ _09821_/X _11264_/Q _11232_/Q _11200_/Q _11168_/Q _09824_/A2 _10035_/B1 VPWR
+ VGND sg13cmos5l_mux4_1
Xfanout417 _10046_/B1 _09791_/B1 VPWR VGND sg13cmos5l_buf_1
Xfanout428 _09987_/B1 _10042_/B1 VPWR VGND sg13cmos5l_buf_1
Xfanout439 _09734_/B _09419_/B VPWR VGND sg13cmos5l_buf_1
XFILLER_100_203 VPWR VGND sg13cmos5l_fill_2
XFILLER_98_275 VPWR VGND sg13cmos5l_decap_4
X_09752_ _11475_/D _10293_/A _09807_/A _09731_/Y _09751_/Y VPWR VGND sg13cmos5l_a22oi_1
X_11629__1337 _11629_/RESET_B VPWR VGND sg13cmos5l_tiehi
XFILLER_67_640 VPWR VGND sg13cmos5l_fill_1
X_08703_ _11406_/D _08703_/A VPWR VGND sg13cmos5l_inv_1
X_06964_ _06964_/Y _07016_/A _07018_/B _06963_/Y VPWR VGND sg13cmos5l_o21ai_1
X_09683_ _09683_/Y _10971_/Q _09955_/B _09991_/B1 VPWR VGND sg13cmos5l_a21oi_1
X_06895_ _11632_/D _11701_/D hold2900/X _08645_/S VPWR VGND sg13cmos5l_mux2_1
X_05915_ _06289_/B _09480_/A VPWR VGND sg13cmos5l_inv_1
XFILLER_27_515 VPWR VGND sg13cmos5l_fill_1
X_08634_ _11381_/D _11711_/D _07194_/B _08645_/S VPWR VGND sg13cmos5l_mux2_1
XFILLER_55_857 VPWR VGND sg13cmos5l_decap_4
XFILLER_55_846 VPWR VGND sg13cmos5l_decap_4
XFILLER_27_559 VPWR VGND sg13cmos5l_fill_1
X_08565_ _08565_/Y _08565_/A _08565_/B VPWR VGND sg13cmos5l_nor2_1
XFILLER_81_164 VPWR VGND sg13cmos5l_fill_2
XFILLER_14_209 VPWR VGND sg13cmos5l_fill_2
XFILLER_23_732 VPWR VGND sg13cmos5l_decap_8
X_07516_ _07516_/Y _07515_/A _08685_/B _07515_/Y VPWR VGND sg13cmos5l_o21ai_1
X_08496_ _08496_/Y _08496_/A _08496_/B VPWR VGND sg13cmos5l_nand2_1
XFILLER_11_905 VPWR VGND sg13cmos5l_decap_4
X_07447_ _08652_/B _11520_/Q _10795_/Q _07447_/S VPWR VGND sg13cmos5l_mux2_1
Xfanout57 fanout57/X _07626_/Y VPWR VGND sg13cmos5l_buf_1
XFILLER_50_584 VPWR VGND sg13cmos5l_decap_8
Xfanout79 fanout79/X _07571_/Y VPWR VGND sg13cmos5l_buf_1
XFILLER_13_23 VPWR VGND sg13cmos5l_decap_8
Xfanout68 fanout68/X _07600_/Y VPWR VGND sg13cmos5l_buf_1
X_07378_ _10880_/D _07383_/B _07376_/Y _07377_/Y VPWR VGND sg13cmos5l_a21oi_1
X_06329_ _06329_/Y _11516_/Q _09262_/A VPWR VGND sg13cmos5l_nand2b_1
X_09117_ _09119_/B _09118_/A _09112_/B _09127_/B VPWR VGND sg13cmos5l_a21oi_1
XFILLER_89_49 VPWR VGND sg13cmos5l_decap_4
X_09048_ _09048_/Y _09069_/C _09047_/Y _09051_/A1 VPWR VGND sg13cmos5l_o21ai_1
XFILLER_2_625 VPWR VGND sg13cmos5l_decap_8
X_11010_ _11010_/Q _11362_/CLK _11010_/D _11010_/RESET_B VPWR VGND sg13cmos5l_dfrbpq_1
XFILLER_49_117 VPWR VGND sg13cmos5l_fill_1
XFILLER_93_908 VPWR VGND sg13cmos5l_fill_2
XFILLER_46_813 VPWR VGND sg13cmos5l_fill_1
XFILLER_57_172 VPWR VGND sg13cmos5l_fill_2
XFILLER_46_879 VPWR VGND sg13cmos5l_fill_2
XFILLER_73_698 VPWR VGND sg13cmos5l_decap_4
XFILLER_60_315 VPWR VGND sg13cmos5l_fill_1
XFILLER_33_529 VPWR VGND sg13cmos5l_fill_2
X_10725_ _10725_/Y _10725_/A _10728_/B _10728_/C VPWR VGND sg13cmos5l_nand3_1
XFILLER_9_202 VPWR VGND sg13cmos5l_decap_4
XFILLER_103_1010 VPWR VGND sg13cmos5l_decap_8
X_10656_ _10662_/C _10656_/A _10656_/B VPWR VGND sg13cmos5l_and2_1
XFILLER_10_971 VPWR VGND sg13cmos5l_fill_1
Xclkload16 clkload16/Y clkload16/A VPWR VGND sg13cmos5l_inv_1
Xclkload49 clkload49/X clkload49/A VPWR VGND sg13cmos5l_buf_8
Xclkload27 clkload27/Y clkload27/A VPWR VGND sg13cmos5l_inv_1
X_10587_ _10588_/C hold2754/X _10675_/B fanout85/X VPWR VGND sg13cmos5l_a21oi_1
Xclkload38 clkload38/X clkload38/A VPWR VGND sg13cmos5l_buf_8
XFILLER_86_1027 VPWR VGND sg13cmos5l_fill_2
XFILLER_6_997 VPWR VGND sg13cmos5l_decap_8
X_11208_ _11208_/Q clkload50/A _11208_/D _11208_/RESET_B VPWR VGND sg13cmos5l_dfrbpq_1
XFILLER_95_234 VPWR VGND sg13cmos5l_decap_4
X_11139_ _11139_/Q clkload46/A _11139_/D _11139_/RESET_B VPWR VGND sg13cmos5l_dfrbpq_1
XFILLER_36_301 VPWR VGND sg13cmos5l_decap_8
XFILLER_36_345 VPWR VGND sg13cmos5l_fill_1
XFILLER_36_334 VPWR VGND sg13cmos5l_decap_4
X_06680_ _06681_/B _06760_/S _06687_/B _06679_/X VPWR VGND sg13cmos5l_a21oi_1
XFILLER_92_996 VPWR VGND sg13cmos5l_decap_8
XFILLER_64_676 VPWR VGND sg13cmos5l_fill_1
XFILLER_52_816 VPWR VGND sg13cmos5l_fill_1
XFILLER_52_838 VPWR VGND sg13cmos5l_fill_2
X_08350_ _08350_/Y _08350_/A _08350_/B VPWR VGND sg13cmos5l_nand2_1
X_07301_ _07301_/Y _11529_/Q _08689_/A VPWR VGND sg13cmos5l_nand2_1
X_08281_ _08281_/Y _08281_/A _08281_/B VPWR VGND sg13cmos5l_nor2_1
XFILLER_81_0 VPWR VGND sg13cmos5l_decap_8
X_07232_ _10850_/D _07244_/A _07232_/B VPWR VGND sg13cmos5l_nand2_1
XFILLER_20_768 VPWR VGND sg13cmos5l_decap_4
X_07163_ _07163_/Y hold2874/X _07164_/A2 _07163_/B1 VPWR VGND sg13cmos5l_o21ai_1
X_06114_ _06114_/Y _06114_/A _06114_/B _06114_/C VPWR VGND sg13cmos5l_nor3_1
X_07094_ _07094_/Y _05879_/Y _07093_/B _07093_/Y VPWR VGND sg13cmos5l_o21ai_1
XFILLER_105_328 VPWR VGND sg13cmos5l_decap_8
X_06045_ _06046_/D _11622_/Q _11621_/Q _06045_/C _06045_/D VPWR VGND sg13cmos5l_nor4_1
Xfanout203 _08309_/B _08246_/Y VPWR VGND sg13cmos5l_buf_1
Xfanout214 _08173_/B _08179_/B VPWR VGND sg13cmos5l_buf_1
XFILLER_8_1005 VPWR VGND sg13cmos5l_decap_8
X_10870__1112 _10870_/RESET_B VPWR VGND sg13cmos5l_tiehi
Xfanout225 _08043_/B _07984_/Y VPWR VGND sg13cmos5l_buf_1
Xfanout236 _07913_/B _07854_/Y VPWR VGND sg13cmos5l_buf_1
XFILLER_86_212 VPWR VGND sg13cmos5l_fill_2
X_09804_ _09804_/Y _10423_/A _09828_/B _09723_/Y VPWR VGND sg13cmos5l_a21oi_1
Xfanout247 _07676_/B _07682_/B VPWR VGND sg13cmos5l_buf_1
Xfanout269 _07629_/B fanout271/X VPWR VGND sg13cmos5l_buf_1
XFILLER_87_757 VPWR VGND sg13cmos5l_fill_1
XFILLER_59_459 VPWR VGND sg13cmos5l_fill_1
X_07996_ _11087_/D _08453_/A1 _08007_/B _07995_/Y VPWR VGND sg13cmos5l_a21oi_1
Xfanout258 _08520_/A1 _07481_/Y VPWR VGND sg13cmos5l_buf_1
X_06947_ _06947_/Y _06784_/Y _06946_/Y _06855_/Y VPWR VGND sg13cmos5l_o21ai_1
X_09735_ _09735_/Y _10909_/Q _09733_/S _09735_/B1 VPWR VGND sg13cmos5l_a21oi_1
XFILLER_67_492 VPWR VGND sg13cmos5l_decap_4
X_09666_ _09748_/A _09666_/A _09668_/B VPWR VGND sg13cmos5l_nand2_1
XFILLER_28_846 VPWR VGND sg13cmos5l_decap_4
X_06878_ _06879_/D _11688_/Q _11689_/Q _11690_/Q _06878_/D VPWR VGND sg13cmos5l_nor4_1
XFILLER_55_654 VPWR VGND sg13cmos5l_decap_8
X_08617_ _08617_/Y _11391_/Q _08616_/B _08627_/C VPWR VGND sg13cmos5l_o21ai_1
XFILLER_27_378 VPWR VGND sg13cmos5l_decap_8
XFILLER_91_28 VPWR VGND sg13cmos5l_decap_8
XFILLER_70_624 VPWR VGND sg13cmos5l_fill_2
XFILLER_43_849 VPWR VGND sg13cmos5l_fill_2
X_09597_ _09603_/B _09593_/Y _09594_/Y _09595_/Y _09596_/Y _06474_/A VPWR VGND sg13cmos5l_a221oi_1
X_08548_ _11358_/D fanout76/X _08569_/B _08547_/Y VPWR VGND sg13cmos5l_a21oi_1
XFILLER_70_679 VPWR VGND sg13cmos5l_fill_2
XFILLER_70_657 VPWR VGND sg13cmos5l_fill_1
XFILLER_42_359 VPWR VGND sg13cmos5l_fill_1
XFILLER_23_551 VPWR VGND sg13cmos5l_decap_8
X_08479_ _11324_/D fanout81/X _08478_/B _08478_/Y VPWR VGND sg13cmos5l_o21ai_1
XFILLER_11_702 VPWR VGND sg13cmos5l_decap_8
XFILLER_24_66 VPWR VGND sg13cmos5l_fill_2
XFILLER_50_392 VPWR VGND sg13cmos5l_fill_1
X_10510_ _10511_/B _10507_/Y _10508_/Y _10560_/A VPWR VGND sg13cmos5l_a21oi_1
X_11490_ _11490_/Q clkload18/A _11490_/D _11490_/RESET_B VPWR VGND sg13cmos5l_dfrbpq_1
XFILLER_11_735 VPWR VGND sg13cmos5l_decap_8
XFILLER_23_595 VPWR VGND sg13cmos5l_fill_1
X_10441_ _10441_/X _07007_/A _10235_/Y _10441_/B1 VPWR VGND sg13cmos5l_a21o_1
XFILLER_6_238 VPWR VGND sg13cmos5l_decap_8
X_10372_ _10376_/B _10694_/A _10366_/Y _10371_/Y VPWR VGND sg13cmos5l_o21ai_1
X_10831__1180 _10831_/RESET_B VPWR VGND sg13cmos5l_tiehi
XFILLER_3_945 VPWR VGND sg13cmos5l_fill_1
XFILLER_2_400 VPWR VGND sg13cmos5l_fill_1
XFILLER_105_862 VPWR VGND sg13cmos5l_decap_8
XFILLER_2_488 VPWR VGND sg13cmos5l_decap_8
XFILLER_78_757 VPWR VGND sg13cmos5l_fill_1
X_11450__1390 _11450_/RESET_B VPWR VGND sg13cmos5l_tiehi
Xfanout792 _07076_/B hold2848/X VPWR VGND sg13cmos5l_buf_1
Xfanout781 _09456_/A _09335_/A VPWR VGND sg13cmos5l_buf_1
Xfanout770 _09557_/A hold2878/X VPWR VGND sg13cmos5l_buf_1
XFILLER_105_91 VPWR VGND sg13cmos5l_decap_8
XFILLER_58_492 VPWR VGND sg13cmos5l_fill_2
XFILLER_46_621 VPWR VGND sg13cmos5l_decap_4
XFILLER_18_323 VPWR VGND sg13cmos5l_decap_8
XFILLER_18_334 VPWR VGND sg13cmos5l_fill_2
XFILLER_46_676 VPWR VGND sg13cmos5l_decap_8
XFILLER_19_868 VPWR VGND sg13cmos5l_fill_1
X_11099__1802 _11099_/RESET_B VPWR VGND sg13cmos5l_tiehi
XFILLER_33_337 VPWR VGND sg13cmos5l_decap_8
X_11757_ _11757_/Q clkload24/A _11757_/D _11757_/RESET_B VPWR VGND sg13cmos5l_dfrbpq_1
X_10708_ _10709_/C _06092_/A _06080_/C _10696_/A VPWR VGND sg13cmos5l_a21oi_1
X_11688_ _11688_/Q clkload25/A _11688_/D _11688_/RESET_B VPWR VGND sg13cmos5l_dfrbpq_1
X_10639_ _10640_/B _10639_/A _10652_/A VPWR VGND sg13cmos5l_nor2_1
XFILLER_53_4 VPWR VGND sg13cmos5l_decap_4
XFILLER_5_293 VPWR VGND sg13cmos5l_fill_1
Xhold2608 _10749_/C _10748_/Y VPWR VGND sg13cmos5l_dlygate4sd3_1
Xhold2619 hold2619/X _11420_/Q VPWR VGND sg13cmos5l_dlygate4sd3_1
X_07850_ _07850_/Y _07850_/A _07850_/B VPWR VGND sg13cmos5l_nand2_1
XFILLER_69_779 VPWR VGND sg13cmos5l_decap_8
XFILLER_69_768 VPWR VGND sg13cmos5l_decap_8
Xhold1907 _07798_/A _10991_/Q VPWR VGND sg13cmos5l_dlygate4sd3_1
Xhold1918 _08188_/A _11181_/Q VPWR VGND sg13cmos5l_dlygate4sd3_1
X_07781_ _10983_/D fanout53/X _07780_/B _07780_/Y VPWR VGND sg13cmos5l_a21oi_1
X_06801_ _06801_/Y _06825_/A _06801_/B VPWR VGND sg13cmos5l_nand2_1
Xhold1929 _08342_/A _11257_/Q VPWR VGND sg13cmos5l_dlygate4sd3_1
Xinput3 input3/X ui_in[10] VPWR VGND sg13cmos5l_buf_1
XFILLER_37_632 VPWR VGND sg13cmos5l_decap_8
XFILLER_37_621 VPWR VGND sg13cmos5l_fill_2
X_09520_ _09526_/B _09516_/Y _09517_/Y _09518_/Y _09519_/Y _09846_/A1 VPWR VGND sg13cmos5l_a221oi_1
X_06732_ _06735_/B _06732_/A _06732_/B VPWR VGND sg13cmos5l_nand2_1
XFILLER_91_270 VPWR VGND sg13cmos5l_fill_2
X_09451_ _09451_/Y _09448_/Y _09450_/Y _09579_/B2 VPWR VGND sg13cmos5l_o21ai_1
X_06663_ _06664_/B _06662_/A _06670_/B _06662_/Y VPWR VGND sg13cmos5l_o21ai_1
XFILLER_101_49 VPWR VGND sg13cmos5l_decap_8
X_06594_ _10796_/D _06346_/B _06592_/Y _06593_/Y VPWR VGND sg13cmos5l_o21ai_1
X_08402_ _11286_/D _08532_/A1 _08401_/B _08401_/Y VPWR VGND sg13cmos5l_a21oi_1
XFILLER_24_348 VPWR VGND sg13cmos5l_decap_4
X_09382_ _09382_/Y _09944_/A _09382_/B VPWR VGND sg13cmos5l_nand2_1
X_08333_ _11252_/D _08333_/A1 _08332_/B _08332_/Y VPWR VGND sg13cmos5l_o21ai_1
XFILLER_60_690 VPWR VGND sg13cmos5l_fill_1
X_08264_ _11218_/D _08329_/A1 _08267_/B _08263_/Y VPWR VGND sg13cmos5l_a21oi_1
XFILLER_32_370 VPWR VGND sg13cmos5l_decap_4
XFILLER_32_392 VPWR VGND sg13cmos5l_decap_8
XFILLER_20_576 VPWR VGND sg13cmos5l_decap_8
X_07215_ _07215_/Y _08889_/A _05946_/A _07227_/B1 hold2772/X _07225_/C1 VPWR VGND
+ sg13cmos5l_a221oi_1
X_08195_ _11184_/D _08520_/A1 _08198_/B _08194_/Y VPWR VGND sg13cmos5l_o21ai_1
XFILLER_20_587 VPWR VGND sg13cmos5l_fill_1
X_07146_ _11738_/D _05884_/Y _07148_/A2 _07145_/Y VPWR VGND sg13cmos5l_a21oi_1
XFILLER_3_208 VPWR VGND sg13cmos5l_decap_8
XFILLER_106_637 VPWR VGND sg13cmos5l_decap_8
X_07077_ _07077_/X _07077_/A _10166_/A VPWR VGND sg13cmos5l_and2_1
XFILLER_3_219 VPWR VGND sg13cmos5l_fill_2
XFILLER_105_147 VPWR VGND sg13cmos5l_decap_8
X_06028_ _06030_/B _11554_/Q _11553_/Q VPWR VGND sg13cmos5l_nor2_1
X_11177__1724 _11177_/RESET_B VPWR VGND sg13cmos5l_tiehi
XFILLER_86_28 VPWR VGND sg13cmos5l_decap_8
XFILLER_0_915 VPWR VGND sg13cmos5l_decap_8
XFILLER_19_109 VPWR VGND sg13cmos5l_fill_1
XFILLER_101_397 VPWR VGND sg13cmos5l_fill_2
X_07979_ _11079_/D fanout54/X _07978_/B _07978_/Y VPWR VGND sg13cmos5l_o21ai_1
X_09718_ _09718_/Y _09712_/Y _09713_/Y _09717_/Y _09851_/B2 VPWR VGND sg13cmos5l_a22oi_1
X_11706__1258 _11706_/RESET_B VPWR VGND sg13cmos5l_tiehi
XFILLER_56_985 VPWR VGND sg13cmos5l_decap_4
X_10990_ _10990_/Q clkload34/A _10990_/D _10990_/RESET_B VPWR VGND sg13cmos5l_dfrbpq_1
XFILLER_16_805 VPWR VGND sg13cmos5l_decap_4
XFILLER_76_1015 VPWR VGND sg13cmos5l_decap_4
XFILLER_43_613 VPWR VGND sg13cmos5l_decap_8
X_09649_ _09649_/Y _09649_/A _09649_/B VPWR VGND sg13cmos5l_nor2_1
X_11611_ _11611_/Q clkload30/A _11611_/D _11611_/RESET_B VPWR VGND sg13cmos5l_dfrbpq_1
X_11427__1436 _11427_/RESET_B VPWR VGND sg13cmos5l_tiehi
X_11478__1227 _11478_/RESET_B VPWR VGND sg13cmos5l_tiehi
XFILLER_42_189 VPWR VGND sg13cmos5l_decap_4
XFILLER_11_510 VPWR VGND sg13cmos5l_fill_2
XFILLER_30_329 VPWR VGND sg13cmos5l_fill_2
X_11542_ _11542_/Q clkload48/A _11542_/D _11542_/RESET_B VPWR VGND sg13cmos5l_dfrbpq_1
X_11473_ _11473_/Q clkload37/A _11473_/D _11473_/RESET_B VPWR VGND sg13cmos5l_dfrbpq_1
XFILLER_100_1013 VPWR VGND sg13cmos5l_decap_8
X_10424_ _10427_/B _10424_/A _10424_/B VPWR VGND sg13cmos5l_nand2_1
XFILLER_3_720 VPWR VGND sg13cmos5l_fill_2
XFILLER_98_808 VPWR VGND sg13cmos5l_decap_4
XFILLER_83_1008 VPWR VGND sg13cmos5l_decap_8
X_10355_ _10355_/Y _10365_/B _10353_/Y _10354_/Y VPWR VGND sg13cmos5l_o21ai_1
XFILLER_105_670 VPWR VGND sg13cmos5l_decap_8
X_10286_ _10309_/B _10286_/A _10286_/B VPWR VGND sg13cmos5l_xnor2_1
XFILLER_2_263 VPWR VGND sg13cmos5l_fill_1
XFILLER_78_554 VPWR VGND sg13cmos5l_fill_1
XFILLER_78_543 VPWR VGND sg13cmos5l_fill_1
XFILLER_39_919 VPWR VGND sg13cmos5l_fill_1
XFILLER_2_285 VPWR VGND sg13cmos5l_fill_1
XFILLER_25_8 VPWR VGND sg13cmos5l_fill_2
XFILLER_76_50 VPWR VGND sg13cmos5l_fill_1
XFILLER_66_738 VPWR VGND sg13cmos5l_decap_4
XFILLER_93_546 VPWR VGND sg13cmos5l_fill_2
X_10966__1016 _10966_/RESET_B VPWR VGND sg13cmos5l_tiehi
XFILLER_19_665 VPWR VGND sg13cmos5l_decap_8
XFILLER_62_944 VPWR VGND sg13cmos5l_fill_1
XFILLER_62_933 VPWR VGND sg13cmos5l_decap_8
XFILLER_62_911 VPWR VGND sg13cmos5l_decap_8
XFILLER_46_495 VPWR VGND sg13cmos5l_decap_8
XFILLER_34_613 VPWR VGND sg13cmos5l_decap_8
XFILLER_34_624 VPWR VGND sg13cmos5l_fill_1
XFILLER_33_134 VPWR VGND sg13cmos5l_fill_2
XFILLER_61_487 VPWR VGND sg13cmos5l_fill_2
XFILLER_21_329 VPWR VGND sg13cmos5l_fill_2
X_11255__1646 _11255_/RESET_B VPWR VGND sg13cmos5l_tiehi
X_07000_ _07000_/Y _06998_/Y _06999_/Y _07062_/S VPWR VGND sg13cmos5l_a21oi_1
XFILLER_89_819 VPWR VGND sg13cmos5l_fill_1
X_08951_ _08952_/B _08960_/A _08942_/B _08937_/Y VPWR VGND sg13cmos5l_o21ai_1
Xhold2427 _08379_/A _11275_/Q VPWR VGND sg13cmos5l_dlygate4sd3_1
X_08882_ _08882_/Y _08882_/A _08895_/B VPWR VGND sg13cmos5l_nand2_1
Xhold2405 _07742_/A _10964_/Q VPWR VGND sg13cmos5l_dlygate4sd3_1
X_07902_ _11041_/D fanout67/X _07901_/B _07901_/Y VPWR VGND sg13cmos5l_a21oi_1
Xhold2416 _07038_/A _11671_/Q VPWR VGND sg13cmos5l_dlygate4sd3_1
XFILLER_97_896 VPWR VGND sg13cmos5l_decap_8
XFILLER_96_362 VPWR VGND sg13cmos5l_decap_4
XFILLER_96_351 VPWR VGND sg13cmos5l_fill_1
X_07833_ _11008_/D fanout73/X _07836_/B _07832_/Y VPWR VGND sg13cmos5l_o21ai_1
Xhold2438 _06850_/A _11616_/Q VPWR VGND sg13cmos5l_dlygate4sd3_1
Xhold2449 hold2449/X _11629_/Q VPWR VGND sg13cmos5l_dlygate4sd3_1
XFILLER_5_1008 VPWR VGND sg13cmos5l_decap_8
XFILLER_99_1026 VPWR VGND sg13cmos5l_fill_2
X_07764_ _07764_/Y _07764_/A _07770_/B VPWR VGND sg13cmos5l_nor2_1
XFILLER_37_451 VPWR VGND sg13cmos5l_fill_1
XFILLER_37_484 VPWR VGND sg13cmos5l_decap_8
X_07695_ _10941_/D fanout79/X _07694_/B _07694_/Y VPWR VGND sg13cmos5l_a21oi_1
X_09503_ _09504_/B _09395_/A _09498_/X _09502_/Y VPWR VGND sg13cmos5l_o21ai_1
X_06715_ _06715_/Y _06719_/B _06665_/B _06732_/B _06713_/A _06714_/Y VPWR VGND sg13cmos5l_a221oi_1
XFILLER_80_752 VPWR VGND sg13cmos5l_fill_1
XFILLER_53_966 VPWR VGND sg13cmos5l_fill_1
X_06646_ _06647_/B _06646_/A _06646_/B VPWR VGND sg13cmos5l_nor2_1
XFILLER_25_635 VPWR VGND sg13cmos5l_decap_8
X_09434_ _09434_/Y _10229_/A _09404_/B _09349_/C _09430_/Y VPWR VGND sg13cmos5l_a22oi_1
XFILLER_52_465 VPWR VGND sg13cmos5l_fill_2
XFILLER_40_627 VPWR VGND sg13cmos5l_decap_8
XFILLER_40_605 VPWR VGND sg13cmos5l_fill_1
X_06577_ _06577_/Y _06628_/B _06668_/A1 _06205_/A VPWR VGND sg13cmos5l_a21oi_1
X_09365_ _09365_/Y _11055_/Q _09606_/B VPWR VGND sg13cmos5l_nand2_1
X_09296_ _09296_/Y _09289_/Y _09291_/Y _09295_/Y _09994_/A1 VPWR VGND sg13cmos5l_a22oi_1
X_08316_ _08316_/Y _08316_/A _08358_/B VPWR VGND sg13cmos5l_nand2_1
X_08247_ _08247_/Y _08247_/A _08299_/B VPWR VGND sg13cmos5l_nor2_1
XFILLER_21_34 VPWR VGND sg13cmos5l_fill_2
X_08178_ _11176_/D fanout52/X _08177_/B _08177_/Y VPWR VGND sg13cmos5l_a21oi_1
XFILLER_4_517 VPWR VGND sg13cmos5l_fill_1
XFILLER_106_434 VPWR VGND sg13cmos5l_decap_8
X_11300__1601 _11300_/RESET_B VPWR VGND sg13cmos5l_tiehi
X_07129_ _07129_/Y hold2847/X _07130_/A2 _07163_/B1 VPWR VGND sg13cmos5l_o21ai_1
XFILLER_97_49 VPWR VGND sg13cmos5l_decap_8
XFILLER_79_318 VPWR VGND sg13cmos5l_fill_2
X_10140_ _10140_/Y _10140_/A _10604_/B VPWR VGND sg13cmos5l_nor2_1
XFILLER_88_841 VPWR VGND sg13cmos5l_decap_8
X_10071_ _10071_/Y _06523_/A _09375_/Y _10070_/X VPWR VGND sg13cmos5l_o21ai_1
XFILLER_88_896 VPWR VGND sg13cmos5l_fill_2
XFILLER_47_204 VPWR VGND sg13cmos5l_decap_8
XFILLER_0_778 VPWR VGND sg13cmos5l_decap_4
Xhold2950 _11467_/D _09541_/Y VPWR VGND sg13cmos5l_dlygate4sd3_1
XFILLER_101_161 VPWR VGND sg13cmos5l_decap_8
XFILLER_48_749 VPWR VGND sg13cmos5l_decap_8
X_11333__1568 _11333_/RESET_B VPWR VGND sg13cmos5l_tiehi
XFILLER_46_20 VPWR VGND sg13cmos5l_decap_8
XFILLER_29_963 VPWR VGND sg13cmos5l_decap_4
XFILLER_90_527 VPWR VGND sg13cmos5l_decap_4
XFILLER_62_207 VPWR VGND sg13cmos5l_fill_2
X_10973_ _10973_/Q clkload41/A _10973_/D _10973_/RESET_B VPWR VGND sg13cmos5l_dfrbpq_1
XFILLER_29_996 VPWR VGND sg13cmos5l_fill_1
XFILLER_71_741 VPWR VGND sg13cmos5l_fill_1
XFILLER_71_730 VPWR VGND sg13cmos5l_fill_2
XFILLER_43_421 VPWR VGND sg13cmos5l_decap_4
XFILLER_102_70 VPWR VGND sg13cmos5l_decap_8
XFILLER_31_616 VPWR VGND sg13cmos5l_decap_8
XFILLER_43_498 VPWR VGND sg13cmos5l_decap_8
X_11525_ _11525_/Q clkload18/A _11525_/D _11525_/RESET_B VPWR VGND sg13cmos5l_dfrbpq_1
XFILLER_7_14 VPWR VGND sg13cmos5l_decap_8
X_11456_ _11456_/Q clkload21/A _11456_/D _11456_/RESET_B VPWR VGND sg13cmos5l_dfrbpq_1
X_11387_ _11387_/Q clkload19/A _11387_/D _11387_/RESET_B VPWR VGND sg13cmos5l_dfrbpq_1
X_10407_ _10408_/C _10407_/A _10422_/B _10422_/C _10422_/D VPWR VGND sg13cmos5l_nand4_1
X_10338_ _10342_/B _10707_/C _10338_/B _10338_/C VPWR VGND sg13cmos5l_nand3_1
XFILLER_3_561 VPWR VGND sg13cmos5l_fill_1
XFILLER_3_550 VPWR VGND sg13cmos5l_decap_8
XFILLER_97_159 VPWR VGND sg13cmos5l_decap_4
XFILLER_94_800 VPWR VGND sg13cmos5l_fill_1
XFILLER_87_82 VPWR VGND sg13cmos5l_decap_4
X_10269_ _10269_/Y _10267_/B _10434_/A _10267_/D _10436_/B2 VPWR VGND sg13cmos5l_a22oi_1
XFILLER_66_513 VPWR VGND sg13cmos5l_fill_2
XFILLER_38_259 VPWR VGND sg13cmos5l_fill_2
XFILLER_19_451 VPWR VGND sg13cmos5l_fill_2
X_11309__1592 _11309_/RESET_B VPWR VGND sg13cmos5l_tiehi
XFILLER_81_549 VPWR VGND sg13cmos5l_decap_8
XFILLER_62_741 VPWR VGND sg13cmos5l_decap_4
X_06500_ _06500_/Y _05954_/Y _06512_/B _09553_/B1 _06499_/Y VPWR VGND sg13cmos5l_a22oi_1
X_07480_ _07480_/Y _07493_/A _07500_/D VPWR VGND sg13cmos5l_nor2_1
XFILLER_50_903 VPWR VGND sg13cmos5l_fill_1
XFILLER_22_605 VPWR VGND sg13cmos5l_fill_1
X_06431_ _06432_/B _10658_/A _06420_/C _06332_/Y VPWR VGND sg13cmos5l_o21ai_1
XFILLER_62_796 VPWR VGND sg13cmos5l_decap_8
X_09150_ _09151_/B _09150_/A _09150_/B VPWR VGND sg13cmos5l_xnor2_1
X_06362_ _06363_/B _06362_/A _06674_/A VPWR VGND sg13cmos5l_nor2_1
X_08101_ _11139_/D fanout62/X _08112_/B _08100_/Y VPWR VGND sg13cmos5l_o21ai_1
X_09081_ _09081_/Y _09079_/Y _09080_/Y _09106_/B1 VPWR VGND sg13cmos5l_o21ai_1
X_06293_ _06293_/Y _11496_/Q _09205_/A VPWR VGND sg13cmos5l_nand2b_1
X_08032_ _11105_/D fanout67/X _08031_/B _08031_/Y VPWR VGND sg13cmos5l_a21oi_1
X_11411__1468 _11411_/RESET_B VPWR VGND sg13cmos5l_tiehi
X_09983_ _09989_/B _09979_/Y _09980_/Y _09981_/Y _09982_/Y _09983_/C1 VPWR VGND sg13cmos5l_a221oi_1
Xhold2202 _08281_/A _11227_/Q VPWR VGND sg13cmos5l_dlygate4sd3_1
X_08934_ _08934_/Y _08921_/A _08931_/A _08946_/B1 VPWR VGND sg13cmos5l_o21ai_1
XFILLER_97_660 VPWR VGND sg13cmos5l_decap_8
Xhold2235 _08429_/A _11300_/Q VPWR VGND sg13cmos5l_dlygate4sd3_1
Xhold2224 _07871_/A _11026_/Q VPWR VGND sg13cmos5l_dlygate4sd3_1
Xhold2213 _08137_/A _11156_/Q VPWR VGND sg13cmos5l_dlygate4sd3_1
Xhold2246 _07754_/A _10970_/Q VPWR VGND sg13cmos5l_dlygate4sd3_1
Xhold2257 _11766_/D _06110_/Y VPWR VGND sg13cmos5l_dlygate4sd3_1
X_08865_ _08867_/B _08876_/A _08890_/D VPWR VGND sg13cmos5l_nor2_1
Xhold2268 _08395_/A _11283_/Q VPWR VGND sg13cmos5l_dlygate4sd3_1
Xhold2279 _08385_/A _11278_/Q VPWR VGND sg13cmos5l_dlygate4sd3_1
X_08796_ _08806_/B _08817_/A _08817_/B VPWR VGND sg13cmos5l_and2_1
X_07816_ _07816_/Y _07816_/A _07820_/B VPWR VGND sg13cmos5l_nand2_1
XFILLER_83_18 VPWR VGND sg13cmos5l_fill_1
X_07747_ _10966_/D _08075_/A1 _07746_/B _07746_/Y VPWR VGND sg13cmos5l_a21oi_1
XFILLER_26_933 VPWR VGND sg13cmos5l_decap_4
XFILLER_53_752 VPWR VGND sg13cmos5l_decap_8
XFILLER_25_432 VPWR VGND sg13cmos5l_fill_1
X_07678_ _07678_/Y _07678_/A _07694_/B VPWR VGND sg13cmos5l_nor2_1
XFILLER_40_424 VPWR VGND sg13cmos5l_decap_8
XFILLER_12_104 VPWR VGND sg13cmos5l_fill_1
X_09417_ _09417_/Y _11089_/Q _09417_/B VPWR VGND sg13cmos5l_nand2_1
X_06629_ _06629_/Y _06183_/Y _06400_/B _06614_/A _06353_/C _06628_/Y VPWR VGND sg13cmos5l_a221oi_1
X_09348_ _09349_/C _09348_/A _09456_/B VPWR VGND sg13cmos5l_nand2_1
X_09279_ _09281_/B _11616_/Q _11611_/Q _09302_/A VPWR VGND sg13cmos5l_nor3_1
XFILLER_5_804 VPWR VGND sg13cmos5l_fill_2
X_11310_ _11310_/Q clkload16/A _11310_/D _11310_/RESET_B VPWR VGND sg13cmos5l_dfrbpq_1
XFILLER_4_325 VPWR VGND sg13cmos5l_fill_2
XFILLER_106_231 VPWR VGND sg13cmos5l_decap_8
X_11241_ _11241_/Q clkload50/A _11241_/D _11241_/RESET_B VPWR VGND sg13cmos5l_dfrbpq_1
X_11172_ _11172_/Q _11339_/CLK _11172_/D _11172_/RESET_B VPWR VGND sg13cmos5l_dfrbpq_1
XFILLER_79_137 VPWR VGND sg13cmos5l_decap_8
X_10123_ _10123_/Y _10123_/A _10123_/B VPWR VGND sg13cmos5l_nand2_1
XFILLER_0_531 VPWR VGND sg13cmos5l_fill_1
X_11541__1491 _11541_/RESET_B VPWR VGND sg13cmos5l_tiehi
XFILLER_103_982 VPWR VGND sg13cmos5l_decap_8
X_10054_ _10055_/C _09968_/Y _09998_/Y _10053_/Y VPWR VGND sg13cmos5l_o21ai_1
XFILLER_75_310 VPWR VGND sg13cmos5l_fill_2
XFILLER_0_575 VPWR VGND sg13cmos5l_fill_1
XFILLER_87_192 VPWR VGND sg13cmos5l_fill_2
Xhold2791 hold2791/X _06922_/Y VPWR VGND sg13cmos5l_dlygate4sd3_1
XFILLER_76_888 VPWR VGND sg13cmos5l_decap_4
Xhold2780 hold2780/X _11396_/Q VPWR VGND sg13cmos5l_dlygate4sd3_1
Xheichips26_RiMaX_841 uio_out[2] VPWR VGND sg13cmos5l_tielo
XFILLER_63_538 VPWR VGND sg13cmos5l_fill_1
XFILLER_29_771 VPWR VGND sg13cmos5l_decap_8
XFILLER_75_398 VPWR VGND sg13cmos5l_decap_4
XFILLER_28_292 VPWR VGND sg13cmos5l_fill_2
XFILLER_73_73 VPWR VGND sg13cmos5l_fill_1
XFILLER_44_752 VPWR VGND sg13cmos5l_fill_2
X_10956_ _10956_/Q _11352_/CLK _10956_/D _10956_/RESET_B VPWR VGND sg13cmos5l_dfrbpq_1
XFILLER_31_402 VPWR VGND sg13cmos5l_fill_2
XFILLER_73_84 VPWR VGND sg13cmos5l_fill_2
XFILLER_44_796 VPWR VGND sg13cmos5l_decap_8
XFILLER_16_487 VPWR VGND sg13cmos5l_fill_2
X_10887_ _10887_/Q clkload12/A _10887_/D _10887_/RESET_B VPWR VGND sg13cmos5l_dfrbpq_1
XFILLER_31_468 VPWR VGND sg13cmos5l_fill_1
XFILLER_85_7 VPWR VGND sg13cmos5l_decap_8
XFILLER_31_479 VPWR VGND sg13cmos5l_decap_8
XFILLER_89_1014 VPWR VGND sg13cmos5l_decap_8
XFILLER_7_141 VPWR VGND sg13cmos5l_decap_8
XFILLER_7_130 VPWR VGND sg13cmos5l_fill_1
X_11508_ _11508_/Q clkload48/A _11508_/D _11508_/RESET_B VPWR VGND sg13cmos5l_dfrbpq_1
XFILLER_8_686 VPWR VGND sg13cmos5l_fill_1
X_11439_ _11439_/Q clkload36/A _11439_/D _11439_/RESET_B VPWR VGND sg13cmos5l_dfrbpq_1
XFILLER_98_70 VPWR VGND sg13cmos5l_decap_8
XFILLER_101_908 VPWR VGND sg13cmos5l_decap_8
XFILLER_98_479 VPWR VGND sg13cmos5l_fill_1
X_11701__1263 _11701_/RESET_B VPWR VGND sg13cmos5l_tiehi
X_06980_ _06980_/Y _06978_/Y _06979_/Y _07050_/B1 VPWR VGND sg13cmos5l_a21oi_1
XFILLER_85_129 VPWR VGND sg13cmos5l_decap_4
XFILLER_79_671 VPWR VGND sg13cmos5l_decap_8
X_05931_ _07008_/A _11487_/Q VPWR VGND sg13cmos5l_inv_1
X_08650_ _08650_/Y _10177_/A _10704_/B VPWR VGND sg13cmos5l_nand2_1
X_05862_ _05862_/Y _08611_/A VPWR VGND sg13cmos5l_inv_1
XFILLER_67_877 VPWR VGND sg13cmos5l_decap_8
XFILLER_66_332 VPWR VGND sg13cmos5l_fill_2
X_07601_ _10913_/D _07595_/B fanout67/X _07595_/Y VPWR VGND sg13cmos5l_a21oi_1
X_08581_ _08581_/Y _11338_/Q _08588_/B VPWR VGND sg13cmos5l_nand2_1
XFILLER_47_590 VPWR VGND sg13cmos5l_decap_8
XFILLER_62_560 VPWR VGND sg13cmos5l_fill_2
X_07532_ _10903_/D _07526_/B _08339_/A1 _07526_/Y VPWR VGND sg13cmos5l_a21oi_1
XFILLER_90_880 VPWR VGND sg13cmos5l_fill_2
X_07463_ _07463_/X _11523_/Q _10798_/Q _07497_/A VPWR VGND sg13cmos5l_mux2_1
XFILLER_22_413 VPWR VGND sg13cmos5l_decap_8
XFILLER_22_435 VPWR VGND sg13cmos5l_decap_8
X_06414_ _06416_/B _06760_/S _06411_/Y _06413_/Y VPWR VGND sg13cmos5l_a21oi_1
X_09202_ _09488_/A _09202_/A _10839_/Q VPWR VGND sg13cmos5l_xnor2_1
X_09133_ _09133_/Y _09130_/Y _09131_/Y _09132_/Y VPWR VGND sg13cmos5l_a21oi_1
X_07394_ _07394_/Y _06321_/B _07400_/A2 _07393_/Y VPWR VGND sg13cmos5l_a21oi_1
XFILLER_33_1013 VPWR VGND sg13cmos5l_fill_2
X_06345_ _06588_/C _11488_/Q _07077_/A _11487_/Q _07076_/B VPWR VGND sg13cmos5l_a22oi_1
X_09064_ _09064_/Y _09052_/A _09068_/B _09064_/B1 VPWR VGND sg13cmos5l_o21ai_1
X_06276_ _06276_/Y _11489_/Q _09189_/A VPWR VGND sg13cmos5l_nor2b_1
X_08015_ _08015_/Y _08015_/A _08023_/B VPWR VGND sg13cmos5l_nor2_1
XFILLER_2_829 VPWR VGND sg13cmos5l_decap_8
XFILLER_2_818 VPWR VGND sg13cmos5l_decap_8
X_10961__1021 _10961_/RESET_B VPWR VGND sg13cmos5l_tiehi
XFILLER_103_245 VPWR VGND sg13cmos5l_decap_8
X_09966_ _09967_/B _09902_/A _09961_/X _09965_/Y VPWR VGND sg13cmos5l_o21ai_1
Xhold2021 _07842_/A _11013_/Q VPWR VGND sg13cmos5l_dlygate4sd3_1
Xhold2010 _08318_/A _11245_/Q VPWR VGND sg13cmos5l_dlygate4sd3_1
X_09897_ _09897_/Y _10915_/Q _09894_/B _10042_/B1 VPWR VGND sg13cmos5l_a21oi_1
XFILLER_57_310 VPWR VGND sg13cmos5l_fill_2
X_08917_ _08931_/B _08930_/A _08930_/B _08930_/D VPWR VGND sg13cmos5l_nor3_1
Xhold2054 _07926_/A _11053_/Q VPWR VGND sg13cmos5l_dlygate4sd3_1
Xhold2032 _08068_/A _11123_/Q VPWR VGND sg13cmos5l_dlygate4sd3_1
Xhold2043 _08070_/A _11124_/Q VPWR VGND sg13cmos5l_dlygate4sd3_1
XFILLER_94_28 VPWR VGND sg13cmos5l_decap_8
Xhold2087 _10791_/A _11595_/Q VPWR VGND sg13cmos5l_dlygate4sd3_1
Xhold2065 _09042_/A _11446_/Q VPWR VGND sg13cmos5l_dlygate4sd3_1
X_08848_ _08848_/Y _11382_/Q _08849_/B VPWR VGND sg13cmos5l_nor2_1
XFILLER_40_1028 VPWR VGND sg13cmos5l_fill_1
Xhold2076 _06970_/A _11654_/Q VPWR VGND sg13cmos5l_dlygate4sd3_1
XFILLER_100_985 VPWR VGND sg13cmos5l_decap_8
XFILLER_58_888 VPWR VGND sg13cmos5l_decap_8
XFILLER_57_387 VPWR VGND sg13cmos5l_fill_1
Xhold2098 _07664_/A _10926_/Q VPWR VGND sg13cmos5l_dlygate4sd3_1
XFILLER_73_858 VPWR VGND sg13cmos5l_decap_8
XFILLER_72_324 VPWR VGND sg13cmos5l_decap_4
X_08779_ _08780_/A _08819_/A _08817_/A _08832_/A1 VPWR VGND sg13cmos5l_o21ai_1
X_11250__1651 _11250_/RESET_B VPWR VGND sg13cmos5l_tiehi
XFILLER_14_903 VPWR VGND sg13cmos5l_decap_4
X_10810_ _10810_/Q clkload38/A _10810_/D _10810_/RESET_B VPWR VGND sg13cmos5l_dfrbpq_1
XFILLER_27_88 VPWR VGND sg13cmos5l_decap_4
X_10741_ _10747_/B _10748_/A _10748_/B VPWR VGND sg13cmos5l_nor2_1
XFILLER_81_880 VPWR VGND sg13cmos5l_decap_8
XFILLER_14_936 VPWR VGND sg13cmos5l_decap_4
XFILLER_14_947 VPWR VGND sg13cmos5l_decap_8
XFILLER_26_785 VPWR VGND sg13cmos5l_decap_8
XFILLER_41_744 VPWR VGND sg13cmos5l_fill_2
X_11079__846 _11079_/RESET_B VPWR VGND sg13cmos5l_tiehi
X_10672_ _10673_/B _10672_/A _10672_/B VPWR VGND sg13cmos5l_xnor2_1
XFILLER_43_87 VPWR VGND sg13cmos5l_fill_2
Xclkbuf_leaf_20_clk _11622_/CLK clkload2/A VPWR VGND sg13cmos5l_buf_8
XFILLER_5_601 VPWR VGND sg13cmos5l_fill_2
XFILLER_5_656 VPWR VGND sg13cmos5l_decap_4
XFILLER_4_133 VPWR VGND sg13cmos5l_decap_8
XFILLER_4_100 VPWR VGND sg13cmos5l_decap_8
X_11224_ _11224_/Q clkload37/A _11224_/D _11224_/RESET_B VPWR VGND sg13cmos5l_dfrbpq_1
XFILLER_4_48 VPWR VGND sg13cmos5l_fill_1
X_11155_ _11155_/Q clkload10/A _11155_/D _11155_/RESET_B VPWR VGND sg13cmos5l_dfrbpq_1
XFILLER_95_416 VPWR VGND sg13cmos5l_decap_4
X_11086_ _11086_/Q _11347_/CLK _11086_/D _11086_/RESET_B VPWR VGND sg13cmos5l_dfrbpq_1
XFILLER_1_873 VPWR VGND sg13cmos5l_decap_4
X_10106_ _11503_/D _10426_/B1 _10115_/A2 _10105_/Y VPWR VGND sg13cmos5l_a21o_1
X_10037_ _10037_/Y _11048_/Q _10034_/B _10042_/B1 VPWR VGND sg13cmos5l_a21oi_1
XFILLER_0_383 VPWR VGND sg13cmos5l_fill_2
XFILLER_84_61 VPWR VGND sg13cmos5l_fill_2
XFILLER_29_590 VPWR VGND sg13cmos5l_fill_1
XFILLER_90_143 VPWR VGND sg13cmos5l_decap_8
X_11382__1516 _11382_/RESET_B VPWR VGND sg13cmos5l_tiehi
XFILLER_16_240 VPWR VGND sg13cmos5l_fill_1
XFILLER_17_774 VPWR VGND sg13cmos5l_decap_8
X_10939_ _10939_/Q _11355_/CLK _10939_/D _10939_/RESET_B VPWR VGND sg13cmos5l_dfrbpq_1
XFILLER_56_1024 VPWR VGND sg13cmos5l_decap_4
XFILLER_32_722 VPWR VGND sg13cmos5l_fill_2
XFILLER_31_265 VPWR VGND sg13cmos5l_decap_8
X_11113__1788 _11113_/RESET_B VPWR VGND sg13cmos5l_tiehi
Xclkbuf_leaf_11_clk clkload14/A clkbuf_4_1_0_clk/X VPWR VGND sg13cmos5l_buf_8
X_06130_ _06131_/B _12766_/A _11759_/Q VPWR VGND sg13cmos5l_nand2b_1
XFILLER_9_984 VPWR VGND sg13cmos5l_decap_8
X_06061_ _10694_/B _10161_/B _06933_/A _06060_/Y _09303_/A _09858_/B2 VPWR VGND sg13cmos5l_a221oi_1
X_11292__1609 _11292_/RESET_B VPWR VGND sg13cmos5l_tiehi
XFILLER_101_705 VPWR VGND sg13cmos5l_decap_4
X_09820_ _09820_/Y _09983_/C1 _09819_/X _10044_/A VPWR VGND sg13cmos5l_a21oi_1
XFILLER_99_777 VPWR VGND sg13cmos5l_decap_8
Xfanout407 _09932_/S1 _09573_/A1 VPWR VGND sg13cmos5l_buf_1
Xfanout429 _10042_/B1 _09982_/B1 VPWR VGND sg13cmos5l_buf_1
Xfanout418 _09990_/S1 _09791_/B1 VPWR VGND sg13cmos5l_buf_1
XFILLER_59_619 VPWR VGND sg13cmos5l_decap_8
XFILLER_98_298 VPWR VGND sg13cmos5l_fill_1
XFILLER_39_310 VPWR VGND sg13cmos5l_fill_2
X_06963_ _06963_/Y _06963_/A _07018_/B VPWR VGND sg13cmos5l_nand2_1
X_09751_ _09751_/Y _09751_/A _09751_/B _09751_/C VPWR VGND sg13cmos5l_nor3_1
XFILLER_95_950 VPWR VGND sg13cmos5l_decap_8
X_08702_ _08703_/A hold2769/X _08936_/B _08931_/A _08922_/A VPWR VGND sg13cmos5l_a22oi_1
XFILLER_39_343 VPWR VGND sg13cmos5l_fill_1
X_05914_ _09643_/A _09218_/A VPWR VGND sg13cmos5l_inv_1
XFILLER_104_49 VPWR VGND sg13cmos5l_decap_8
XFILLER_95_983 VPWR VGND sg13cmos5l_fill_2
XFILLER_95_972 VPWR VGND sg13cmos5l_fill_2
X_09682_ _09682_/Y _11003_/Q _09957_/B VPWR VGND sg13cmos5l_nand2_1
X_06894_ _06894_/X _11733_/Q hold2685/X _07091_/S VPWR VGND sg13cmos5l_mux2_1
XFILLER_55_825 VPWR VGND sg13cmos5l_fill_2
XFILLER_54_302 VPWR VGND sg13cmos5l_decap_4
XFILLER_39_376 VPWR VGND sg13cmos5l_decap_8
XFILLER_66_195 VPWR VGND sg13cmos5l_decap_8
X_08633_ _11380_/D _07094_/Y _07190_/B _08633_/S VPWR VGND sg13cmos5l_mux2_1
XFILLER_81_132 VPWR VGND sg13cmos5l_fill_1
X_08564_ _11366_/D fanout55/X _08563_/B _08563_/Y VPWR VGND sg13cmos5l_a21oi_1
XFILLER_70_839 VPWR VGND sg13cmos5l_decap_8
XFILLER_35_571 VPWR VGND sg13cmos5l_fill_2
X_07515_ _07515_/Y _07515_/A _07515_/B VPWR VGND sg13cmos5l_nand2_1
X_08495_ _11332_/D fanout59/X _08494_/B _08494_/Y VPWR VGND sg13cmos5l_o21ai_1
X_10979__1003 _10979_/RESET_B VPWR VGND sg13cmos5l_tiehi
X_07446_ _10890_/D _07640_/B _08508_/A1 _07441_/Y VPWR VGND sg13cmos5l_a21oi_1
Xfanout58 fanout58/X _07626_/Y VPWR VGND sg13cmos5l_buf_1
Xfanout69 _10422_/A _10583_/B VPWR VGND sg13cmos5l_buf_1
XFILLER_23_799 VPWR VGND sg13cmos5l_fill_1
X_07377_ _07377_/Y _07377_/A _07383_/B VPWR VGND sg13cmos5l_nor2_1
XFILLER_22_298 VPWR VGND sg13cmos5l_decap_8
X_06328_ _06328_/Y _06443_/A _10672_/A _06328_/C _06328_/D VPWR VGND sg13cmos5l_nand4_1
X_09116_ _11451_/D _09114_/Y _09115_/Y _09108_/Y VPWR VGND sg13cmos5l_o21ai_1
XFILLER_89_28 VPWR VGND sg13cmos5l_decap_8
X_09047_ _09047_/Y _09023_/Y _09046_/Y _09074_/A VPWR VGND sg13cmos5l_a21oi_1
X_06259_ _10611_/A _11513_/Q _09968_/A VPWR VGND sg13cmos5l_xnor2_1
X_11268__1633 _11268_/RESET_B VPWR VGND sg13cmos5l_tiehi
XFILLER_104_598 VPWR VGND sg13cmos5l_decap_8
XFILLER_89_287 VPWR VGND sg13cmos5l_fill_2
X_09949_ _09949_/Y _10006_/A _09949_/B _09949_/C VPWR VGND sg13cmos5l_nand3_1
Xclkbuf_leaf_69_clk _11671_/CLK clkbuf_4_2_0_clk/X VPWR VGND sg13cmos5l_buf_8
XFILLER_85_471 VPWR VGND sg13cmos5l_decap_8
XFILLER_38_76 VPWR VGND sg13cmos5l_fill_2
XFILLER_85_482 VPWR VGND sg13cmos5l_fill_1
XFILLER_45_335 VPWR VGND sg13cmos5l_fill_1
XFILLER_14_700 VPWR VGND sg13cmos5l_fill_1
XFILLER_54_97 VPWR VGND sg13cmos5l_fill_1
X_10724_ _10728_/C _10707_/A _11758_/Q _09283_/A VPWR VGND sg13cmos5l_o21ai_1
X_10655_ _10662_/B _10638_/Y _10651_/Y _10652_/X _10639_/A _10654_/Y VPWR VGND sg13cmos5l_a221oi_1
XFILLER_70_74 VPWR VGND sg13cmos5l_fill_2
XFILLER_9_269 VPWR VGND sg13cmos5l_decap_8
Xclkload17 clkload17/Y clkload17/A VPWR VGND sg13cmos5l_inv_1
XFILLER_10_950 VPWR VGND sg13cmos5l_decap_8
Xclkload28 clkload28/Y clkload28/A VPWR VGND sg13cmos5l_inv_2
X_10586_ _10588_/B _10592_/B _10579_/Y _10585_/Y VPWR VGND sg13cmos5l_a21oi_1
XFILLER_10_983 VPWR VGND sg13cmos5l_decap_8
Xclkload39 clkload39/X clkload39/A VPWR VGND sg13cmos5l_buf_8
XFILLER_55_8 VPWR VGND sg13cmos5l_fill_1
XFILLER_5_464 VPWR VGND sg13cmos5l_fill_2
XFILLER_96_714 VPWR VGND sg13cmos5l_decap_4
X_11207_ _11207_/Q _11364_/CLK _11207_/D _11207_/RESET_B VPWR VGND sg13cmos5l_dfrbpq_1
X_11138_ _11138_/Q clkload58/A _11138_/D _11138_/RESET_B VPWR VGND sg13cmos5l_dfrbpq_1
X_11507__1169 _11507_/RESET_B VPWR VGND sg13cmos5l_tiehi
XFILLER_84_909 VPWR VGND sg13cmos5l_fill_2
XFILLER_23_1012 VPWR VGND sg13cmos5l_decap_8
XFILLER_64_611 VPWR VGND sg13cmos5l_decap_8
XFILLER_49_663 VPWR VGND sg13cmos5l_fill_2
XFILLER_37_803 VPWR VGND sg13cmos5l_decap_8
X_11069_ _11069_/Q clkload42/A _11069_/D _11069_/RESET_B VPWR VGND sg13cmos5l_dfrbpq_1
Xclkbuf_leaf_0_clk _11668_/CLK clkbuf_4_0_0_clk/X VPWR VGND sg13cmos5l_buf_8
XFILLER_91_430 VPWR VGND sg13cmos5l_decap_8
XFILLER_48_184 VPWR VGND sg13cmos5l_decap_8
XFILLER_48_173 VPWR VGND sg13cmos5l_fill_2
XFILLER_37_869 VPWR VGND sg13cmos5l_fill_2
XFILLER_63_187 VPWR VGND sg13cmos5l_fill_1
XFILLER_63_165 VPWR VGND sg13cmos5l_decap_8
X_07300_ _07300_/Y _07311_/B _07298_/Y hold2274/X VPWR VGND sg13cmos5l_a21oi_1
XFILLER_60_872 VPWR VGND sg13cmos5l_decap_4
X_11346__1555 _11346_/RESET_B VPWR VGND sg13cmos5l_tiehi
X_08280_ _11226_/D fanout96/X _08285_/B _08279_/Y VPWR VGND sg13cmos5l_a21oi_1
X_07231_ _07232_/B _10122_/B _07237_/A2 _07243_/B1 _07172_/A VPWR VGND sg13cmos5l_a22oi_1
XFILLER_20_747 VPWR VGND sg13cmos5l_fill_1
X_07162_ _11746_/D _05875_/Y _07164_/A2 _07161_/Y VPWR VGND sg13cmos5l_a21oi_1
X_06113_ _06114_/C _06134_/A _06107_/S _06132_/B VPWR VGND sg13cmos5l_a21oi_1
XFILLER_106_819 VPWR VGND sg13cmos5l_decap_8
X_07093_ _07093_/Y _07093_/A _07093_/B VPWR VGND sg13cmos5l_nand2_1
X_06044_ _06045_/D _06044_/A _06144_/A _06044_/C VPWR VGND sg13cmos5l_nand3_1
Xfanout204 _08135_/B _08143_/B VPWR VGND sg13cmos5l_buf_1
Xfanout215 _08179_/B _08116_/Y VPWR VGND sg13cmos5l_buf_1
XFILLER_87_747 VPWR VGND sg13cmos5l_fill_2
X_09803_ _09803_/Y _09938_/A _09885_/B _09858_/B2 VPWR VGND sg13cmos5l_o21ai_1
XFILLER_59_416 VPWR VGND sg13cmos5l_decap_8
XFILLER_8_1028 VPWR VGND sg13cmos5l_fill_1
Xfanout226 _07881_/B _07883_/B VPWR VGND sg13cmos5l_buf_1
Xfanout237 _07748_/B fanout246/X VPWR VGND sg13cmos5l_buf_1
X_07995_ _07995_/Y _07995_/A _08007_/B VPWR VGND sg13cmos5l_nor2_1
Xfanout259 _08518_/A1 _08453_/A1 VPWR VGND sg13cmos5l_buf_1
Xfanout248 _07682_/B fanout256/X VPWR VGND sg13cmos5l_buf_1
XFILLER_101_568 VPWR VGND sg13cmos5l_fill_2
X_06946_ _06946_/Y _10691_/B _11617_/Q _11607_/Q _06946_/D VPWR VGND sg13cmos5l_nor4_1
XFILLER_68_994 VPWR VGND sg13cmos5l_fill_2
X_09734_ _09734_/Y _10941_/Q _09734_/B VPWR VGND sg13cmos5l_nand2_1
X_11069__856 _11069_/RESET_B VPWR VGND sg13cmos5l_tiehi
XFILLER_28_814 VPWR VGND sg13cmos5l_decap_8
XFILLER_28_825 VPWR VGND sg13cmos5l_fill_1
X_06877_ _06878_/D _10751_/A _11684_/Q _11685_/Q _11687_/Q VPWR VGND sg13cmos5l_nand4_1
X_09665_ _09672_/B _09745_/A _09665_/B VPWR VGND sg13cmos5l_nor2_1
XFILLER_70_603 VPWR VGND sg13cmos5l_decap_8
X_08616_ _08628_/B _08616_/A _08616_/B VPWR VGND sg13cmos5l_nand2_1
XFILLER_82_485 VPWR VGND sg13cmos5l_fill_1
XFILLER_55_688 VPWR VGND sg13cmos5l_decap_8
XFILLER_43_839 VPWR VGND sg13cmos5l_decap_4
X_09596_ _09596_/Y _11032_/Q _09593_/B _09601_/B1 VPWR VGND sg13cmos5l_a21oi_1
X_08547_ _08547_/Y _08547_/A _08569_/B VPWR VGND sg13cmos5l_nor2_1
XFILLER_23_530 VPWR VGND sg13cmos5l_fill_2
X_08478_ _08478_/Y _08478_/A _08478_/B VPWR VGND sg13cmos5l_nand2_1
X_07429_ _07429_/Y _07427_/Y _08771_/A _07429_/B1 VPWR VGND sg13cmos5l_a21oi_1
XFILLER_51_894 VPWR VGND sg13cmos5l_decap_8
X_10440_ _10440_/Y _10440_/A1 _10495_/A2 _10508_/B1 VPWR VGND sg13cmos5l_a21oi_1
X_11660__1304 _11660_/RESET_B VPWR VGND sg13cmos5l_tiehi
X_11076__849 _11076_/RESET_B VPWR VGND sg13cmos5l_tiehi
X_10371_ _10371_/Y hold2940/X _10495_/A2 _10369_/Y _10370_/Y _10508_/B1 VPWR VGND
+ sg13cmos5l_a221oi_1
XFILLER_105_841 VPWR VGND sg13cmos5l_decap_8
XFILLER_46_1001 VPWR VGND sg13cmos5l_fill_1
XFILLER_78_736 VPWR VGND sg13cmos5l_decap_8
XFILLER_2_467 VPWR VGND sg13cmos5l_decap_8
XFILLER_104_395 VPWR VGND sg13cmos5l_decap_8
Xfanout760 _10305_/A _11476_/Q VPWR VGND sg13cmos5l_buf_1
XFILLER_93_706 VPWR VGND sg13cmos5l_decap_8
Xfanout793 _10171_/A hold2848/X VPWR VGND sg13cmos5l_buf_1
X_11718__1244 _11718_/RESET_B VPWR VGND sg13cmos5l_tiehi
XFILLER_58_460 VPWR VGND sg13cmos5l_fill_1
XFILLER_19_803 VPWR VGND sg13cmos5l_fill_1
Xfanout771 _09217_/A hold2918/X VPWR VGND sg13cmos5l_buf_1
Xfanout782 _09429_/A hold2922/X VPWR VGND sg13cmos5l_buf_1
XFILLER_105_70 VPWR VGND sg13cmos5l_decap_8
XFILLER_92_216 VPWR VGND sg13cmos5l_fill_2
XFILLER_65_30 VPWR VGND sg13cmos5l_fill_1
X_10813__950 _10813_/RESET_B VPWR VGND sg13cmos5l_tiehi
XFILLER_61_603 VPWR VGND sg13cmos5l_decap_8
XFILLER_45_154 VPWR VGND sg13cmos5l_decap_8
XFILLER_61_636 VPWR VGND sg13cmos5l_fill_2
XFILLER_60_135 VPWR VGND sg13cmos5l_fill_2
X_11756_ _11756_/Q clkload30/A _11756_/D _11756_/RESET_B VPWR VGND sg13cmos5l_dfrbpq_1
XFILLER_53_1016 VPWR VGND sg13cmos5l_decap_4
XFILLER_14_574 VPWR VGND sg13cmos5l_decap_4
X_10707_ _10709_/B _10707_/A _11758_/Q _10707_/C VPWR VGND sg13cmos5l_nor3_1
X_11687_ _11687_/Q clkload26/A _11687_/D _11687_/RESET_B VPWR VGND sg13cmos5l_dfrbpq_1
X_10638_ _10638_/Y _10639_/A _10652_/A VPWR VGND sg13cmos5l_nand2_1
X_10569_ _10569_/X _10569_/A _10569_/B VPWR VGND sg13cmos5l_and2_1
Xhold2609 _11567_/D _10749_/Y VPWR VGND sg13cmos5l_dlygate4sd3_1
X_11669__1295 _11669_/RESET_B VPWR VGND sg13cmos5l_tiehi
Xhold1908 _08352_/A _11262_/Q VPWR VGND sg13cmos5l_dlygate4sd3_1
XFILLER_69_747 VPWR VGND sg13cmos5l_decap_8
XFILLER_2_990 VPWR VGND sg13cmos5l_decap_8
X_07780_ _07780_/Y _07780_/A _07780_/B VPWR VGND sg13cmos5l_nor2_1
X_06800_ _06800_/Y _06800_/A _10763_/S VPWR VGND sg13cmos5l_nand2_1
XFILLER_84_706 VPWR VGND sg13cmos5l_decap_8
XFILLER_37_600 VPWR VGND sg13cmos5l_decap_4
Xhold1919 _08202_/A _11188_/Q VPWR VGND sg13cmos5l_dlygate4sd3_1
Xinput4 input4/X ui_in[11] VPWR VGND sg13cmos5l_buf_1
X_06731_ _06735_/A _06732_/A _06729_/Y _06730_/Y VPWR VGND sg13cmos5l_o21ai_1
XFILLER_37_644 VPWR VGND sg13cmos5l_decap_8
XFILLER_36_132 VPWR VGND sg13cmos5l_decap_8
X_09450_ _09450_/Y _11282_/Q _09578_/A2 _09449_/Y VPWR VGND sg13cmos5l_o21ai_1
XFILLER_37_699 VPWR VGND sg13cmos5l_decap_8
XFILLER_36_165 VPWR VGND sg13cmos5l_fill_2
X_08401_ _08401_/Y _08401_/A _08401_/B VPWR VGND sg13cmos5l_nor2_1
X_06662_ _06662_/Y _06662_/A _06662_/B VPWR VGND sg13cmos5l_nand2_1
XFILLER_24_316 VPWR VGND sg13cmos5l_fill_1
XFILLER_101_28 VPWR VGND sg13cmos5l_decap_8
XFILLER_91_282 VPWR VGND sg13cmos5l_decap_4
XFILLER_52_669 VPWR VGND sg13cmos5l_decap_8
XFILLER_51_113 VPWR VGND sg13cmos5l_decap_8
X_06593_ _06593_/Y _06643_/B1 _06590_/Y _06591_/Y VPWR VGND sg13cmos5l_a21oi_1
X_09381_ _09382_/B hold2775/X _09404_/B _09380_/Y VPWR VGND sg13cmos5l_a21oi_1
X_08332_ _08332_/Y _08332_/A _08332_/B VPWR VGND sg13cmos5l_nand2_1
XFILLER_33_883 VPWR VGND sg13cmos5l_decap_8
X_08263_ _08263_/Y _08263_/A _08263_/B VPWR VGND sg13cmos5l_nor2_1
XFILLER_20_533 VPWR VGND sg13cmos5l_decap_8
X_07214_ _10841_/D _05965_/Y _07239_/A2 _07226_/B1 _07213_/Y VPWR VGND sg13cmos5l_a22oi_1
X_08194_ _08194_/Y _08194_/A _08198_/B VPWR VGND sg13cmos5l_nand2_1
XFILLER_106_616 VPWR VGND sg13cmos5l_decap_8
X_07145_ _07145_/Y hold2766/X _07148_/A2 _07145_/B1 VPWR VGND sg13cmos5l_o21ai_1
XFILLER_105_126 VPWR VGND sg13cmos5l_decap_8
X_07076_ _10166_/A _07007_/A _07076_/B VPWR VGND sg13cmos5l_nand2b_1
XFILLER_10_25 VPWR VGND sg13cmos5l_decap_8
X_06027_ _06030_/A _07076_/B _07007_/A _06022_/A VPWR VGND sg13cmos5l_a21oi_1
XFILLER_101_332 VPWR VGND sg13cmos5l_decap_4
XFILLER_59_246 VPWR VGND sg13cmos5l_decap_8
XFILLER_19_12 VPWR VGND sg13cmos5l_fill_1
XFILLER_102_866 VPWR VGND sg13cmos5l_decap_8
X_07978_ _07978_/Y _07978_/A _07978_/B VPWR VGND sg13cmos5l_nand2_1
XFILLER_59_279 VPWR VGND sg13cmos5l_decap_4
XFILLER_47_408 VPWR VGND sg13cmos5l_decap_4
XFILLER_19_45 VPWR VGND sg13cmos5l_fill_1
X_06929_ _11640_/D _06804_/B _06835_/B _06928_/Y VPWR VGND sg13cmos5l_o21ai_1
X_09717_ _09717_/Y _11292_/Q _09850_/A2 _09716_/Y VPWR VGND sg13cmos5l_o21ai_1
XFILLER_90_709 VPWR VGND sg13cmos5l_fill_2
X_11420__1450 _11420_/RESET_B VPWR VGND sg13cmos5l_tiehi
X_10834__1174 _10834_/RESET_B VPWR VGND sg13cmos5l_tiehi
XFILLER_56_975 VPWR VGND sg13cmos5l_fill_1
XFILLER_83_783 VPWR VGND sg13cmos5l_fill_1
XFILLER_82_260 VPWR VGND sg13cmos5l_decap_8
X_11714__1250 _11714_/RESET_B VPWR VGND sg13cmos5l_tiehi
XFILLER_55_474 VPWR VGND sg13cmos5l_fill_1
XFILLER_43_603 VPWR VGND sg13cmos5l_fill_1
X_09648_ _11471_/D _09666_/A _09672_/A _09622_/Y _09647_/Y VPWR VGND sg13cmos5l_a22oi_1
XFILLER_28_677 VPWR VGND sg13cmos5l_fill_2
XFILLER_28_699 VPWR VGND sg13cmos5l_fill_1
XFILLER_43_669 VPWR VGND sg13cmos5l_fill_1
XFILLER_43_658 VPWR VGND sg13cmos5l_decap_8
XFILLER_43_636 VPWR VGND sg13cmos5l_fill_1
X_09579_ _09579_/Y _09573_/Y _09574_/Y _09578_/Y _09579_/B2 VPWR VGND sg13cmos5l_a22oi_1
X_11471__1241 _11471_/RESET_B VPWR VGND sg13cmos5l_tiehi
X_11610_ _11610_/Q clkload29/A _11610_/D _11610_/RESET_B VPWR VGND sg13cmos5l_dfrbpq_1
X_11453__1373 _11453_/RESET_B VPWR VGND sg13cmos5l_tiehi
XFILLER_35_99 VPWR VGND sg13cmos5l_decap_4
X_11541_ _11541_/Q clkload48/A _11541_/D _11541_/RESET_B VPWR VGND sg13cmos5l_dfrbpq_1
XFILLER_11_599 VPWR VGND sg13cmos5l_decap_8
X_11472_ _11472_/Q clkload38/A _11472_/D _11472_/RESET_B VPWR VGND sg13cmos5l_dfrbpq_1
X_10423_ _10423_/Y _10423_/A _10423_/B VPWR VGND sg13cmos5l_nor2_1
X_11624__1343 _11624_/RESET_B VPWR VGND sg13cmos5l_tiehi
X_10354_ _10354_/Y hold2884/X _06085_/A _10168_/B VPWR VGND sg13cmos5l_a21oi_1
XFILLER_4_0 VPWR VGND sg13cmos5l_decap_8
X_10285_ _10286_/B _10285_/A _10285_/B VPWR VGND sg13cmos5l_xor2_1
XFILLER_65_205 VPWR VGND sg13cmos5l_fill_1
Xfanout590 _07160_/A2 _07154_/A2 VPWR VGND sg13cmos5l_buf_1
XFILLER_47_931 VPWR VGND sg13cmos5l_decap_4
XFILLER_80_219 VPWR VGND sg13cmos5l_fill_2
XFILLER_92_72 VPWR VGND sg13cmos5l_decap_8
XFILLER_61_422 VPWR VGND sg13cmos5l_fill_1
XFILLER_18_187 VPWR VGND sg13cmos5l_fill_2
XFILLER_15_861 VPWR VGND sg13cmos5l_decap_4
XFILLER_42_680 VPWR VGND sg13cmos5l_decap_8
XFILLER_14_371 VPWR VGND sg13cmos5l_decap_8
X_11739_ _11739_/Q clkload14/A _11739_/D _11739_/RESET_B VPWR VGND sg13cmos5l_dfrbpq_1
XFILLER_30_897 VPWR VGND sg13cmos5l_fill_1
X_11059__866 _11059_/RESET_B VPWR VGND sg13cmos5l_tiehi
X_08950_ _08960_/B _11631_/Q _08950_/B VPWR VGND sg13cmos5l_xnor2_1
X_08881_ _11433_/D _08879_/Y _08880_/Y _08871_/Y VPWR VGND sg13cmos5l_o21ai_1
Xhold2428 _08143_/A _11159_/Q VPWR VGND sg13cmos5l_dlygate4sd3_1
X_07901_ _07901_/Y _07901_/A _07901_/B VPWR VGND sg13cmos5l_nor2_1
Xhold2417 _11671_/D _07039_/Y VPWR VGND sg13cmos5l_dlygate4sd3_1
Xhold2406 _08121_/A _11148_/Q VPWR VGND sg13cmos5l_dlygate4sd3_1
XFILLER_99_1005 VPWR VGND sg13cmos5l_decap_8
X_07832_ _07832_/Y _07832_/A _07836_/B VPWR VGND sg13cmos5l_nand2_1
Xhold2439 _11616_/D _06852_/Y VPWR VGND sg13cmos5l_dlygate4sd3_1
XFILLER_57_728 VPWR VGND sg13cmos5l_fill_2
XFILLER_69_599 VPWR VGND sg13cmos5l_decap_8
XFILLER_57_739 VPWR VGND sg13cmos5l_decap_4
X_07763_ _10974_/D fanout77/X _07784_/B _07762_/Y VPWR VGND sg13cmos5l_a21oi_1
X_09502_ _09502_/Y _09495_/Y _09497_/Y _09501_/Y _09579_/B2 VPWR VGND sg13cmos5l_a22oi_1
XFILLER_2_81 VPWR VGND sg13cmos5l_fill_2
XFILLER_71_208 VPWR VGND sg13cmos5l_fill_2
XFILLER_65_783 VPWR VGND sg13cmos5l_decap_8
X_07694_ _07694_/Y _07694_/A _07694_/B VPWR VGND sg13cmos5l_nor2_1
X_11066__859 _11066_/RESET_B VPWR VGND sg13cmos5l_tiehi
X_06714_ _06714_/Y _06714_/A _06733_/B VPWR VGND sg13cmos5l_nor2_1
X_06645_ _06646_/B _06645_/A _06645_/B VPWR VGND sg13cmos5l_and2_1
X_09433_ _09436_/B _09433_/A _09433_/B VPWR VGND sg13cmos5l_nor2_1
X_09364_ _09364_/Y _11119_/Q _09606_/B _09605_/B1 VPWR VGND sg13cmos5l_a21oi_1
X_08315_ _11243_/D _08510_/A1 _08364_/B _08314_/Y VPWR VGND sg13cmos5l_o21ai_1
X_06576_ _12769_/A _06133_/A _06576_/B VPWR VGND sg13cmos5l_nand2b_1
XFILLER_21_820 VPWR VGND sg13cmos5l_fill_1
X_09295_ _09295_/Y _11305_/Q _09903_/B _09294_/Y VPWR VGND sg13cmos5l_o21ai_1
XFILLER_21_875 VPWR VGND sg13cmos5l_decap_8
X_08246_ _08246_/Y _08506_/C _08246_/B VPWR VGND sg13cmos5l_nor2_1
X_08177_ _08177_/Y _08177_/A _08177_/B VPWR VGND sg13cmos5l_nor2_1
XFILLER_106_413 VPWR VGND sg13cmos5l_decap_8
X_07128_ _11729_/D _05876_/Y _07130_/A2 _07127_/Y VPWR VGND sg13cmos5l_a21oi_1
XFILLER_97_28 VPWR VGND sg13cmos5l_decap_8
X_11126__1775 _11126_/RESET_B VPWR VGND sg13cmos5l_tiehi
X_07059_ _07059_/Y _06998_/Y _07058_/Y _07059_/B1 VPWR VGND sg13cmos5l_a21oi_1
XFILLER_43_1015 VPWR VGND sg13cmos5l_decap_4
X_10070_ _10070_/X _10070_/A _10834_/Q VPWR VGND sg13cmos5l_or2_1
XFILLER_102_641 VPWR VGND sg13cmos5l_fill_1
XFILLER_101_140 VPWR VGND sg13cmos5l_decap_8
Xhold2940 hold2940/X _11467_/Q VPWR VGND sg13cmos5l_dlygate4sd3_1
XFILLER_102_685 VPWR VGND sg13cmos5l_decap_8
Xhold2951 _10601_/A _11741_/Q VPWR VGND sg13cmos5l_dlygate4sd3_1
XFILLER_48_739 VPWR VGND sg13cmos5l_decap_4
XFILLER_46_43 VPWR VGND sg13cmos5l_fill_1
X_11341__1560 _11341_/RESET_B VPWR VGND sg13cmos5l_tiehi
XFILLER_28_441 VPWR VGND sg13cmos5l_decap_4
XFILLER_44_901 VPWR VGND sg13cmos5l_decap_4
X_10972_ _10972_/Q clkload33/A _10972_/D _10972_/RESET_B VPWR VGND sg13cmos5l_dfrbpq_1
XFILLER_16_603 VPWR VGND sg13cmos5l_fill_2
XFILLER_55_282 VPWR VGND sg13cmos5l_decap_8
XFILLER_71_775 VPWR VGND sg13cmos5l_decap_8
XFILLER_70_296 VPWR VGND sg13cmos5l_fill_1
XFILLER_30_138 VPWR VGND sg13cmos5l_fill_2
X_11524_ _11524_/Q clkload14/A _11524_/D _11524_/RESET_B VPWR VGND sg13cmos5l_dfrbpq_1
X_11455_ _11455_/Q clkload49/A _11455_/D _11455_/RESET_B VPWR VGND sg13cmos5l_dfrbpq_1
X_10406_ _10422_/D _10434_/B _06229_/B _10424_/B _10434_/A VPWR VGND sg13cmos5l_a22oi_1
XFILLER_7_378 VPWR VGND sg13cmos5l_decap_8
X_11386_ _11386_/Q clkload19/A _11386_/D _11386_/RESET_B VPWR VGND sg13cmos5l_dfrbpq_1
XFILLER_106_980 VPWR VGND sg13cmos5l_decap_8
X_10337_ _10338_/C _09507_/A _06085_/A _10336_/Y VPWR VGND sg13cmos5l_a21oi_1
XFILLER_97_138 VPWR VGND sg13cmos5l_decap_8
X_10268_ _10297_/A _10268_/A _10295_/A VPWR VGND sg13cmos5l_nand2_1
XFILLER_79_886 VPWR VGND sg13cmos5l_decap_8
XFILLER_78_396 VPWR VGND sg13cmos5l_decap_8
X_10199_ _10199_/X _11396_/Q _10833_/Q VPWR VGND sg13cmos5l_and2_1
XFILLER_38_216 VPWR VGND sg13cmos5l_decap_8
X_10915__1067 _10915_/RESET_B VPWR VGND sg13cmos5l_tiehi
XFILLER_66_547 VPWR VGND sg13cmos5l_fill_2
XFILLER_47_772 VPWR VGND sg13cmos5l_fill_1
XFILLER_34_411 VPWR VGND sg13cmos5l_decap_8
X_06430_ _06430_/Y _11516_/Q _11485_/Q _06411_/Y _06428_/X _06429_/Y VPWR VGND sg13cmos5l_a221oi_1
XFILLER_62_764 VPWR VGND sg13cmos5l_decap_8
XFILLER_22_617 VPWR VGND sg13cmos5l_decap_4
XFILLER_34_455 VPWR VGND sg13cmos5l_fill_2
XFILLER_15_680 VPWR VGND sg13cmos5l_fill_2
XFILLER_22_639 VPWR VGND sg13cmos5l_fill_1
X_11204__1697 _11204_/RESET_B VPWR VGND sg13cmos5l_tiehi
X_06361_ _06361_/Y _06146_/Y _06682_/A _06692_/A VPWR VGND sg13cmos5l_o21ai_1
XFILLER_30_650 VPWR VGND sg13cmos5l_decap_8
X_08100_ _08100_/Y _08100_/A _08112_/B VPWR VGND sg13cmos5l_nand2_1
X_09080_ _09080_/Y _09118_/C _09067_/X _05939_/A VPWR VGND sg13cmos5l_o21ai_1
X_06292_ _06292_/X _06292_/A _06292_/B VPWR VGND sg13cmos5l_or2_1
X_08031_ _08031_/Y _08031_/A _08031_/B VPWR VGND sg13cmos5l_nor2_1
XFILLER_30_694 VPWR VGND sg13cmos5l_decap_8
XFILLER_103_405 VPWR VGND sg13cmos5l_fill_2
X_09982_ _09982_/Y _10918_/Q _09962_/B _09982_/B1 VPWR VGND sg13cmos5l_a21oi_1
XFILLER_88_127 VPWR VGND sg13cmos5l_fill_2
X_08933_ _08933_/Y _08955_/A _08929_/Y _08932_/Y VPWR VGND sg13cmos5l_a21oi_1
Xhold2203 _08401_/A _11286_/Q VPWR VGND sg13cmos5l_dlygate4sd3_1
Xhold2225 _06811_/A _11604_/Q VPWR VGND sg13cmos5l_dlygate4sd3_1
Xhold2236 _08557_/A _11363_/Q VPWR VGND sg13cmos5l_dlygate4sd3_1
Xhold2214 _07778_/A _10982_/Q VPWR VGND sg13cmos5l_dlygate4sd3_1
XFILLER_84_300 VPWR VGND sg13cmos5l_decap_8
X_08864_ _08864_/X _08864_/A _08864_/B VPWR VGND sg13cmos5l_xor2_1
Xhold2247 _08387_/A _11279_/Q VPWR VGND sg13cmos5l_dlygate4sd3_1
Xhold2269 _07311_/A _10869_/Q VPWR VGND sg13cmos5l_dlygate4sd3_1
Xhold2258 _07688_/A _10938_/Q VPWR VGND sg13cmos5l_dlygate4sd3_1
X_08795_ _08795_/Y _08795_/A _08795_/B VPWR VGND sg13cmos5l_xnor2_1
X_07815_ _10999_/D _08534_/A1 _07808_/B _07814_/Y VPWR VGND sg13cmos5l_o21ai_1
XFILLER_38_783 VPWR VGND sg13cmos5l_decap_4
X_07746_ _07746_/Y _07746_/A _07746_/B VPWR VGND sg13cmos5l_nor2_1
XFILLER_26_956 VPWR VGND sg13cmos5l_decap_8
XFILLER_26_967 VPWR VGND sg13cmos5l_fill_1
X_07677_ _10932_/D _08071_/A1 _07676_/B _07676_/Y VPWR VGND sg13cmos5l_a21oi_1
X_09416_ _09422_/B _09412_/Y _09413_/Y _09414_/Y _09415_/Y _09846_/A1 VPWR VGND sg13cmos5l_a221oi_1
X_06628_ _06628_/Y _06628_/A _06628_/B VPWR VGND sg13cmos5l_nor2_1
XFILLER_25_477 VPWR VGND sg13cmos5l_decap_8
X_06559_ _06560_/B _06133_/A _11674_/Q _10868_/Q _06134_/A VPWR VGND sg13cmos5l_a22oi_1
X_09347_ _09347_/Y _09405_/A _09336_/B _09644_/A VPWR VGND sg13cmos5l_o21ai_1
X_09278_ _09302_/A _09278_/A _09885_/B VPWR VGND sg13cmos5l_nand2_1
X_08229_ _11201_/D fanout68/X _08228_/B _08228_/Y VPWR VGND sg13cmos5l_o21ai_1
XFILLER_32_89 VPWR VGND sg13cmos5l_fill_1
XFILLER_4_315 VPWR VGND sg13cmos5l_fill_2
XFILLER_10_1025 VPWR VGND sg13cmos5l_decap_4
XFILLER_106_210 VPWR VGND sg13cmos5l_decap_8
X_11240_ _11240_/Q clkload50/A _11240_/D _11240_/RESET_B VPWR VGND sg13cmos5l_dfrbpq_1
X_11359__1542 _11359_/RESET_B VPWR VGND sg13cmos5l_tiehi
XFILLER_4_337 VPWR VGND sg13cmos5l_fill_2
X_11171_ _11171_/Q clkload45/A _11171_/D _11171_/RESET_B VPWR VGND sg13cmos5l_dfrbpq_1
XFILLER_4_359 VPWR VGND sg13cmos5l_decap_4
XFILLER_106_287 VPWR VGND sg13cmos5l_decap_8
X_10122_ _10122_/Y _10584_/A _10122_/B VPWR VGND sg13cmos5l_nor2_1
XFILLER_103_961 VPWR VGND sg13cmos5l_decap_8
XFILLER_94_108 VPWR VGND sg13cmos5l_fill_1
XFILLER_88_650 VPWR VGND sg13cmos5l_fill_2
XFILLER_88_672 VPWR VGND sg13cmos5l_fill_2
XFILLER_87_160 VPWR VGND sg13cmos5l_fill_2
X_10053_ _10053_/Y _10668_/A _10053_/A2 _09998_/B _10052_/Y VPWR VGND sg13cmos5l_a22oi_1
XFILLER_48_525 VPWR VGND sg13cmos5l_decap_8
XFILLER_0_587 VPWR VGND sg13cmos5l_decap_8
XFILLER_87_182 VPWR VGND sg13cmos5l_fill_2
Xhold2781 hold2781/X _11630_/Q VPWR VGND sg13cmos5l_dlygate4sd3_1
Xhold2792 hold2792/X _11735_/Q VPWR VGND sg13cmos5l_dlygate4sd3_1
XFILLER_57_86 VPWR VGND sg13cmos5l_fill_1
Xhold2770 _05978_/A _10848_/Q VPWR VGND sg13cmos5l_dlygate4sd3_1
Xheichips26_RiMaX_842 uio_out[3] VPWR VGND sg13cmos5l_tielo
XFILLER_35_219 VPWR VGND sg13cmos5l_decap_8
X_11049__876 _11049_/RESET_B VPWR VGND sg13cmos5l_tiehi
XFILLER_44_742 VPWR VGND sg13cmos5l_fill_1
XFILLER_17_934 VPWR VGND sg13cmos5l_fill_2
X_10955_ _10955_/Q clkload32/A _10955_/D _10955_/RESET_B VPWR VGND sg13cmos5l_dfrbpq_1
XFILLER_90_358 VPWR VGND sg13cmos5l_decap_4
XFILLER_44_775 VPWR VGND sg13cmos5l_decap_8
XFILLER_43_252 VPWR VGND sg13cmos5l_fill_1
XFILLER_71_594 VPWR VGND sg13cmos5l_decap_4
XFILLER_32_959 VPWR VGND sg13cmos5l_fill_1
X_10886_ _10886_/Q clkload11/A _10886_/D _10886_/RESET_B VPWR VGND sg13cmos5l_dfrbpq_1
XFILLER_43_296 VPWR VGND sg13cmos5l_fill_2
XFILLER_31_447 VPWR VGND sg13cmos5l_fill_1
X_11507_ _11507_/Q clkload48/A _11507_/D _11507_/RESET_B VPWR VGND sg13cmos5l_dfrbpq_1
XFILLER_8_665 VPWR VGND sg13cmos5l_decap_8
X_11438_ _11438_/Q _11535_/CLK _11438_/D _11438_/RESET_B VPWR VGND sg13cmos5l_dfrbpq_1
X_11369_ _11369_/Q clkload46/A _11369_/D _11369_/RESET_B VPWR VGND sg13cmos5l_dfrbpq_1
XFILLER_4_860 VPWR VGND sg13cmos5l_fill_1
X_11056__869 _11056_/RESET_B VPWR VGND sg13cmos5l_tiehi
XFILLER_79_694 VPWR VGND sg13cmos5l_fill_1
X_05930_ _10173_/A _07077_/A VPWR VGND sg13cmos5l_inv_1
XFILLER_39_525 VPWR VGND sg13cmos5l_fill_2
X_05861_ _05861_/Y _10537_/A VPWR VGND sg13cmos5l_inv_1
X_11394__1502 _11394_/RESET_B VPWR VGND sg13cmos5l_tiehi
XFILLER_39_569 VPWR VGND sg13cmos5l_fill_1
XFILLER_39_536 VPWR VGND sg13cmos5l_decap_8
XFILLER_96_1019 VPWR VGND sg13cmos5l_decap_8
XFILLER_94_697 VPWR VGND sg13cmos5l_fill_2
X_08580_ _08580_/Y _11306_/Q _08588_/B _08599_/S1 VPWR VGND sg13cmos5l_o21ai_1
XFILLER_82_837 VPWR VGND sg13cmos5l_fill_1
XFILLER_66_366 VPWR VGND sg13cmos5l_fill_2
X_07600_ _07600_/Y _07599_/A _08737_/B _07604_/B _07599_/Y VPWR VGND sg13cmos5l_a22oi_1
XFILLER_26_219 VPWR VGND sg13cmos5l_fill_2
XFILLER_81_325 VPWR VGND sg13cmos5l_fill_2
XFILLER_47_580 VPWR VGND sg13cmos5l_decap_4
XFILLER_35_720 VPWR VGND sg13cmos5l_fill_2
X_07531_ _07531_/Y _07530_/A _08694_/B _07528_/Y _07530_/Y VPWR VGND sg13cmos5l_a22oi_1
XFILLER_35_764 VPWR VGND sg13cmos5l_decap_8
X_11516__1151 _11516_/RESET_B VPWR VGND sg13cmos5l_tiehi
X_07462_ _10893_/D _07482_/B _08384_/A1 _07461_/Y VPWR VGND sg13cmos5l_a21oi_1
X_06413_ _06413_/Y _06760_/S _06419_/B VPWR VGND sg13cmos5l_nor2_1
X_07393_ _07393_/Y _07391_/Y _08746_/A _07400_/A2 VPWR VGND sg13cmos5l_a21oi_1
XFILLER_10_609 VPWR VGND sg13cmos5l_decap_8
X_09201_ _09514_/B _09202_/A _10839_/Q VPWR VGND sg13cmos5l_nand2_1
X_06344_ _10793_/D _08642_/S _06343_/Y _06083_/A VPWR VGND sg13cmos5l_o21ai_1
X_09132_ _09132_/Y _05939_/A _09127_/B _09154_/B1 VPWR VGND sg13cmos5l_o21ai_1
XFILLER_50_778 VPWR VGND sg13cmos5l_fill_2
XFILLER_31_970 VPWR VGND sg13cmos5l_fill_2
XFILLER_33_1025 VPWR VGND sg13cmos5l_decap_4
XFILLER_31_992 VPWR VGND sg13cmos5l_fill_1
X_09063_ _09063_/Y _09063_/A1 _09058_/Y _09062_/Y VPWR VGND sg13cmos5l_a21oi_1
X_06275_ _06602_/B _07020_/A _09180_/A VPWR VGND sg13cmos5l_nor2_1
X_08014_ _11096_/D _08536_/A1 _08013_/B _08013_/Y VPWR VGND sg13cmos5l_a21oi_1
XFILLER_104_714 VPWR VGND sg13cmos5l_decap_8
XFILLER_89_403 VPWR VGND sg13cmos5l_fill_1
XFILLER_103_224 VPWR VGND sg13cmos5l_decap_8
X_09965_ _09965_/Y _09994_/A1 _09964_/Y _09960_/Y VPWR VGND sg13cmos5l_a21oi_1
Xhold2011 _07812_/A _10998_/Q VPWR VGND sg13cmos5l_dlygate4sd3_1
Xhold2000 _08456_/A _11313_/Q VPWR VGND sg13cmos5l_dlygate4sd3_1
X_09896_ _09896_/Y _10947_/Q _10039_/B VPWR VGND sg13cmos5l_nand2_1
XFILLER_85_620 VPWR VGND sg13cmos5l_fill_1
X_08916_ _08916_/Y _08915_/A _08961_/A _08916_/B1 VPWR VGND sg13cmos5l_o21ai_1
Xhold2033 _08088_/A _11133_/Q VPWR VGND sg13cmos5l_dlygate4sd3_1
Xhold2022 _08056_/A _11117_/Q VPWR VGND sg13cmos5l_dlygate4sd3_1
Xhold2044 _07796_/A _10990_/Q VPWR VGND sg13cmos5l_dlygate4sd3_1
XFILLER_100_931 VPWR VGND sg13cmos5l_fill_1
Xhold2088 _11595_/D _10792_/Y VPWR VGND sg13cmos5l_dlygate4sd3_1
X_08847_ _08847_/Y _11382_/Q _08849_/B VPWR VGND sg13cmos5l_nand2_1
Xhold2055 _07966_/A _11073_/Q VPWR VGND sg13cmos5l_dlygate4sd3_1
Xhold2077 _11654_/D _06971_/Y VPWR VGND sg13cmos5l_dlygate4sd3_1
Xhold2066 _08316_/A _11244_/Q VPWR VGND sg13cmos5l_dlygate4sd3_1
XFILLER_45_506 VPWR VGND sg13cmos5l_fill_1
Xhold2099 _08015_/A _11097_/Q VPWR VGND sg13cmos5l_dlygate4sd3_1
XFILLER_85_697 VPWR VGND sg13cmos5l_decap_8
X_08778_ _08778_/Y _08778_/A _08811_/B VPWR VGND sg13cmos5l_nand2_1
X_07729_ _10957_/D _08384_/A1 _07746_/B _07728_/Y VPWR VGND sg13cmos5l_a21oi_1
XFILLER_25_230 VPWR VGND sg13cmos5l_fill_2
X_10740_ _10748_/B _10744_/A _10744_/B VPWR VGND sg13cmos5l_or2_1
X_11544__1485 _11544_/RESET_B VPWR VGND sg13cmos5l_tiehi
XFILLER_43_11 VPWR VGND sg13cmos5l_decap_8
XFILLER_41_723 VPWR VGND sg13cmos5l_fill_2
XFILLER_13_403 VPWR VGND sg13cmos5l_fill_1
X_10671_ _10672_/B _10658_/A _10658_/B _06248_/A VPWR VGND sg13cmos5l_a21oi_1
X_11577__1375 _11577_/RESET_B VPWR VGND sg13cmos5l_tiehi
X_11559__1441 _11559_/RESET_B VPWR VGND sg13cmos5l_tiehi
XFILLER_40_299 VPWR VGND sg13cmos5l_fill_2
XFILLER_104_0 VPWR VGND sg13cmos5l_decap_8
X_11223_ _11223_/Q clkload9/A _11223_/D _11223_/RESET_B VPWR VGND sg13cmos5l_dfrbpq_1
XFILLER_68_609 VPWR VGND sg13cmos5l_fill_1
XFILLER_68_30 VPWR VGND sg13cmos5l_fill_1
X_11154_ _11154_/Q clkload9/A _11154_/D _11154_/RESET_B VPWR VGND sg13cmos5l_dfrbpq_1
XFILLER_1_852 VPWR VGND sg13cmos5l_decap_8
XFILLER_76_620 VPWR VGND sg13cmos5l_fill_2
XFILLER_68_96 VPWR VGND sg13cmos5l_fill_1
XFILLER_0_362 VPWR VGND sg13cmos5l_fill_2
XFILLER_0_340 VPWR VGND sg13cmos5l_decap_4
X_11085_ _11085_/Q clkload34/A _11085_/D _11085_/RESET_B VPWR VGND sg13cmos5l_dfrbpq_1
X_10105_ _10105_/Y _10114_/A1 _09665_/B _10104_/Y VPWR VGND sg13cmos5l_a21oi_1
X_10036_ _10036_/Y _11080_/Q _10039_/B VPWR VGND sg13cmos5l_nand2_1
XFILLER_102_290 VPWR VGND sg13cmos5l_decap_8
XFILLER_76_631 VPWR VGND sg13cmos5l_fill_1
XFILLER_49_856 VPWR VGND sg13cmos5l_decap_8
XFILLER_48_333 VPWR VGND sg13cmos5l_fill_2
XFILLER_63_325 VPWR VGND sg13cmos5l_fill_1
XFILLER_36_528 VPWR VGND sg13cmos5l_decap_8
XFILLER_1_1023 VPWR VGND sg13cmos5l_decap_4
XFILLER_91_667 VPWR VGND sg13cmos5l_fill_2
XFILLER_51_509 VPWR VGND sg13cmos5l_decap_8
XFILLER_90_199 VPWR VGND sg13cmos5l_fill_1
X_10938_ _10938_/Q clkload41/A _10938_/D _10938_/RESET_B VPWR VGND sg13cmos5l_dfrbpq_1
XFILLER_31_200 VPWR VGND sg13cmos5l_decap_4
X_10869_ _10869_/Q _11767_/CLK _10869_/D _10869_/RESET_B VPWR VGND sg13cmos5l_dfrbpq_1
X_11085__1816 _11085_/RESET_B VPWR VGND sg13cmos5l_tiehi
XFILLER_13_992 VPWR VGND sg13cmos5l_decap_8
X_11121__1780 _11121_/RESET_B VPWR VGND sg13cmos5l_tiehi
X_06060_ _06060_/Y _06060_/A _06060_/B VPWR VGND sg13cmos5l_nand2_1
X_11765__926 _11765_/RESET_B VPWR VGND sg13cmos5l_tiehi
XFILLER_99_789 VPWR VGND sg13cmos5l_decap_8
XFILLER_98_244 VPWR VGND sg13cmos5l_decap_8
Xfanout408 _09573_/A1 _06455_/X VPWR VGND sg13cmos5l_buf_1
Xfanout419 _10035_/B1 _09991_/B1 VPWR VGND sg13cmos5l_buf_1
XFILLER_100_205 VPWR VGND sg13cmos5l_fill_1
X_06962_ _06962_/Y _07012_/A _07018_/B _06961_/Y VPWR VGND sg13cmos5l_o21ai_1
X_09750_ _09751_/C _09669_/B _09746_/Y _09749_/Y VPWR VGND sg13cmos5l_o21ai_1
X_09681_ _09687_/B _09677_/Y _09678_/Y _09679_/Y _09680_/Y _10038_/C1 VPWR VGND sg13cmos5l_a221oi_1
X_08701_ _08930_/C _08931_/A VPWR VGND sg13cmos5l_inv_1
XFILLER_39_322 VPWR VGND sg13cmos5l_decap_8
X_05913_ _09666_/A _09217_/A VPWR VGND sg13cmos5l_inv_1
XFILLER_104_28 VPWR VGND sg13cmos5l_decap_8
X_08632_ _11379_/D _11709_/D _07186_/B _08633_/S VPWR VGND sg13cmos5l_mux2_1
X_06893_ _11631_/D _11700_/D hold2810/X _08640_/A VPWR VGND sg13cmos5l_mux2_1
XFILLER_94_494 VPWR VGND sg13cmos5l_decap_8
X_08563_ _08563_/Y _08563_/A _08563_/B VPWR VGND sg13cmos5l_nor2_1
X_08494_ _08494_/Y _08494_/A _08494_/B VPWR VGND sg13cmos5l_nand2_1
XFILLER_81_166 VPWR VGND sg13cmos5l_fill_1
XFILLER_63_870 VPWR VGND sg13cmos5l_fill_2
X_07514_ _07515_/B _11403_/Q _07514_/B VPWR VGND sg13cmos5l_xnor2_1
X_07445_ _07445_/Y _07447_/S _11519_/Q _07444_/Y VPWR VGND sg13cmos5l_o21ai_1
XFILLER_62_391 VPWR VGND sg13cmos5l_fill_2
XFILLER_22_222 VPWR VGND sg13cmos5l_fill_1
Xfanout59 fanout59/X _07620_/Y VPWR VGND sg13cmos5l_buf_1
XFILLER_50_564 VPWR VGND sg13cmos5l_decap_8
XFILLER_10_417 VPWR VGND sg13cmos5l_fill_2
XFILLER_22_266 VPWR VGND sg13cmos5l_fill_2
X_07376_ _07376_/Y _10433_/A _07376_/A2 _07375_/Y VPWR VGND sg13cmos5l_a21oi_1
X_09115_ _09115_/Y _05939_/A _09118_/A _09154_/B1 VPWR VGND sg13cmos5l_o21ai_1
X_06327_ _06328_/D _10620_/A _06326_/Y _06324_/Y VPWR VGND sg13cmos5l_o21ai_1
X_06258_ _06407_/B _11513_/Q _09968_/A VPWR VGND sg13cmos5l_xor2_1
X_09046_ _09046_/Y _09069_/A _09069_/B VPWR VGND sg13cmos5l_nor2_1
X_11039__886 _11039_/RESET_B VPWR VGND sg13cmos5l_tiehi
XFILLER_2_605 VPWR VGND sg13cmos5l_decap_8
X_10874__1108 _10874_/RESET_B VPWR VGND sg13cmos5l_tiehi
XFILLER_104_500 VPWR VGND sg13cmos5l_fill_1
X_10910__1072 _10910_/RESET_B VPWR VGND sg13cmos5l_tiehi
XFILLER_89_222 VPWR VGND sg13cmos5l_decap_8
X_06189_ _06351_/B _10073_/A _09429_/A VPWR VGND sg13cmos5l_nand2_1
XFILLER_104_566 VPWR VGND sg13cmos5l_decap_8
XFILLER_104_533 VPWR VGND sg13cmos5l_decap_8
XFILLER_89_233 VPWR VGND sg13cmos5l_fill_1
XFILLER_89_277 VPWR VGND sg13cmos5l_fill_1
X_09948_ _09949_/C _09948_/A _09948_/B _09948_/C VPWR VGND sg13cmos5l_nand3_1
XFILLER_58_642 VPWR VGND sg13cmos5l_decap_8
XFILLER_38_22 VPWR VGND sg13cmos5l_decap_8
XFILLER_100_761 VPWR VGND sg13cmos5l_decap_8
X_09879_ _09879_/Y _11298_/Q _09903_/B _09878_/Y VPWR VGND sg13cmos5l_o21ai_1
XFILLER_79_1014 VPWR VGND sg13cmos5l_decap_4
X_11163__1738 _11163_/RESET_B VPWR VGND sg13cmos5l_tiehi
XFILLER_46_826 VPWR VGND sg13cmos5l_decap_8
XFILLER_45_303 VPWR VGND sg13cmos5l_fill_1
XFILLER_46_848 VPWR VGND sg13cmos5l_decap_4
XFILLER_46_837 VPWR VGND sg13cmos5l_fill_1
XFILLER_73_678 VPWR VGND sg13cmos5l_decap_8
X_11046__879 _11046_/RESET_B VPWR VGND sg13cmos5l_tiehi
XFILLER_61_829 VPWR VGND sg13cmos5l_decap_8
XFILLER_60_328 VPWR VGND sg13cmos5l_fill_2
X_10723_ _10726_/A _10723_/A _10727_/B VPWR VGND sg13cmos5l_nand2_1
XFILLER_60_339 VPWR VGND sg13cmos5l_decap_8
XFILLER_41_575 VPWR VGND sg13cmos5l_decap_8
XFILLER_41_553 VPWR VGND sg13cmos5l_fill_2
X_10654_ _10654_/Y _10654_/A _10665_/B VPWR VGND sg13cmos5l_nand2_1
XFILLER_70_42 VPWR VGND sg13cmos5l_decap_8
X_10585_ _10585_/Y _10585_/A _10585_/B VPWR VGND sg13cmos5l_nand2_1
Xclkload29 clkload29/Y clkload29/A VPWR VGND sg13cmos5l_inv_2
Xclkload18 clkload18/Y clkload18/A VPWR VGND sg13cmos5l_inv_2
XFILLER_6_933 VPWR VGND sg13cmos5l_decap_4
XFILLER_5_454 VPWR VGND sg13cmos5l_fill_2
X_11500__1183 _11500_/RESET_B VPWR VGND sg13cmos5l_tiehi
X_11206_ _11206_/Q clkload52/A _11206_/D _11206_/RESET_B VPWR VGND sg13cmos5l_dfrbpq_1
XFILLER_95_214 VPWR VGND sg13cmos5l_fill_1
XFILLER_68_428 VPWR VGND sg13cmos5l_fill_1
XFILLER_68_406 VPWR VGND sg13cmos5l_fill_1
XFILLER_1_671 VPWR VGND sg13cmos5l_decap_4
X_11137_ _11137_/Q _11361_/CLK _11137_/D _11137_/RESET_B VPWR VGND sg13cmos5l_dfrbpq_1
XFILLER_23_1002 VPWR VGND sg13cmos5l_fill_1
XFILLER_95_269 VPWR VGND sg13cmos5l_fill_1
XFILLER_77_962 VPWR VGND sg13cmos5l_decap_8
XFILLER_49_653 VPWR VGND sg13cmos5l_decap_4
XFILLER_48_130 VPWR VGND sg13cmos5l_decap_8
X_11068_ _11068_/Q _11356_/CLK _11068_/D _11068_/RESET_B VPWR VGND sg13cmos5l_dfrbpq_1
XFILLER_92_943 VPWR VGND sg13cmos5l_decap_8
X_10019_ _10019_/Y _10019_/A _10019_/B VPWR VGND sg13cmos5l_nor2_1
X_11139__1762 _11139_/RESET_B VPWR VGND sg13cmos5l_tiehi
XFILLER_64_645 VPWR VGND sg13cmos5l_decap_8
XFILLER_48_163 VPWR VGND sg13cmos5l_decap_4
XFILLER_37_848 VPWR VGND sg13cmos5l_decap_8
XFILLER_37_837 VPWR VGND sg13cmos5l_decap_8
XFILLER_91_453 VPWR VGND sg13cmos5l_fill_2
XFILLER_36_369 VPWR VGND sg13cmos5l_fill_2
XFILLER_45_881 VPWR VGND sg13cmos5l_fill_1
XFILLER_45_870 VPWR VGND sg13cmos5l_fill_1
XFILLER_32_531 VPWR VGND sg13cmos5l_fill_2
X_07230_ _10849_/D _07244_/A _07230_/B VPWR VGND sg13cmos5l_nand2_1
XFILLER_32_586 VPWR VGND sg13cmos5l_decap_8
X_07161_ _07161_/Y _07098_/A _07164_/A2 _07163_/B1 VPWR VGND sg13cmos5l_o21ai_1
X_06112_ _06114_/B _06132_/B _06107_/S _12765_/A VPWR VGND sg13cmos5l_a21oi_1
XFILLER_105_308 VPWR VGND sg13cmos5l_fill_2
X_07092_ _11709_/D hold2742/X hold2733/X _07093_/B VPWR VGND sg13cmos5l_mux2_1
X_06043_ _06044_/C _11607_/Q _11606_/Q _06043_/C VPWR VGND sg13cmos5l_nor3_1
Xfanout205 _08141_/B _08143_/B VPWR VGND sg13cmos5l_buf_1
XFILLER_87_726 VPWR VGND sg13cmos5l_decap_4
XFILLER_86_214 VPWR VGND sg13cmos5l_fill_1
X_09802_ _09807_/B _09996_/A _09802_/B _09802_/C VPWR VGND sg13cmos5l_nor3_1
Xfanout238 _07746_/B fanout246/X VPWR VGND sg13cmos5l_buf_1
Xfanout227 _07875_/B _07883_/B VPWR VGND sg13cmos5l_buf_1
Xfanout216 _08011_/B _08005_/B VPWR VGND sg13cmos5l_buf_1
X_07994_ _11086_/D _08451_/A1 _08005_/B _07993_/Y VPWR VGND sg13cmos5l_a21oi_1
Xfanout249 _07702_/B _07684_/B VPWR VGND sg13cmos5l_buf_1
X_06945_ _11645_/D _06931_/B hold2647/X _06944_/Y VPWR VGND sg13cmos5l_o21ai_1
XFILLER_68_973 VPWR VGND sg13cmos5l_fill_2
X_09733_ _09733_/X _11005_/Q _10973_/Q _09733_/S VPWR VGND sg13cmos5l_mux2_1
XFILLER_95_781 VPWR VGND sg13cmos5l_decap_8
X_06876_ _06876_/X _06072_/A _10762_/S _06875_/Y VPWR VGND sg13cmos5l_a21o_1
XFILLER_82_420 VPWR VGND sg13cmos5l_fill_2
XFILLER_39_185 VPWR VGND sg13cmos5l_decap_8
X_09664_ _09665_/B _09852_/A1 _09659_/X _09663_/Y VPWR VGND sg13cmos5l_o21ai_1
XFILLER_82_453 VPWR VGND sg13cmos5l_fill_2
X_08615_ _08616_/B _08615_/A _08615_/B VPWR VGND sg13cmos5l_and2_1
X_09595_ _09595_/Y _11064_/Q _09600_/B VPWR VGND sg13cmos5l_nand2_1
XFILLER_70_637 VPWR VGND sg13cmos5l_decap_8
XFILLER_70_626 VPWR VGND sg13cmos5l_fill_1
XFILLER_54_155 VPWR VGND sg13cmos5l_decap_4
XFILLER_42_328 VPWR VGND sg13cmos5l_fill_2
XFILLER_36_870 VPWR VGND sg13cmos5l_fill_1
XFILLER_54_199 VPWR VGND sg13cmos5l_decap_8
X_08546_ _11357_/D fanout78/X _08553_/B _08545_/Y VPWR VGND sg13cmos5l_a21oi_1
X_08477_ _11323_/D fanout82/X _08496_/B _08476_/Y VPWR VGND sg13cmos5l_o21ai_1
XFILLER_50_361 VPWR VGND sg13cmos5l_decap_8
XFILLER_50_350 VPWR VGND sg13cmos5l_fill_2
X_10928__1054 _10928_/RESET_B VPWR VGND sg13cmos5l_tiehi
X_07428_ _08771_/A _09155_/A _08651_/B VPWR VGND sg13cmos5l_nand2_1
XFILLER_23_586 VPWR VGND sg13cmos5l_decap_8
XFILLER_7_719 VPWR VGND sg13cmos5l_fill_1
XFILLER_6_207 VPWR VGND sg13cmos5l_decap_4
XFILLER_11_759 VPWR VGND sg13cmos5l_fill_2
X_07359_ _07359_/Y _07359_/A _07359_/B VPWR VGND sg13cmos5l_nor2_1
XFILLER_40_34 VPWR VGND sg13cmos5l_fill_2
XFILLER_40_23 VPWR VGND sg13cmos5l_decap_8
XFILLER_10_269 VPWR VGND sg13cmos5l_decap_8
X_10370_ _10370_/Y _10422_/A _10343_/Y _10494_/B1 VPWR VGND sg13cmos5l_a21oi_1
XFILLER_3_903 VPWR VGND sg13cmos5l_decap_4
X_09029_ _09029_/Y _09024_/Y _09026_/Y _09028_/Y _09061_/A _09131_/A VPWR VGND sg13cmos5l_a221oi_1
X_11217__1684 _11217_/RESET_B VPWR VGND sg13cmos5l_tiehi
XFILLER_3_969 VPWR VGND sg13cmos5l_decap_8
XFILLER_3_958 VPWR VGND sg13cmos5l_fill_2
XFILLER_105_897 VPWR VGND sg13cmos5l_decap_8
XFILLER_104_374 VPWR VGND sg13cmos5l_decap_8
Xfanout750 _09909_/A hold2899/X VPWR VGND sg13cmos5l_buf_1
Xfanout794 _09270_/A hold2864/X VPWR VGND sg13cmos5l_buf_1
XFILLER_58_450 VPWR VGND sg13cmos5l_fill_1
XFILLER_1_28 VPWR VGND sg13cmos5l_decap_8
Xfanout783 _09405_/A hold2887/X VPWR VGND sg13cmos5l_buf_1
Xfanout772 _10440_/A1 _11471_/Q VPWR VGND sg13cmos5l_buf_1
Xfanout761 _09641_/A _06310_/B VPWR VGND sg13cmos5l_buf_1
XFILLER_92_228 VPWR VGND sg13cmos5l_fill_1
XFILLER_74_921 VPWR VGND sg13cmos5l_fill_2
X_11744__1192 _11744_/RESET_B VPWR VGND sg13cmos5l_tiehi
XFILLER_46_634 VPWR VGND sg13cmos5l_decap_8
XFILLER_45_100 VPWR VGND sg13cmos5l_fill_1
X_11439__1412 _11439_/RESET_B VPWR VGND sg13cmos5l_tiehi
XFILLER_60_103 VPWR VGND sg13cmos5l_fill_2
X_11755_ _11755_/Q clkload30/A _11755_/D _11755_/RESET_B VPWR VGND sg13cmos5l_dfrbpq_1
XFILLER_41_350 VPWR VGND sg13cmos5l_fill_2
X_10706_ _11554_/D hold2808/X _10686_/X _06019_/B VPWR VGND sg13cmos5l_a21o_1
XFILLER_14_586 VPWR VGND sg13cmos5l_fill_1
X_11686_ _11686_/Q clkload23/A _11686_/D _11686_/RESET_B VPWR VGND sg13cmos5l_dfrbpq_1
X_11628__1338 _11628_/RESET_B VPWR VGND sg13cmos5l_tiehi
X_10637_ _10652_/A _10653_/A _10857_/Q VPWR VGND sg13cmos5l_xor2_1
XFILLER_10_770 VPWR VGND sg13cmos5l_decap_4
X_10568_ _10569_/B _10568_/A _10568_/B _10570_/C VPWR VGND sg13cmos5l_nor3_1
X_10499_ _10499_/Y _10568_/A _10499_/B VPWR VGND sg13cmos5l_nor2_1
XFILLER_69_704 VPWR VGND sg13cmos5l_decap_4
Xhold1909 _08210_/A _11192_/Q VPWR VGND sg13cmos5l_dlygate4sd3_1
XFILLER_1_490 VPWR VGND sg13cmos5l_decap_8
XFILLER_83_217 VPWR VGND sg13cmos5l_fill_1
XFILLER_77_781 VPWR VGND sg13cmos5l_fill_2
Xinput5 input5/X ui_in[12] VPWR VGND sg13cmos5l_buf_1
XFILLER_49_461 VPWR VGND sg13cmos5l_decap_8
X_06730_ _06730_/Y _06732_/A _06729_/Y _06744_/A1 VPWR VGND sg13cmos5l_a21oi_1
XFILLER_65_954 VPWR VGND sg13cmos5l_fill_2
XFILLER_36_144 VPWR VGND sg13cmos5l_decap_8
X_06661_ _06662_/B _06179_/B _06646_/B _06299_/Y VPWR VGND sg13cmos5l_a21oi_1
XFILLER_92_773 VPWR VGND sg13cmos5l_decap_4
XFILLER_91_272 VPWR VGND sg13cmos5l_fill_1
XFILLER_80_913 VPWR VGND sg13cmos5l_decap_8
XFILLER_52_626 VPWR VGND sg13cmos5l_decap_4
X_08400_ _11285_/D _08530_/A1 _08405_/B _08399_/Y VPWR VGND sg13cmos5l_a21oi_1
X_06592_ _06592_/Y _06591_/A _06400_/D _06614_/A VPWR VGND sg13cmos5l_a21oi_1
XFILLER_36_199 VPWR VGND sg13cmos5l_fill_2
X_11029__896 _11029_/RESET_B VPWR VGND sg13cmos5l_tiehi
X_09380_ _09380_/Y _09376_/Y _09377_/Y _09379_/Y VPWR VGND sg13cmos5l_o21ai_1
X_11579__1367 _11579_/RESET_B VPWR VGND sg13cmos5l_tiehi
X_08331_ _11251_/D _08331_/A1 _08328_/B _08330_/Y VPWR VGND sg13cmos5l_o21ai_1
X_08262_ _11217_/D _08457_/A1 _08283_/B _08261_/Y VPWR VGND sg13cmos5l_a21oi_1
XFILLER_20_512 VPWR VGND sg13cmos5l_decap_8
X_07213_ _07213_/Y _08889_/A _05945_/A _07227_/B1 _06820_/C _07225_/C1 VPWR VGND sg13cmos5l_a221oi_1
X_08193_ _11183_/D _08453_/A1 _08216_/B _08192_/Y VPWR VGND sg13cmos5l_o21ai_1
X_07144_ _11737_/D _05885_/Y _07160_/A2 _07143_/Y VPWR VGND sg13cmos5l_a21oi_1
XFILLER_105_105 VPWR VGND sg13cmos5l_decap_8
X_11075__850 _11075_/RESET_B VPWR VGND sg13cmos5l_tiehi
X_10795__932 _10795_/RESET_B VPWR VGND sg13cmos5l_tiehi
X_07075_ _07075_/Y _08616_/A _07074_/Y _07070_/Y VPWR VGND sg13cmos5l_a21oi_1
X_06026_ _11748_/D _06026_/A _07786_/A _06026_/C VPWR VGND sg13cmos5l_nand3_1
XFILLER_99_350 VPWR VGND sg13cmos5l_fill_1
X_11036__889 _11036_/RESET_B VPWR VGND sg13cmos5l_tiehi
XFILLER_59_225 VPWR VGND sg13cmos5l_decap_4
X_07977_ _11078_/D fanout56/X _07976_/B _07976_/Y VPWR VGND sg13cmos5l_o21ai_1
XFILLER_75_707 VPWR VGND sg13cmos5l_decap_8
X_06928_ _06928_/Y _10688_/A _07202_/C _06927_/X VPWR VGND sg13cmos5l_a21oi_1
XFILLER_74_228 VPWR VGND sg13cmos5l_fill_1
XFILLER_74_206 VPWR VGND sg13cmos5l_decap_4
X_09716_ _09716_/Y _05975_/Y _09841_/B _09715_/Y VPWR VGND sg13cmos5l_a21oi_1
XFILLER_83_751 VPWR VGND sg13cmos5l_fill_1
XFILLER_83_740 VPWR VGND sg13cmos5l_decap_8
XFILLER_56_954 VPWR VGND sg13cmos5l_fill_2
XFILLER_55_431 VPWR VGND sg13cmos5l_fill_2
XFILLER_28_667 VPWR VGND sg13cmos5l_fill_1
X_11082__843 _11082_/RESET_B VPWR VGND sg13cmos5l_tiehi
X_06859_ _06859_/Y _06859_/A _10785_/B VPWR VGND sg13cmos5l_nand2_1
XFILLER_76_1006 VPWR VGND sg13cmos5l_fill_1
XFILLER_70_401 VPWR VGND sg13cmos5l_fill_2
X_09647_ _09647_/Y _09672_/A _09647_/B _09647_/C _09647_/D VPWR VGND sg13cmos5l_nor4_1
X_09578_ _09578_/Y _11287_/Q _09578_/A2 _09577_/Y VPWR VGND sg13cmos5l_o21ai_1
XFILLER_42_169 VPWR VGND sg13cmos5l_fill_1
X_08529_ _08529_/Y _08529_/A _08529_/B VPWR VGND sg13cmos5l_nor2_1
XFILLER_35_89 VPWR VGND sg13cmos5l_fill_2
X_11540_ _11540_/Q clkload43/A _11540_/D _11540_/RESET_B VPWR VGND sg13cmos5l_dfrbpq_1
XFILLER_11_512 VPWR VGND sg13cmos5l_fill_1
XFILLER_23_361 VPWR VGND sg13cmos5l_decap_8
XFILLER_51_44 VPWR VGND sg13cmos5l_decap_8
XFILLER_11_567 VPWR VGND sg13cmos5l_fill_2
X_11471_ _11471_/Q clkload38/A _11471_/D _11471_/RESET_B VPWR VGND sg13cmos5l_dfrbpq_1
X_10422_ _10422_/Y _10422_/A _10422_/B _10422_/C _10422_/D VPWR VGND sg13cmos5l_nand4_1
X_10353_ _10353_/Y _10353_/A _10353_/B VPWR VGND sg13cmos5l_nand2_1
XFILLER_2_210 VPWR VGND sg13cmos5l_decap_4
X_10284_ _10545_/A _10285_/A _10285_/B _10286_/A VPWR VGND sg13cmos5l_a21o_1
XFILLER_3_777 VPWR VGND sg13cmos5l_fill_2
XFILLER_104_182 VPWR VGND sg13cmos5l_decap_8
XFILLER_78_567 VPWR VGND sg13cmos5l_fill_2
XFILLER_66_718 VPWR VGND sg13cmos5l_decap_8
XFILLER_38_409 VPWR VGND sg13cmos5l_decap_8
Xfanout580 _06775_/B1 _06397_/X VPWR VGND sg13cmos5l_buf_1
Xfanout591 _07164_/A2 _07154_/A2 VPWR VGND sg13cmos5l_buf_1
XFILLER_47_954 VPWR VGND sg13cmos5l_decap_8
XFILLER_47_943 VPWR VGND sg13cmos5l_fill_2
XFILLER_46_420 VPWR VGND sg13cmos5l_fill_1
XFILLER_80_209 VPWR VGND sg13cmos5l_decap_4
XFILLER_46_475 VPWR VGND sg13cmos5l_fill_2
XFILLER_46_464 VPWR VGND sg13cmos5l_decap_8
XFILLER_46_453 VPWR VGND sg13cmos5l_fill_2
XFILLER_18_199 VPWR VGND sg13cmos5l_fill_1
XFILLER_33_136 VPWR VGND sg13cmos5l_fill_1
XFILLER_34_659 VPWR VGND sg13cmos5l_decap_8
XFILLER_61_467 VPWR VGND sg13cmos5l_fill_2
X_11738_ _11738_/Q clkload22/A _11738_/D _11738_/RESET_B VPWR VGND sg13cmos5l_dfrbpq_1
XFILLER_30_865 VPWR VGND sg13cmos5l_fill_2
X_11669_ _11669_/Q clkload7/A _11669_/D _11669_/RESET_B VPWR VGND sg13cmos5l_dfrbpq_1
XFILLER_103_609 VPWR VGND sg13cmos5l_decap_8
XFILLER_102_119 VPWR VGND sg13cmos5l_decap_8
X_07900_ _11040_/D fanout73/X _07899_/B _07899_/Y VPWR VGND sg13cmos5l_a21oi_1
XFILLER_69_512 VPWR VGND sg13cmos5l_fill_1
X_08880_ _08880_/Y _08880_/A1 _08890_/B _06078_/A VPWR VGND sg13cmos5l_o21ai_1
Xhold2407 _07461_/A _10893_/Q VPWR VGND sg13cmos5l_dlygate4sd3_1
Xhold2418 _08129_/A _11152_/Q VPWR VGND sg13cmos5l_dlygate4sd3_1
X_07831_ _11007_/D fanout75/X _07836_/B _07830_/Y VPWR VGND sg13cmos5l_o21ai_1
Xhold2429 _08005_/A _11092_/Q VPWR VGND sg13cmos5l_dlygate4sd3_1
XFILLER_99_1028 VPWR VGND sg13cmos5l_fill_1
XFILLER_2_60 VPWR VGND sg13cmos5l_decap_4
X_07762_ _07762_/Y _07762_/A _07784_/B VPWR VGND sg13cmos5l_nor2_1
XFILLER_49_291 VPWR VGND sg13cmos5l_decap_4
X_09501_ _09501_/Y _11284_/Q _09578_/A2 _09500_/Y VPWR VGND sg13cmos5l_o21ai_1
X_07693_ _10940_/D fanout80/X _07702_/B _07692_/Y VPWR VGND sg13cmos5l_a21oi_1
X_06713_ _06713_/Y _06713_/A _06713_/B VPWR VGND sg13cmos5l_xnor2_1
XFILLER_92_581 VPWR VGND sg13cmos5l_decap_8
XFILLER_80_732 VPWR VGND sg13cmos5l_fill_2
XFILLER_53_935 VPWR VGND sg13cmos5l_fill_2
X_06644_ _10803_/D _06173_/B _06641_/Y _06643_/Y VPWR VGND sg13cmos5l_o21ai_1
XFILLER_24_125 VPWR VGND sg13cmos5l_fill_2
X_09432_ _09433_/B _09506_/A _09432_/B VPWR VGND sg13cmos5l_nand2_1
XFILLER_52_467 VPWR VGND sg13cmos5l_fill_1
X_09363_ _09363_/Y _11087_/Q _09363_/B VPWR VGND sg13cmos5l_nand2_1
X_06575_ _06575_/Y _06575_/A _06575_/B VPWR VGND sg13cmos5l_nand2_1
X_08314_ _08314_/Y _08314_/A _08364_/B VPWR VGND sg13cmos5l_nand2_1
XFILLER_52_489 VPWR VGND sg13cmos5l_decap_8
X_09294_ _09294_/Y _05987_/Y _10039_/B _09293_/Y VPWR VGND sg13cmos5l_a21oi_1
XANTENNA_10 _08441_/Y VPWR VGND sg13cmos5l_antennanp
X_10837__1168 _10837_/RESET_B VPWR VGND sg13cmos5l_tiehi
XFILLER_20_342 VPWR VGND sg13cmos5l_decap_8
X_08245_ _11209_/D fanout50/X _08244_/B _08244_/Y VPWR VGND sg13cmos5l_o21ai_1
X_11423__1444 _11423_/RESET_B VPWR VGND sg13cmos5l_tiehi
X_08176_ _11175_/D fanout54/X _08177_/B _08175_/Y VPWR VGND sg13cmos5l_a21oi_1
X_11474__1235 _11474_/RESET_B VPWR VGND sg13cmos5l_tiehi
X_07127_ _07127_/Y hold2834/X _07130_/A2 _07155_/B1 VPWR VGND sg13cmos5l_o21ai_1
XFILLER_106_469 VPWR VGND sg13cmos5l_decap_8
XFILLER_79_309 VPWR VGND sg13cmos5l_decap_4
X_07058_ _07058_/Y _11517_/Q _10165_/B VPWR VGND sg13cmos5l_nand2_1
XFILLER_0_703 VPWR VGND sg13cmos5l_decap_4
X_11098__1803 _11098_/RESET_B VPWR VGND sg13cmos5l_tiehi
X_06009_ _06009_/X _11757_/Q _11758_/Q VPWR VGND sg13cmos5l_or2_1
XFILLER_0_758 VPWR VGND sg13cmos5l_decap_8
Xhold2941 _05923_/A _11493_/Q VPWR VGND sg13cmos5l_dlygate4sd3_1
Xhold2930 hold2930/X _11464_/Q VPWR VGND sg13cmos5l_dlygate4sd3_1
Xhold2952 _09231_/B _10847_/Q VPWR VGND sg13cmos5l_dlygate4sd3_1
XFILLER_47_228 VPWR VGND sg13cmos5l_decap_8
XFILLER_101_196 VPWR VGND sg13cmos5l_decap_8
X_10971_ _10971_/Q _11355_/CLK _10971_/D _10971_/RESET_B VPWR VGND sg13cmos5l_dfrbpq_1
XFILLER_62_209 VPWR VGND sg13cmos5l_fill_1
XFILLER_56_784 VPWR VGND sg13cmos5l_fill_2
XFILLER_46_55 VPWR VGND sg13cmos5l_fill_2
XFILLER_29_987 VPWR VGND sg13cmos5l_fill_1
XFILLER_55_272 VPWR VGND sg13cmos5l_fill_2
XFILLER_16_659 VPWR VGND sg13cmos5l_fill_2
XFILLER_15_147 VPWR VGND sg13cmos5l_decap_4
XFILLER_43_478 VPWR VGND sg13cmos5l_fill_1
XFILLER_31_629 VPWR VGND sg13cmos5l_decap_8
X_11523_ _11523_/Q clkload14/A _11523_/D _11523_/RESET_B VPWR VGND sg13cmos5l_dfrbpq_1
X_11454_ _11454_/Q clkload52/A _11454_/D _11454_/RESET_B VPWR VGND sg13cmos5l_dfrbpq_1
XFILLER_7_335 VPWR VGND sg13cmos5l_decap_8
X_10405_ _10422_/C _09641_/A _10479_/C _06236_/A _10424_/A VPWR VGND sg13cmos5l_a22oi_1
X_11385_ _11385_/Q clkload19/A _11385_/D _11385_/RESET_B VPWR VGND sg13cmos5l_dfrbpq_1
X_10336_ _10336_/Y _10333_/A _10334_/Y _10335_/Y VPWR VGND sg13cmos5l_a21oi_1
XFILLER_97_117 VPWR VGND sg13cmos5l_decap_8
XFILLER_79_832 VPWR VGND sg13cmos5l_decap_4
X_10267_ _10267_/Y _10267_/A _10267_/B _10267_/C _10267_/D VPWR VGND sg13cmos5l_nand4_1
Xclkbuf_4_9_0_clk clkload3/A clkbuf_0_clk/X VPWR VGND sg13cmos5l_buf_8
XFILLER_39_718 VPWR VGND sg13cmos5l_decap_8
XFILLER_66_526 VPWR VGND sg13cmos5l_fill_2
X_10198_ _11522_/D _10226_/C1 _10195_/Y _10196_/Y _10197_/Y _06953_/A VPWR VGND sg13cmos5l_a221oi_1
XFILLER_39_729 VPWR VGND sg13cmos5l_fill_1
XFILLER_38_228 VPWR VGND sg13cmos5l_fill_2
XFILLER_4_1021 VPWR VGND sg13cmos5l_decap_8
XFILLER_93_378 VPWR VGND sg13cmos5l_decap_8
XFILLER_59_1012 VPWR VGND sg13cmos5l_decap_8
XFILLER_47_784 VPWR VGND sg13cmos5l_decap_8
XFILLER_62_721 VPWR VGND sg13cmos5l_decap_8
XFILLER_47_795 VPWR VGND sg13cmos5l_decap_8
X_11065__860 _11065_/RESET_B VPWR VGND sg13cmos5l_tiehi
XFILLER_61_242 VPWR VGND sg13cmos5l_decap_4
X_11176__1725 _11176_/RESET_B VPWR VGND sg13cmos5l_tiehi
XFILLER_61_297 VPWR VGND sg13cmos5l_fill_1
X_11026__899 _11026_/RESET_B VPWR VGND sg13cmos5l_tiehi
XFILLER_14_191 VPWR VGND sg13cmos5l_decap_4
X_06360_ _06360_/Y _06664_/A _06673_/A VPWR VGND sg13cmos5l_nand2_1
XFILLER_21_139 VPWR VGND sg13cmos5l_fill_1
X_06291_ _06292_/B _06673_/A _06291_/B VPWR VGND sg13cmos5l_nor2_1
XFILLER_30_662 VPWR VGND sg13cmos5l_fill_2
X_08030_ _11104_/D fanout73/X _08047_/B _08029_/Y VPWR VGND sg13cmos5l_a21oi_1
X_11705__1259 _11705_/RESET_B VPWR VGND sg13cmos5l_tiehi
XFILLER_104_929 VPWR VGND sg13cmos5l_decap_8
X_11072__853 _11072_/RESET_B VPWR VGND sg13cmos5l_tiehi
X_09981_ _09981_/Y _10950_/Q _09981_/B VPWR VGND sg13cmos5l_nand2_1
X_08932_ _08932_/Y _08955_/A _08931_/Y _08921_/A VPWR VGND sg13cmos5l_o21ai_1
Xhold2204 _08043_/A _11111_/Q VPWR VGND sg13cmos5l_dlygate4sd3_1
Xhold2226 _11604_/D _06812_/Y VPWR VGND sg13cmos5l_dlygate4sd3_1
Xhold2215 _07281_/A _10864_/Q VPWR VGND sg13cmos5l_dlygate4sd3_1
Xhold2237 _08269_/A _11221_/Q VPWR VGND sg13cmos5l_dlygate4sd3_1
X_08863_ _08886_/A _08864_/A _08864_/B VPWR VGND sg13cmos5l_nor2_1
Xhold2259 _08265_/A _11219_/Q VPWR VGND sg13cmos5l_dlygate4sd3_1
Xhold2248 _08533_/A _11351_/Q VPWR VGND sg13cmos5l_dlygate4sd3_1
X_08794_ _08795_/B _08784_/A _08784_/B _08781_/Y VPWR VGND sg13cmos5l_o21ai_1
X_07814_ _07814_/Y _07814_/A _07814_/B VPWR VGND sg13cmos5l_nand2_1
XFILLER_72_507 VPWR VGND sg13cmos5l_fill_2
X_11580__1469 _11580_/RESET_B VPWR VGND sg13cmos5l_tiehi
XFILLER_44_209 VPWR VGND sg13cmos5l_decap_8
X_07745_ _10965_/D _08073_/A1 _07768_/B _07744_/Y VPWR VGND sg13cmos5l_a21oi_1
X_11595__1403 _11595_/RESET_B VPWR VGND sg13cmos5l_tiehi
XFILLER_80_540 VPWR VGND sg13cmos5l_decap_8
XFILLER_53_776 VPWR VGND sg13cmos5l_fill_2
X_07676_ _07676_/Y _07676_/A _07676_/B VPWR VGND sg13cmos5l_nor2_1
XFILLER_16_58 VPWR VGND sg13cmos5l_fill_1
X_09415_ _09415_/Y _10897_/Q _09708_/S _09842_/B1 VPWR VGND sg13cmos5l_a21oi_1
XFILLER_26_979 VPWR VGND sg13cmos5l_decap_8
XFILLER_53_798 VPWR VGND sg13cmos5l_decap_8
X_06627_ _06627_/Y _06628_/A _06627_/B VPWR VGND sg13cmos5l_xnor2_1
X_06558_ _06560_/A _06564_/A1 _11658_/Q _10884_/Q _06134_/B VPWR VGND sg13cmos5l_a22oi_1
X_09346_ _09433_/A _09346_/A _09456_/B VPWR VGND sg13cmos5l_nor2_1
X_09277_ _09277_/X _11621_/Q _11620_/Q _11613_/Q _11612_/Q VPWR VGND sg13cmos5l_or4_1
X_06489_ _06489_/Y _11635_/Q _10164_/B _06488_/Y VPWR VGND sg13cmos5l_a21oi_1
XFILLER_5_806 VPWR VGND sg13cmos5l_fill_1
X_08228_ _08228_/Y _08228_/A _08228_/B VPWR VGND sg13cmos5l_nand2_1
XFILLER_5_828 VPWR VGND sg13cmos5l_decap_8
XFILLER_10_1004 VPWR VGND sg13cmos5l_decap_8
X_10965__1017 _10965_/RESET_B VPWR VGND sg13cmos5l_tiehi
X_08159_ _08159_/Y _08159_/A _08177_/B VPWR VGND sg13cmos5l_nor2_1
XFILLER_106_266 VPWR VGND sg13cmos5l_decap_8
X_11170_ _11170_/Q _11362_/CLK _11170_/D _11170_/RESET_B VPWR VGND sg13cmos5l_dfrbpq_1
X_10121_ _10123_/B _09802_/B _09802_/C _05935_/A VPWR VGND sg13cmos5l_o21ai_1
XFILLER_0_511 VPWR VGND sg13cmos5l_decap_8
XFILLER_103_940 VPWR VGND sg13cmos5l_decap_8
X_10052_ _10052_/Y _09912_/A _09276_/Y _10026_/A VPWR VGND sg13cmos5l_a21oi_1
XFILLER_88_684 VPWR VGND sg13cmos5l_fill_2
XFILLER_76_824 VPWR VGND sg13cmos5l_decap_8
XFILLER_48_504 VPWR VGND sg13cmos5l_fill_2
Xhold2782 hold2782/X _11646_/Q VPWR VGND sg13cmos5l_dlygate4sd3_1
Xhold2760 _05976_/A _10847_/Q VPWR VGND sg13cmos5l_dlygate4sd3_1
Xhold2771 _10848_/D _07228_/Y VPWR VGND sg13cmos5l_dlygate4sd3_1
X_11254__1647 _11254_/RESET_B VPWR VGND sg13cmos5l_tiehi
XFILLER_91_827 VPWR VGND sg13cmos5l_fill_2
Xhold2793 hold2793/X _11405_/Q VPWR VGND sg13cmos5l_dlygate4sd3_1
XFILLER_28_261 VPWR VGND sg13cmos5l_decap_4
X_10954_ _10954_/Q _11646_/CLK _10954_/D _10954_/RESET_B VPWR VGND sg13cmos5l_dfrbpq_1
XFILLER_44_754 VPWR VGND sg13cmos5l_fill_1
XFILLER_43_242 VPWR VGND sg13cmos5l_fill_1
XFILLER_43_220 VPWR VGND sg13cmos5l_fill_1
X_10885_ _10885_/Q _11767_/CLK _10885_/D _10885_/RESET_B VPWR VGND sg13cmos5l_dfrbpq_1
XFILLER_12_651 VPWR VGND sg13cmos5l_decap_8
XFILLER_12_662 VPWR VGND sg13cmos5l_fill_1
XFILLER_7_110 VPWR VGND sg13cmos5l_fill_1
X_10999__983 _10999_/RESET_B VPWR VGND sg13cmos5l_tiehi
X_11506_ _11506_/Q clkload38/A _11506_/D _11506_/RESET_B VPWR VGND sg13cmos5l_dfrbpq_1
X_11437_ _11437_/Q _11535_/CLK _11437_/D _11437_/RESET_B VPWR VGND sg13cmos5l_dfrbpq_1
X_11368_ _11368_/Q clkload51/A _11368_/D _11368_/RESET_B VPWR VGND sg13cmos5l_dfrbpq_1
X_10319_ _10319_/Y _11464_/Q _06085_/A _10318_/X _10353_/A _10168_/B VPWR VGND sg13cmos5l_a221oi_1
XFILLER_4_872 VPWR VGND sg13cmos5l_decap_4
X_11299_ _11299_/Q clkload46/A _11299_/D _11299_/RESET_B VPWR VGND sg13cmos5l_dfrbpq_1
XFILLER_79_640 VPWR VGND sg13cmos5l_decap_8
XFILLER_26_1011 VPWR VGND sg13cmos5l_decap_8
XFILLER_66_312 VPWR VGND sg13cmos5l_fill_2
XFILLER_66_301 VPWR VGND sg13cmos5l_fill_2
XFILLER_39_504 VPWR VGND sg13cmos5l_decap_8
X_05860_ _05860_/Y _07651_/S VPWR VGND sg13cmos5l_inv_1
XFILLER_94_687 VPWR VGND sg13cmos5l_fill_1
XFILLER_19_272 VPWR VGND sg13cmos5l_fill_2
X_07530_ _07530_/Y _07530_/A _07530_/B VPWR VGND sg13cmos5l_nor2_1
XFILLER_90_893 VPWR VGND sg13cmos5l_decap_8
XFILLER_90_871 VPWR VGND sg13cmos5l_decap_4
XFILLER_50_713 VPWR VGND sg13cmos5l_fill_1
X_07461_ _07461_/Y _07461_/A _07482_/B VPWR VGND sg13cmos5l_nor2_1
XFILLER_34_264 VPWR VGND sg13cmos5l_decap_8
XFILLER_97_0 VPWR VGND sg13cmos5l_decap_8
X_06412_ _06419_/B _06271_/D _06389_/C _06328_/D VPWR VGND sg13cmos5l_a21o_1
X_07392_ _08746_/A _11448_/Q _07416_/B VPWR VGND sg13cmos5l_nand2_1
XFILLER_50_757 VPWR VGND sg13cmos5l_decap_8
XFILLER_22_459 VPWR VGND sg13cmos5l_decap_8
X_09200_ _09514_/A _09559_/A _10840_/Q VPWR VGND sg13cmos5l_xnor2_1
X_06343_ _06343_/Y _10710_/B _09303_/D _10711_/A VPWR VGND sg13cmos5l_nor3_1
X_09131_ _09131_/Y _09131_/A _09131_/B VPWR VGND sg13cmos5l_nor2_1
XFILLER_33_1015 VPWR VGND sg13cmos5l_fill_1
X_09062_ _09062_/Y _09059_/Y _09061_/Y _09052_/A VPWR VGND sg13cmos5l_o21ai_1
X_06274_ _06274_/Y _11492_/Q _06274_/B VPWR VGND sg13cmos5l_nor2_1
X_11332__1569 _11332_/RESET_B VPWR VGND sg13cmos5l_tiehi
X_08013_ _08013_/Y _08013_/A _08013_/B VPWR VGND sg13cmos5l_nor2_1
XFILLER_103_203 VPWR VGND sg13cmos5l_decap_8
XFILLER_98_960 VPWR VGND sg13cmos5l_fill_1
Xhold2001 _08374_/A _11273_/Q VPWR VGND sg13cmos5l_dlygate4sd3_1
X_09964_ _09964_/Y _11301_/Q _09903_/B _09963_/Y VPWR VGND sg13cmos5l_o21ai_1
Xhold2012 _08076_/A _11127_/Q VPWR VGND sg13cmos5l_dlygate4sd3_1
Xhold2034 _07970_/A _11075_/Q VPWR VGND sg13cmos5l_dlygate4sd3_1
X_09895_ _09895_/Y _11011_/Q _10039_/B _10046_/B1 VPWR VGND sg13cmos5l_a21oi_1
Xhold2023 _08498_/A _11334_/Q VPWR VGND sg13cmos5l_dlygate4sd3_1
X_08915_ _08940_/A _08915_/A _08961_/A VPWR VGND sg13cmos5l_and2_1
Xhold2045 _08336_/A _11254_/Q VPWR VGND sg13cmos5l_dlygate4sd3_1
XFILLER_100_943 VPWR VGND sg13cmos5l_fill_1
Xhold2056 _07788_/A _10986_/Q VPWR VGND sg13cmos5l_dlygate4sd3_1
Xhold2067 _10744_/B _11565_/Q VPWR VGND sg13cmos5l_dlygate4sd3_1
XFILLER_85_654 VPWR VGND sg13cmos5l_fill_2
XFILLER_84_120 VPWR VGND sg13cmos5l_decap_8
Xhold2078 _09055_/A _11447_/Q VPWR VGND sg13cmos5l_dlygate4sd3_1
XFILLER_57_312 VPWR VGND sg13cmos5l_fill_1
X_08846_ _08846_/Y _08846_/A _08846_/B VPWR VGND sg13cmos5l_nand2_1
XFILLER_40_1019 VPWR VGND sg13cmos5l_decap_8
Xhold2089 _09108_/A _11451_/Q VPWR VGND sg13cmos5l_dlygate4sd3_1
X_05989_ _10827_/D _10787_/A _06853_/A _06946_/D VPWR VGND sg13cmos5l_or3_1
X_08777_ _08777_/X _08651_/A _10704_/B _08776_/Y VPWR VGND sg13cmos5l_a21o_1
XFILLER_26_732 VPWR VGND sg13cmos5l_decap_8
XFILLER_27_46 VPWR VGND sg13cmos5l_fill_2
XFILLER_27_57 VPWR VGND sg13cmos5l_decap_4
XFILLER_27_68 VPWR VGND sg13cmos5l_decap_4
X_07728_ _07728_/Y _07728_/A _07746_/B VPWR VGND sg13cmos5l_nor2_1
XFILLER_26_754 VPWR VGND sg13cmos5l_decap_8
XFILLER_26_765 VPWR VGND sg13cmos5l_fill_2
X_07659_ _10923_/D _08053_/A1 _07714_/B _07658_/Y VPWR VGND sg13cmos5l_a21oi_1
XFILLER_53_562 VPWR VGND sg13cmos5l_decap_8
XFILLER_41_702 VPWR VGND sg13cmos5l_decap_8
XFILLER_25_275 VPWR VGND sg13cmos5l_decap_4
X_10670_ _10670_/Y _10666_/Y _10668_/Y _10669_/Y VPWR VGND sg13cmos5l_o21ai_1
XFILLER_41_757 VPWR VGND sg13cmos5l_fill_2
XFILLER_40_223 VPWR VGND sg13cmos5l_decap_4
X_09329_ _09329_/Y _09537_/A _09326_/Y _09328_/Y _09301_/S VPWR VGND sg13cmos5l_a22oi_1
XFILLER_40_245 VPWR VGND sg13cmos5l_fill_1
XFILLER_9_419 VPWR VGND sg13cmos5l_decap_4
XFILLER_21_481 VPWR VGND sg13cmos5l_decap_4
XFILLER_5_603 VPWR VGND sg13cmos5l_fill_1
X_11308__1593 _11308_/RESET_B VPWR VGND sg13cmos5l_tiehi
X_11222_ _11222_/Q clkload9/A _11222_/D _11222_/RESET_B VPWR VGND sg13cmos5l_dfrbpq_1
XFILLER_5_669 VPWR VGND sg13cmos5l_fill_2
X_11055__870 _11055_/RESET_B VPWR VGND sg13cmos5l_tiehi
XFILLER_4_39 VPWR VGND sg13cmos5l_decap_8
XFILLER_4_28 VPWR VGND sg13cmos5l_decap_8
XFILLER_1_831 VPWR VGND sg13cmos5l_decap_8
X_11153_ _11153_/Q clkload35/A _11153_/D _11153_/RESET_B VPWR VGND sg13cmos5l_dfrbpq_1
XFILLER_49_824 VPWR VGND sg13cmos5l_decap_8
XFILLER_48_301 VPWR VGND sg13cmos5l_decap_4
X_11084_ _11084_/Q _11352_/CLK _11084_/D _11084_/RESET_B VPWR VGND sg13cmos5l_dfrbpq_1
X_10104_ _10104_/Y _10114_/A1 _05972_/A _10131_/A2 VPWR VGND sg13cmos5l_o21ai_1
XFILLER_102_280 VPWR VGND sg13cmos5l_decap_4
X_10035_ _10035_/Y _11144_/Q _10039_/B _10035_/B1 VPWR VGND sg13cmos5l_a21oi_1
XFILLER_88_492 VPWR VGND sg13cmos5l_decap_4
XFILLER_76_643 VPWR VGND sg13cmos5l_decap_8
XFILLER_49_835 VPWR VGND sg13cmos5l_fill_1
XFILLER_0_385 VPWR VGND sg13cmos5l_fill_1
Xhold2590 _06026_/A _06022_/Y VPWR VGND sg13cmos5l_dlygate4sd3_1
XFILLER_84_41 VPWR VGND sg13cmos5l_fill_1
XFILLER_76_687 VPWR VGND sg13cmos5l_fill_1
XFILLER_76_676 VPWR VGND sg13cmos5l_decap_8
XFILLER_36_507 VPWR VGND sg13cmos5l_fill_2
XFILLER_84_74 VPWR VGND sg13cmos5l_fill_2
XFILLER_84_63 VPWR VGND sg13cmos5l_fill_1
XFILLER_75_186 VPWR VGND sg13cmos5l_decap_4
XFILLER_1_1002 VPWR VGND sg13cmos5l_decap_8
XFILLER_17_710 VPWR VGND sg13cmos5l_decap_8
XFILLER_17_732 VPWR VGND sg13cmos5l_fill_1
XFILLER_29_581 VPWR VGND sg13cmos5l_fill_2
XFILLER_44_551 VPWR VGND sg13cmos5l_fill_1
XFILLER_16_231 VPWR VGND sg13cmos5l_decap_8
XFILLER_17_90 VPWR VGND sg13cmos5l_fill_2
X_10937_ _10937_/Q clkload40/A _10937_/D _10937_/RESET_B VPWR VGND sg13cmos5l_dfrbpq_1
XFILLER_32_724 VPWR VGND sg13cmos5l_fill_1
XFILLER_90_7 VPWR VGND sg13cmos5l_decap_8
X_11062__863 _11062_/RESET_B VPWR VGND sg13cmos5l_tiehi
XFILLER_31_223 VPWR VGND sg13cmos5l_decap_8
XFILLER_32_746 VPWR VGND sg13cmos5l_decap_8
XFILLER_32_757 VPWR VGND sg13cmos5l_fill_2
X_10868_ _10868_/Q clkload12/A _10868_/D _10868_/RESET_B VPWR VGND sg13cmos5l_dfrbpq_1
XFILLER_8_430 VPWR VGND sg13cmos5l_fill_1
XFILLER_9_931 VPWR VGND sg13cmos5l_fill_2
X_10799_ _10799_/Q clkload18/A _10799_/D _10799_/RESET_B VPWR VGND sg13cmos5l_dfrbpq_1
X_11519__1145 _11519_/RESET_B VPWR VGND sg13cmos5l_tiehi
XFILLER_99_735 VPWR VGND sg13cmos5l_fill_1
XFILLER_99_724 VPWR VGND sg13cmos5l_fill_2
XFILLER_4_680 VPWR VGND sg13cmos5l_decap_4
Xfanout409 _09707_/S1 _09715_/B1 VPWR VGND sg13cmos5l_buf_1
XFILLER_100_217 VPWR VGND sg13cmos5l_fill_2
X_06961_ _06961_/Y _06961_/A _07018_/B VPWR VGND sg13cmos5l_nand2_1
X_05912_ _05912_/Y _10827_/Q VPWR VGND sg13cmos5l_inv_1
XFILLER_79_481 VPWR VGND sg13cmos5l_fill_2
X_09680_ _09680_/Y _11035_/Q _09962_/B _09982_/B1 VPWR VGND sg13cmos5l_a21oi_1
XFILLER_39_312 VPWR VGND sg13cmos5l_fill_1
X_08700_ _08931_/A _08700_/A _08700_/B VPWR VGND sg13cmos5l_nand2_1
XFILLER_95_974 VPWR VGND sg13cmos5l_fill_1
X_06892_ _06892_/X _11732_/Q hold2663/X _07091_/S VPWR VGND sg13cmos5l_mux2_1
X_08631_ _11378_/D _11708_/D hold2796/X _08642_/S VPWR VGND sg13cmos5l_mux2_1
XFILLER_55_827 VPWR VGND sg13cmos5l_fill_1
XFILLER_55_816 VPWR VGND sg13cmos5l_fill_1
XFILLER_95_996 VPWR VGND sg13cmos5l_decap_8
XFILLER_82_624 VPWR VGND sg13cmos5l_fill_1
XFILLER_67_687 VPWR VGND sg13cmos5l_fill_2
XFILLER_54_337 VPWR VGND sg13cmos5l_fill_1
XFILLER_54_326 VPWR VGND sg13cmos5l_decap_8
X_08562_ _11365_/D fanout58/X _08563_/B _08561_/Y VPWR VGND sg13cmos5l_a21oi_1
X_08493_ _11331_/D fanout61/X _08504_/B _08492_/Y VPWR VGND sg13cmos5l_o21ai_1
XFILLER_23_724 VPWR VGND sg13cmos5l_decap_4
X_07513_ _08685_/B _11530_/Q _10805_/Q _07527_/S VPWR VGND sg13cmos5l_mux2_1
X_07444_ _07444_/Y _07447_/S _05950_/Y _07652_/A1 VPWR VGND sg13cmos5l_a21oi_1
XFILLER_23_746 VPWR VGND sg13cmos5l_decap_8
Xfanout49 fanout49/X fanout50/X VPWR VGND sg13cmos5l_buf_1
XFILLER_22_245 VPWR VGND sg13cmos5l_decap_8
X_07375_ _07375_/Y _07373_/Y _07374_/Y _07375_/B1 VPWR VGND sg13cmos5l_a21oi_1
XFILLER_31_790 VPWR VGND sg13cmos5l_decap_4
X_09114_ _09114_/Y _09137_/A _09111_/Y _09113_/Y VPWR VGND sg13cmos5l_a21oi_1
X_06326_ _06326_/Y _10611_/A _06323_/Y _06325_/Y VPWR VGND sg13cmos5l_a21oi_1
XFILLER_13_59 VPWR VGND sg13cmos5l_fill_2
X_06257_ _06257_/Y _11513_/Q _09968_/A VPWR VGND sg13cmos5l_nand2_1
X_09045_ _09074_/A _09043_/A _09036_/C _09034_/A VPWR VGND sg13cmos5l_a21o_1
X_11573__1393 _11573_/RESET_B VPWR VGND sg13cmos5l_tiehi
X_11547__1479 _11547_/RESET_B VPWR VGND sg13cmos5l_tiehi
X_10882__1100 _10882_/RESET_B VPWR VGND sg13cmos5l_tiehi
X_06188_ _06205_/A _11487_/Q _07076_/B VPWR VGND sg13cmos5l_xnor2_1
XFILLER_2_639 VPWR VGND sg13cmos5l_decap_4
XFILLER_89_256 VPWR VGND sg13cmos5l_fill_1
XFILLER_89_245 VPWR VGND sg13cmos5l_decap_8
XFILLER_89_289 VPWR VGND sg13cmos5l_fill_1
X_09947_ _09949_/B _09948_/B _09948_/C _09948_/A VPWR VGND sg13cmos5l_a21o_1
XFILLER_58_610 VPWR VGND sg13cmos5l_fill_1
X_09878_ _09878_/Y _05981_/Y _09986_/B _09987_/B1 _09877_/Y VPWR VGND sg13cmos5l_a22oi_1
XFILLER_58_665 VPWR VGND sg13cmos5l_decap_8
XFILLER_57_142 VPWR VGND sg13cmos5l_fill_2
XFILLER_38_78 VPWR VGND sg13cmos5l_fill_1
XFILLER_18_507 VPWR VGND sg13cmos5l_decap_8
X_11171__1730 _11171_/RESET_B VPWR VGND sg13cmos5l_tiehi
XFILLER_58_687 VPWR VGND sg13cmos5l_decap_8
X_08829_ _08829_/Y _08825_/Y _08827_/X _08828_/Y VPWR VGND sg13cmos5l_o21ai_1
XFILLER_45_315 VPWR VGND sg13cmos5l_decap_8
X_10989__993 _10989_/RESET_B VPWR VGND sg13cmos5l_tiehi
XFILLER_45_348 VPWR VGND sg13cmos5l_fill_1
XFILLER_54_44 VPWR VGND sg13cmos5l_fill_2
XFILLER_81_690 VPWR VGND sg13cmos5l_decap_8
X_10722_ _10722_/Y _10717_/Y _10720_/Y _10721_/Y VPWR VGND sg13cmos5l_a21oi_1
XFILLER_54_77 VPWR VGND sg13cmos5l_decap_4
XFILLER_26_595 VPWR VGND sg13cmos5l_decap_8
X_11700__1264 _11700_/RESET_B VPWR VGND sg13cmos5l_tiehi
XFILLER_41_565 VPWR VGND sg13cmos5l_fill_1
XFILLER_13_256 VPWR VGND sg13cmos5l_fill_2
X_10653_ _10665_/B _10653_/A _10857_/Q _10653_/C VPWR VGND sg13cmos5l_nand3_1
XFILLER_13_278 VPWR VGND sg13cmos5l_fill_1
XFILLER_103_1024 VPWR VGND sg13cmos5l_decap_4
XFILLER_70_76 VPWR VGND sg13cmos5l_fill_1
X_10584_ _10585_/B _10584_/A _10622_/A _10584_/C VPWR VGND sg13cmos5l_nand3_1
XFILLER_6_901 VPWR VGND sg13cmos5l_fill_2
Xclkload19 clkload19/Y clkload19/A VPWR VGND sg13cmos5l_inv_1
X_10996__986 _10996_/RESET_B VPWR VGND sg13cmos5l_tiehi
XFILLER_79_74 VPWR VGND sg13cmos5l_fill_1
X_11205_ _11205_/Q clkload54/A _11205_/D _11205_/RESET_B VPWR VGND sg13cmos5l_dfrbpq_1
X_11136_ _11136_/Q clkload57/A _11136_/D _11136_/RESET_B VPWR VGND sg13cmos5l_dfrbpq_1
XFILLER_95_204 VPWR VGND sg13cmos5l_fill_2
XFILLER_68_418 VPWR VGND sg13cmos5l_fill_1
XFILLER_1_650 VPWR VGND sg13cmos5l_decap_8
XFILLER_95_248 VPWR VGND sg13cmos5l_decap_8
X_11610__1368 _11610_/RESET_B VPWR VGND sg13cmos5l_tiehi
XFILLER_49_610 VPWR VGND sg13cmos5l_decap_8
XFILLER_76_451 VPWR VGND sg13cmos5l_fill_1
X_11067_ _11067_/Q clkload54/A _11067_/D _11067_/RESET_B VPWR VGND sg13cmos5l_dfrbpq_1
X_10018_ _10018_/X _11271_/Q _11239_/Q _11207_/Q _11175_/Q _10007_/B _10021_/B1 VPWR
+ VGND sg13cmos5l_mux4_1
XFILLER_95_95 VPWR VGND sg13cmos5l_fill_2
XFILLER_77_996 VPWR VGND sg13cmos5l_decap_8
XFILLER_92_966 VPWR VGND sg13cmos5l_fill_2
XFILLER_63_145 VPWR VGND sg13cmos5l_decap_8
XFILLER_91_476 VPWR VGND sg13cmos5l_fill_2
XFILLER_51_307 VPWR VGND sg13cmos5l_fill_2
XFILLER_45_893 VPWR VGND sg13cmos5l_decap_8
XFILLER_44_370 VPWR VGND sg13cmos5l_fill_1
X_10960__1022 _10960_/RESET_B VPWR VGND sg13cmos5l_tiehi
XFILLER_60_863 VPWR VGND sg13cmos5l_fill_1
XFILLER_20_705 VPWR VGND sg13cmos5l_fill_2
XFILLER_32_543 VPWR VGND sg13cmos5l_fill_2
X_07160_ _11745_/D _05876_/Y _07160_/A2 _07159_/Y VPWR VGND sg13cmos5l_a21oi_1
X_07091_ _11708_/D hold2754/X hold2658/X _07091_/S VPWR VGND sg13cmos5l_mux2_1
X_06111_ _06121_/B _06953_/A input18/X VPWR VGND sg13cmos5l_nor2_1
X_06042_ _06144_/A _11594_/Q _11592_/Q VPWR VGND sg13cmos5l_nor2_1
XFILLER_101_515 VPWR VGND sg13cmos5l_decap_8
XFILLER_99_576 VPWR VGND sg13cmos5l_fill_1
X_09801_ _09802_/C _09902_/A _09796_/X _09800_/Y VPWR VGND sg13cmos5l_o21ai_1
XFILLER_8_1019 VPWR VGND sg13cmos5l_decap_8
Xfanout206 _08143_/B _08169_/B VPWR VGND sg13cmos5l_buf_1
Xfanout217 _08005_/B _08013_/B VPWR VGND sg13cmos5l_buf_1
Xfanout228 _07901_/B _07877_/B VPWR VGND sg13cmos5l_buf_1
X_09732_ _09732_/X _11133_/Q _11101_/Q _11069_/Q _11037_/Q _09733_/S _06477_/B VPWR
+ VGND sg13cmos5l_mux4_1
X_07993_ _07993_/Y _07993_/A _08005_/B VPWR VGND sg13cmos5l_nor2_1
Xfanout239 _07768_/B _07750_/B VPWR VGND sg13cmos5l_buf_1
XFILLER_101_559 VPWR VGND sg13cmos5l_fill_1
X_06944_ _06944_/Y _06944_/A _10776_/B VPWR VGND sg13cmos5l_nand2_1
XFILLER_68_963 VPWR VGND sg13cmos5l_fill_1
XFILLER_67_451 VPWR VGND sg13cmos5l_decap_4
XFILLER_39_142 VPWR VGND sg13cmos5l_fill_1
XFILLER_95_771 VPWR VGND sg13cmos5l_fill_1
X_06875_ _06875_/Y _06875_/A _06875_/B _06875_/C _06875_/D VPWR VGND sg13cmos5l_nor4_1
XFILLER_83_922 VPWR VGND sg13cmos5l_fill_2
XFILLER_82_410 VPWR VGND sg13cmos5l_fill_1
XFILLER_68_996 VPWR VGND sg13cmos5l_fill_1
XFILLER_55_613 VPWR VGND sg13cmos5l_decap_8
X_09663_ _09663_/Y _09656_/Y _09658_/Y _09662_/Y _09851_/B2 VPWR VGND sg13cmos5l_a22oi_1
XFILLER_27_304 VPWR VGND sg13cmos5l_decap_8
XFILLER_55_668 VPWR VGND sg13cmos5l_fill_2
X_08614_ _08615_/B _08614_/A _08614_/B VPWR VGND sg13cmos5l_nor2_1
XFILLER_27_359 VPWR VGND sg13cmos5l_decap_8
X_09594_ _09594_/Y _11128_/Q _09600_/B _09605_/B1 VPWR VGND sg13cmos5l_a21oi_1
XFILLER_39_1021 VPWR VGND sg13cmos5l_decap_8
X_08545_ _08545_/Y _08545_/A _08553_/B VPWR VGND sg13cmos5l_nor2_1
XFILLER_54_189 VPWR VGND sg13cmos5l_decap_4
XFILLER_35_392 VPWR VGND sg13cmos5l_fill_2
X_08476_ _08476_/Y _08476_/A _08496_/B VPWR VGND sg13cmos5l_nand2_1
X_11045__880 _11045_/RESET_B VPWR VGND sg13cmos5l_tiehi
XFILLER_11_716 VPWR VGND sg13cmos5l_fill_1
XFILLER_23_543 VPWR VGND sg13cmos5l_fill_2
XFILLER_23_565 VPWR VGND sg13cmos5l_decap_8
X_07427_ _07427_/Y _11550_/Q _08762_/A VPWR VGND sg13cmos5l_nand2_1
XFILLER_10_226 VPWR VGND sg13cmos5l_fill_2
X_07358_ _07358_/Y _09641_/A _07375_/B1 _07357_/Y VPWR VGND sg13cmos5l_a21oi_1
X_06309_ _06309_/Y _06308_/Y _10583_/A VPWR VGND sg13cmos5l_nand2b_1
X_07289_ _07289_/Y _11527_/Q _08667_/S VPWR VGND sg13cmos5l_nand2_1
X_11381__1517 _11381_/RESET_B VPWR VGND sg13cmos5l_tiehi
X_09028_ _09028_/Y _09036_/B _09028_/B VPWR VGND sg13cmos5l_xnor2_1
X_11189__1712 _11189_/RESET_B VPWR VGND sg13cmos5l_tiehi
XFILLER_105_876 VPWR VGND sg13cmos5l_decap_8
XFILLER_78_716 VPWR VGND sg13cmos5l_decap_4
Xfanout751 _06322_/B hold2899/X VPWR VGND sg13cmos5l_buf_1
X_10846__1150 _10846_/RESET_B VPWR VGND sg13cmos5l_tiehi
Xfanout740 _06236_/A _10426_/B1 VPWR VGND sg13cmos5l_buf_1
X_11052__873 _11052_/RESET_B VPWR VGND sg13cmos5l_tiehi
XFILLER_59_963 VPWR VGND sg13cmos5l_fill_2
XFILLER_49_99 VPWR VGND sg13cmos5l_fill_1
Xfanout762 _10267_/D _06310_/B VPWR VGND sg13cmos5l_buf_1
Xfanout773 _09480_/A _09611_/A VPWR VGND sg13cmos5l_buf_1
Xfanout784 _09354_/A _09376_/A VPWR VGND sg13cmos5l_buf_1
X_11112__1789 _11112_/RESET_B VPWR VGND sg13cmos5l_tiehi
XFILLER_100_581 VPWR VGND sg13cmos5l_decap_8
XFILLER_92_218 VPWR VGND sg13cmos5l_fill_1
Xfanout795 _10653_/A _11420_/Q VPWR VGND sg13cmos5l_buf_1
XFILLER_73_410 VPWR VGND sg13cmos5l_fill_2
X_11503__1177 _11503_/RESET_B VPWR VGND sg13cmos5l_tiehi
XFILLER_73_421 VPWR VGND sg13cmos5l_decap_8
XFILLER_65_98 VPWR VGND sg13cmos5l_decap_8
X_11457__1358 _11457_/RESET_B VPWR VGND sg13cmos5l_tiehi
XFILLER_45_178 VPWR VGND sg13cmos5l_fill_1
XFILLER_92_1012 VPWR VGND sg13cmos5l_decap_8
XFILLER_14_510 VPWR VGND sg13cmos5l_fill_1
XFILLER_26_392 VPWR VGND sg13cmos5l_decap_4
X_11754_ _11754_/Q clkload24/A _11754_/D _11754_/RESET_B VPWR VGND sg13cmos5l_dfrbpq_1
XFILLER_53_1007 VPWR VGND sg13cmos5l_fill_1
X_10705_ _10705_/Y _05862_/Y _10690_/A _10704_/Y VPWR VGND sg13cmos5l_o21ai_1
X_11685_ _11685_/Q clkload23/A _11685_/D _11685_/RESET_B VPWR VGND sg13cmos5l_dfrbpq_1
XFILLER_42_896 VPWR VGND sg13cmos5l_decap_8
XFILLER_42_885 VPWR VGND sg13cmos5l_decap_8
X_10636_ _10639_/A _10578_/A _10633_/Y _10635_/Y VPWR VGND sg13cmos5l_o21ai_1
X_11636__1330 _11636_/RESET_B VPWR VGND sg13cmos5l_tiehi
X_10567_ _10570_/C _10567_/A _10567_/B VPWR VGND sg13cmos5l_nand2_1
XFILLER_6_764 VPWR VGND sg13cmos5l_fill_1
XFILLER_6_753 VPWR VGND sg13cmos5l_fill_2
XFILLER_5_230 VPWR VGND sg13cmos5l_decap_8
XFILLER_10_782 VPWR VGND sg13cmos5l_fill_1
X_10498_ _10499_/B _10474_/A _10569_/A _10497_/Y VPWR VGND sg13cmos5l_a21oi_1
XFILLER_5_274 VPWR VGND sg13cmos5l_fill_1
X_10978__1004 _10978_/RESET_B VPWR VGND sg13cmos5l_tiehi
XFILLER_96_579 VPWR VGND sg13cmos5l_decap_8
X_11119_ _11119_/Q clkload44/A _11119_/D _11119_/RESET_B VPWR VGND sg13cmos5l_dfrbpq_1
Xinput6 input6/X ui_in[13] VPWR VGND sg13cmos5l_buf_1
XFILLER_65_922 VPWR VGND sg13cmos5l_decap_8
XFILLER_49_484 VPWR VGND sg13cmos5l_decap_8
XFILLER_65_966 VPWR VGND sg13cmos5l_fill_2
XFILLER_64_421 VPWR VGND sg13cmos5l_decap_8
XFILLER_37_668 VPWR VGND sg13cmos5l_fill_1
X_06660_ _10805_/D _06668_/A1 _06657_/Y _06659_/Y VPWR VGND sg13cmos5l_o21ai_1
XFILLER_92_796 VPWR VGND sg13cmos5l_fill_1
XFILLER_37_679 VPWR VGND sg13cmos5l_fill_2
XFILLER_36_178 VPWR VGND sg13cmos5l_decap_8
XFILLER_36_167 VPWR VGND sg13cmos5l_fill_1
XFILLER_91_295 VPWR VGND sg13cmos5l_fill_2
XFILLER_52_649 VPWR VGND sg13cmos5l_fill_1
X_06591_ _06591_/Y _06591_/A _06722_/B VPWR VGND sg13cmos5l_nor2_1
XFILLER_17_370 VPWR VGND sg13cmos5l_decap_8
XFILLER_33_841 VPWR VGND sg13cmos5l_fill_1
X_11267__1634 _11267_/RESET_B VPWR VGND sg13cmos5l_tiehi
X_08330_ _08330_/Y _08330_/A _08332_/B VPWR VGND sg13cmos5l_nand2_1
X_08261_ _08261_/Y _08261_/A _08283_/B VPWR VGND sg13cmos5l_nor2_1
X_07212_ _10840_/D _05963_/Y _07212_/A2 _07226_/B1 _07211_/Y VPWR VGND sg13cmos5l_a22oi_1
X_08192_ _08192_/Y _08192_/A _08216_/B VPWR VGND sg13cmos5l_nand2_1
X_07143_ _07143_/Y hold2738/X _07160_/A2 _07155_/B1 VPWR VGND sg13cmos5l_o21ai_1
X_07074_ _07074_/Y _07071_/Y _07073_/Y _06952_/A VPWR VGND sg13cmos5l_o21ai_1
X_06025_ _06026_/C _06811_/A _06019_/B _10727_/B _06796_/A VPWR VGND sg13cmos5l_a22oi_1
XFILLER_0_929 VPWR VGND sg13cmos5l_decap_8
XFILLER_102_846 VPWR VGND sg13cmos5l_decap_8
XFILLER_102_857 VPWR VGND sg13cmos5l_fill_1
X_07976_ _07976_/Y _07976_/A _07976_/B VPWR VGND sg13cmos5l_nand2_1
X_06927_ _06927_/X _06927_/A _06927_/B VPWR VGND sg13cmos5l_and2_1
XFILLER_56_933 VPWR VGND sg13cmos5l_decap_8
X_09715_ _09715_/Y _11356_/Q _09708_/S _09715_/B1 VPWR VGND sg13cmos5l_a21oi_1
XFILLER_28_624 VPWR VGND sg13cmos5l_fill_1
X_09646_ _09647_/D _09558_/C _09644_/Y _09645_/Y VPWR VGND sg13cmos5l_o21ai_1
X_06858_ _06858_/Y _06801_/Y _06851_/Y _06857_/Y VPWR VGND sg13cmos5l_o21ai_1
XFILLER_55_465 VPWR VGND sg13cmos5l_decap_8
XFILLER_27_167 VPWR VGND sg13cmos5l_decap_8
XFILLER_28_679 VPWR VGND sg13cmos5l_fill_1
X_10986__996 _10986_/RESET_B VPWR VGND sg13cmos5l_tiehi
X_06789_ _06875_/A _06825_/A _06801_/B VPWR VGND sg13cmos5l_nand2b_1
XFILLER_82_295 VPWR VGND sg13cmos5l_decap_8
XFILLER_70_424 VPWR VGND sg13cmos5l_decap_4
XFILLER_43_627 VPWR VGND sg13cmos5l_decap_8
X_09577_ _09577_/Y _05966_/Y _09570_/B _09577_/B1 _09576_/Y VPWR VGND sg13cmos5l_a22oi_1
XFILLER_42_137 VPWR VGND sg13cmos5l_decap_8
X_08528_ _11348_/D _08528_/A1 _08527_/B _08527_/Y VPWR VGND sg13cmos5l_a21oi_1
XFILLER_51_693 VPWR VGND sg13cmos5l_decap_8
XFILLER_51_671 VPWR VGND sg13cmos5l_fill_1
X_08459_ _11314_/D _08524_/A1 _08468_/B _08458_/Y VPWR VGND sg13cmos5l_o21ai_1
XFILLER_13_1013 VPWR VGND sg13cmos5l_decap_8
X_11470_ _11470_/Q _11535_/CLK _11470_/D _11470_/RESET_B VPWR VGND sg13cmos5l_dfrbpq_1
X_10421_ _10421_/Y _06150_/B _10495_/A2 _10508_/B1 VPWR VGND sg13cmos5l_a21oi_1
XFILLER_100_1027 VPWR VGND sg13cmos5l_fill_2
X_10352_ _10353_/B _10365_/A _10351_/B _10351_/C VPWR VGND sg13cmos5l_o21ai_1
X_10993__989 _10993_/RESET_B VPWR VGND sg13cmos5l_tiehi
X_10283_ _10286_/A _10288_/A _10281_/X _10248_/X VPWR VGND sg13cmos5l_o21ai_1
XFILLER_105_684 VPWR VGND sg13cmos5l_fill_1
XFILLER_104_161 VPWR VGND sg13cmos5l_decap_8
XFILLER_78_579 VPWR VGND sg13cmos5l_decap_4
XFILLER_66_708 VPWR VGND sg13cmos5l_fill_1
X_11345__1556 _11345_/RESET_B VPWR VGND sg13cmos5l_tiehi
Xfanout570 _10770_/S _06927_/B VPWR VGND sg13cmos5l_buf_1
Xfanout592 _07154_/A2 _07150_/A2 VPWR VGND sg13cmos5l_buf_1
XFILLER_59_793 VPWR VGND sg13cmos5l_decap_4
Xfanout581 _06733_/B _06425_/B VPWR VGND sg13cmos5l_buf_1
XFILLER_86_590 VPWR VGND sg13cmos5l_fill_1
XFILLER_74_752 VPWR VGND sg13cmos5l_fill_1
XFILLER_18_123 VPWR VGND sg13cmos5l_fill_2
XFILLER_92_63 VPWR VGND sg13cmos5l_decap_4
XFILLER_62_958 VPWR VGND sg13cmos5l_decap_8
XFILLER_61_413 VPWR VGND sg13cmos5l_decap_8
XFILLER_18_189 VPWR VGND sg13cmos5l_fill_1
XFILLER_34_638 VPWR VGND sg13cmos5l_decap_8
X_11737_ _11737_/Q clkload22/A _11737_/D _11737_/RESET_B VPWR VGND sg13cmos5l_dfrbpq_1
XFILLER_30_822 VPWR VGND sg13cmos5l_fill_2
XFILLER_30_844 VPWR VGND sg13cmos5l_decap_8
X_11668_ _11668_/Q _11668_/CLK _11668_/D _11668_/RESET_B VPWR VGND sg13cmos5l_dfrbpq_1
X_11599_ _11599_/Q clkload27/A _11599_/D _11599_/RESET_B VPWR VGND sg13cmos5l_dfrbpq_1
X_10619_ _10641_/B _10620_/A _10620_/B VPWR VGND sg13cmos5l_nand2_1
XFILLER_69_502 VPWR VGND sg13cmos5l_decap_4
Xhold2408 _07581_/A _10911_/Q VPWR VGND sg13cmos5l_dlygate4sd3_1
XFILLER_69_524 VPWR VGND sg13cmos5l_decap_4
X_11035__890 _11035_/RESET_B VPWR VGND sg13cmos5l_tiehi
Xhold2419 _07861_/A _11021_/Q VPWR VGND sg13cmos5l_dlygate4sd3_1
X_07830_ _07830_/Y _07830_/A _07836_/B VPWR VGND sg13cmos5l_nand2_1
XFILLER_96_332 VPWR VGND sg13cmos5l_fill_2
XFILLER_84_527 VPWR VGND sg13cmos5l_decap_8
X_07761_ _10973_/D fanout79/X _07760_/B _07760_/Y VPWR VGND sg13cmos5l_a21oi_1
XFILLER_65_741 VPWR VGND sg13cmos5l_decap_4
XFILLER_65_730 VPWR VGND sg13cmos5l_decap_4
XFILLER_2_83 VPWR VGND sg13cmos5l_fill_1
X_09500_ _09500_/Y _05962_/Y _09570_/B _09577_/B1 _09499_/Y VPWR VGND sg13cmos5l_a22oi_1
X_06712_ _06713_/B _06710_/Y _06718_/B _06760_/S VPWR VGND sg13cmos5l_mux2_1
XFILLER_65_774 VPWR VGND sg13cmos5l_fill_1
XFILLER_65_763 VPWR VGND sg13cmos5l_decap_8
X_07692_ _07692_/Y _07692_/A _07702_/B VPWR VGND sg13cmos5l_nor2_1
XFILLER_25_616 VPWR VGND sg13cmos5l_fill_1
XFILLER_92_571 VPWR VGND sg13cmos5l_decap_4
XFILLER_64_262 VPWR VGND sg13cmos5l_fill_1
XFILLER_52_413 VPWR VGND sg13cmos5l_decap_8
XFILLER_37_498 VPWR VGND sg13cmos5l_decap_8
X_06643_ _06643_/Y _06173_/A _06400_/B _06643_/B1 _06642_/X VPWR VGND sg13cmos5l_a22oi_1
XFILLER_25_649 VPWR VGND sg13cmos5l_decap_8
X_09431_ _09432_/B _09431_/A _09536_/B VPWR VGND sg13cmos5l_nand2_1
X_10830__1182 _10830_/RESET_B VPWR VGND sg13cmos5l_tiehi
XFILLER_52_446 VPWR VGND sg13cmos5l_fill_2
X_09362_ _09368_/B _09358_/Y _09359_/Y _09360_/Y _09361_/Y _09602_/C1 VPWR VGND sg13cmos5l_a221oi_1
X_06574_ _06575_/B _06132_/B _10889_/Q _10873_/Q _06574_/B2 VPWR VGND sg13cmos5l_a22oi_1
X_08313_ _11242_/D _08313_/A1 _08364_/B _08312_/Y VPWR VGND sg13cmos5l_o21ai_1
XFILLER_61_980 VPWR VGND sg13cmos5l_decap_8
X_11042__883 _11042_/RESET_B VPWR VGND sg13cmos5l_tiehi
X_09293_ _09293_/Y _11369_/Q _10034_/B _10021_/B1 VPWR VGND sg13cmos5l_a21oi_1
XANTENNA_11 _11511_/Q VPWR VGND sg13cmos5l_antennanp
XFILLER_21_833 VPWR VGND sg13cmos5l_decap_8
XFILLER_21_844 VPWR VGND sg13cmos5l_fill_1
XFILLER_21_855 VPWR VGND sg13cmos5l_fill_1
X_08244_ _08244_/Y _08244_/A _08244_/B VPWR VGND sg13cmos5l_nand2_1
XFILLER_20_365 VPWR VGND sg13cmos5l_decap_8
X_08175_ _08175_/Y _08175_/A _08177_/B VPWR VGND sg13cmos5l_nor2_1
X_10803__940 _10803_/RESET_B VPWR VGND sg13cmos5l_tiehi
X_07126_ _11728_/D _05877_/Y _07126_/A2 _07125_/Y VPWR VGND sg13cmos5l_a21oi_1
XFILLER_21_59 VPWR VGND sg13cmos5l_fill_2
XFILLER_106_448 VPWR VGND sg13cmos5l_decap_8
X_07057_ _07057_/X hold2509/X _07060_/A2 _07056_/Y VPWR VGND sg13cmos5l_a21o_1
X_11620__1351 _11620_/RESET_B VPWR VGND sg13cmos5l_tiehi
X_06008_ _06008_/Y _11757_/Q _11758_/Q VPWR VGND sg13cmos5l_nor2_1
XFILLER_0_737 VPWR VGND sg13cmos5l_decap_8
XFILLER_99_192 VPWR VGND sg13cmos5l_decap_8
XFILLER_88_877 VPWR VGND sg13cmos5l_decap_4
XFILLER_88_855 VPWR VGND sg13cmos5l_decap_8
Xhold2931 _06262_/A _11512_/Q VPWR VGND sg13cmos5l_dlygate4sd3_1
Xhold2920 hold2920/X _10853_/Q VPWR VGND sg13cmos5l_dlygate4sd3_1
XFILLER_48_708 VPWR VGND sg13cmos5l_fill_1
Xhold2953 _06394_/B _11610_/Q VPWR VGND sg13cmos5l_dlygate4sd3_1
Xhold2942 _10551_/A _11414_/Q VPWR VGND sg13cmos5l_dlygate4sd3_1
XFILLER_101_175 VPWR VGND sg13cmos5l_decap_8
XFILLER_75_538 VPWR VGND sg13cmos5l_fill_2
X_07959_ _11069_/D fanout78/X _07958_/B _07958_/Y VPWR VGND sg13cmos5l_o21ai_1
XFILLER_16_605 VPWR VGND sg13cmos5l_fill_1
X_10970_ _10970_/Q clkload40/A _10970_/D _10970_/RESET_B VPWR VGND sg13cmos5l_dfrbpq_1
XFILLER_46_89 VPWR VGND sg13cmos5l_decap_8
X_09629_ _09629_/Y _11129_/Q _09630_/B _09659_/S1 VPWR VGND sg13cmos5l_a21oi_1
XFILLER_71_755 VPWR VGND sg13cmos5l_decap_8
XFILLER_43_457 VPWR VGND sg13cmos5l_fill_2
XFILLER_15_137 VPWR VGND sg13cmos5l_fill_2
XFILLER_102_84 VPWR VGND sg13cmos5l_decap_8
XFILLER_12_800 VPWR VGND sg13cmos5l_decap_8
X_11668__1296 _11668_/RESET_B VPWR VGND sg13cmos5l_tiehi
XFILLER_24_693 VPWR VGND sg13cmos5l_fill_2
Xclkbuf_leaf_50_clk _11349_/CLK clkload4/A VPWR VGND sg13cmos5l_buf_8
X_11522_ _11522_/Q clkload14/A _11522_/D _11522_/RESET_B VPWR VGND sg13cmos5l_dfrbpq_1
XFILLER_7_303 VPWR VGND sg13cmos5l_fill_1
XFILLER_7_28 VPWR VGND sg13cmos5l_decap_8
X_11453_ _11453_/Q clkload52/A _11453_/D _11453_/RESET_B VPWR VGND sg13cmos5l_dfrbpq_1
X_10404_ _10422_/B _10426_/A1 _10298_/A _09696_/A _10436_/B2 VPWR VGND sg13cmos5l_a22oi_1
X_11384_ _11384_/Q _11713_/CLK _11384_/D _11384_/RESET_B VPWR VGND sg13cmos5l_dfrbpq_1
X_10335_ _10335_/Y _10333_/A _10334_/Y _10353_/A VPWR VGND sg13cmos5l_o21ai_1
XFILLER_105_481 VPWR VGND sg13cmos5l_decap_8
XFILLER_78_310 VPWR VGND sg13cmos5l_fill_2
X_10266_ _10270_/B _10267_/A _10267_/D VPWR VGND sg13cmos5l_nand2_1
XFILLER_78_343 VPWR VGND sg13cmos5l_fill_1
X_10197_ _10197_/Y _06908_/A _07067_/X _10166_/X hold2792/X VPWR VGND sg13cmos5l_a22oi_1
XFILLER_4_1000 VPWR VGND sg13cmos5l_decap_8
XFILLER_23_8 VPWR VGND sg13cmos5l_fill_1
XFILLER_66_538 VPWR VGND sg13cmos5l_fill_1
XFILLER_93_368 VPWR VGND sg13cmos5l_fill_1
XFILLER_59_1002 VPWR VGND sg13cmos5l_decap_4
XFILLER_46_273 VPWR VGND sg13cmos5l_fill_2
XFILLER_35_947 VPWR VGND sg13cmos5l_decap_8
XFILLER_99_4 VPWR VGND sg13cmos5l_decap_8
XFILLER_61_265 VPWR VGND sg13cmos5l_fill_2
XFILLER_15_682 VPWR VGND sg13cmos5l_fill_1
Xclkbuf_leaf_41_clk clkload54/A clkbuf_4_14_0_clk/X VPWR VGND sg13cmos5l_buf_8
X_12769_ _12769_/X _12769_/A VPWR VGND sg13cmos5l_buf_1
X_06290_ _06291_/B _11499_/Q _09214_/A VPWR VGND sg13cmos5l_nand2b_1
Xinput20 input20/X uio_in[2] VPWR VGND sg13cmos5l_buf_1
X_11713__1251 _11713_/RESET_B VPWR VGND sg13cmos5l_tiehi
XFILLER_104_908 VPWR VGND sg13cmos5l_decap_8
X_09980_ _09980_/Y _10982_/Q _09962_/B _09991_/B1 VPWR VGND sg13cmos5l_a21oi_1
XFILLER_103_429 VPWR VGND sg13cmos5l_fill_2
XFILLER_103_418 VPWR VGND sg13cmos5l_decap_8
X_11426__1438 _11426_/RESET_B VPWR VGND sg13cmos5l_tiehi
X_08931_ _08931_/Y _08931_/A _08931_/B VPWR VGND sg13cmos5l_xnor2_1
X_08862_ _08864_/B _08862_/A _08862_/B VPWR VGND sg13cmos5l_nor2_1
Xhold2216 _10864_/D _07282_/Y VPWR VGND sg13cmos5l_dlygate4sd3_1
Xhold2227 _07678_/A _10933_/Q VPWR VGND sg13cmos5l_dlygate4sd3_1
Xhold2205 _07877_/A _11029_/Q VPWR VGND sg13cmos5l_dlygate4sd3_1
XFILLER_97_674 VPWR VGND sg13cmos5l_fill_1
XFILLER_85_836 VPWR VGND sg13cmos5l_fill_1
X_11477__1229 _11477_/RESET_B VPWR VGND sg13cmos5l_tiehi
Xhold2238 _07750_/A _10968_/Q VPWR VGND sg13cmos5l_dlygate4sd3_1
X_07813_ _10998_/D _08075_/A1 _07813_/A2 _07812_/Y VPWR VGND sg13cmos5l_o21ai_1
Xhold2249 _08391_/A _11281_/Q VPWR VGND sg13cmos5l_dlygate4sd3_1
XFILLER_84_335 VPWR VGND sg13cmos5l_fill_2
XFILLER_84_324 VPWR VGND sg13cmos5l_decap_8
X_08793_ _08795_/A _08793_/A _08793_/B VPWR VGND sg13cmos5l_nand2_1
X_07744_ _07744_/Y _07744_/A _07768_/B VPWR VGND sg13cmos5l_nor2_1
XFILLER_93_891 VPWR VGND sg13cmos5l_fill_1
XFILLER_38_796 VPWR VGND sg13cmos5l_fill_2
X_07675_ _10931_/D _08526_/A1 _07676_/B _07674_/Y VPWR VGND sg13cmos5l_a21oi_1
XFILLER_53_766 VPWR VGND sg13cmos5l_decap_8
X_09414_ _09414_/Y _10929_/Q _09841_/B VPWR VGND sg13cmos5l_nand2_1
X_06626_ _06627_/B _06626_/A _06625_/Y VPWR VGND sg13cmos5l_nor2b_1
X_10983__999 _10983_/RESET_B VPWR VGND sg13cmos5l_tiehi
XFILLER_52_254 VPWR VGND sg13cmos5l_decap_8
Xclkbuf_leaf_32_clk clkload50/A clkload5/A VPWR VGND sg13cmos5l_buf_8
X_06557_ _06557_/Y _06557_/A _06557_/B VPWR VGND sg13cmos5l_nand2_1
X_09345_ _09345_/Y _09345_/A _09345_/B VPWR VGND sg13cmos5l_nor2_1
X_09276_ _09276_/Y _11621_/Q _11620_/Q _11613_/Q _11612_/Q VPWR VGND sg13cmos5l_nor4_1
X_06488_ _06488_/Y _06506_/B _06507_/A _10164_/B VPWR VGND sg13cmos5l_nor3_1
XFILLER_21_652 VPWR VGND sg13cmos5l_fill_2
X_08227_ _11200_/D fanout72/X _08236_/B _08226_/Y VPWR VGND sg13cmos5l_o21ai_1
XFILLER_4_306 VPWR VGND sg13cmos5l_fill_1
X_08158_ _11166_/D fanout76/X _08171_/B _08157_/Y VPWR VGND sg13cmos5l_a21oi_1
XFILLER_4_339 VPWR VGND sg13cmos5l_fill_1
XFILLER_106_245 VPWR VGND sg13cmos5l_decap_8
X_07109_ _07109_/Y hold2749/X _07132_/A2 _07155_/B1 VPWR VGND sg13cmos5l_o21ai_1
X_08089_ _11133_/D fanout78/X _08088_/B _08088_/Y VPWR VGND sg13cmos5l_o21ai_1
X_10120_ _10120_/Y _10250_/B _10135_/B VPWR VGND sg13cmos5l_nand2_1
XFILLER_88_652 VPWR VGND sg13cmos5l_fill_1
X_10051_ _10055_/B _10051_/A _10051_/B VPWR VGND sg13cmos5l_nor2_1
XFILLER_103_996 VPWR VGND sg13cmos5l_decap_8
XFILLER_88_674 VPWR VGND sg13cmos5l_fill_1
Xhold2750 _05879_/A _11742_/Q VPWR VGND sg13cmos5l_dlygate4sd3_1
XFILLER_76_847 VPWR VGND sg13cmos5l_fill_2
Xhold2783 _10794_/D _06580_/Y VPWR VGND sg13cmos5l_dlygate4sd3_1
Xhold2761 _10847_/D _07226_/Y VPWR VGND sg13cmos5l_dlygate4sd3_1
XFILLER_57_77 VPWR VGND sg13cmos5l_decap_8
Xhold2772 hold2772/X _11697_/Q VPWR VGND sg13cmos5l_dlygate4sd3_1
Xhold2794 _10604_/A _11418_/Q VPWR VGND sg13cmos5l_dlygate4sd3_1
XFILLER_29_752 VPWR VGND sg13cmos5l_decap_8
X_10953_ _10953_/Q clkload51/A _10953_/D _10953_/RESET_B VPWR VGND sg13cmos5l_dfrbpq_1
XFILLER_56_582 VPWR VGND sg13cmos5l_decap_8
XFILLER_28_284 VPWR VGND sg13cmos5l_decap_4
XFILLER_29_785 VPWR VGND sg13cmos5l_decap_8
X_10884_ _10884_/Q clkload13/A _10884_/D _10884_/RESET_B VPWR VGND sg13cmos5l_dfrbpq_1
Xclkbuf_leaf_23_clk _11594_/CLK clkload2/A VPWR VGND sg13cmos5l_buf_8
XFILLER_106_1022 VPWR VGND sg13cmos5l_decap_8
XFILLER_11_140 VPWR VGND sg13cmos5l_decap_8
XFILLER_8_645 VPWR VGND sg13cmos5l_fill_1
X_11505_ _11505_/Q clkload38/A _11505_/D _11505_/RESET_B VPWR VGND sg13cmos5l_dfrbpq_1
XFILLER_89_1028 VPWR VGND sg13cmos5l_fill_1
XFILLER_7_155 VPWR VGND sg13cmos5l_fill_1
X_11436_ _11436_/Q _11535_/CLK _11436_/D _11436_/RESET_B VPWR VGND sg13cmos5l_dfrbpq_1
XFILLER_22_80 VPWR VGND sg13cmos5l_fill_2
X_11367_ _11367_/Q clkload49/A _11367_/D _11367_/RESET_B VPWR VGND sg13cmos5l_dfrbpq_1
XFILLER_98_84 VPWR VGND sg13cmos5l_decap_8
X_10318_ _10318_/X _10334_/B _10318_/B VPWR VGND sg13cmos5l_and2_1
X_11298_ _11298_/Q _11362_/CLK _11298_/D _11298_/RESET_B VPWR VGND sg13cmos5l_dfrbpq_1
XFILLER_79_630 VPWR VGND sg13cmos5l_decap_4
XFILLER_78_162 VPWR VGND sg13cmos5l_decap_8
X_10249_ _10279_/A _10285_/A _10289_/A VPWR VGND sg13cmos5l_nand2_1
XFILLER_93_121 VPWR VGND sg13cmos5l_fill_1
XFILLER_66_324 VPWR VGND sg13cmos5l_fill_2
X_11032__893 _11032_/RESET_B VPWR VGND sg13cmos5l_tiehi
XFILLER_35_722 VPWR VGND sg13cmos5l_fill_1
X_07460_ _07460_/Y _07452_/B _07457_/X _07458_/X _07459_/Y VPWR VGND sg13cmos5l_a22oi_1
X_06411_ _06411_/Y _06385_/C _06408_/Y _06410_/Y VPWR VGND sg13cmos5l_o21ai_1
X_07391_ _07391_/Y _11544_/Q _08750_/A VPWR VGND sg13cmos5l_nand2_1
XFILLER_16_991 VPWR VGND sg13cmos5l_decap_8
XFILLER_22_427 VPWR VGND sg13cmos5l_fill_1
XFILLER_22_449 VPWR VGND sg13cmos5l_fill_2
X_11125__1776 _11125_/RESET_B VPWR VGND sg13cmos5l_tiehi
X_06342_ _10711_/A _10703_/A _10691_/D VPWR VGND sg13cmos5l_nand2_1
X_09130_ _09130_/Y _09124_/Y _09128_/Y _09129_/Y VPWR VGND sg13cmos5l_o21ai_1
Xclkbuf_leaf_14_clk clkload23/A clkbuf_4_4_0_clk/X VPWR VGND sg13cmos5l_buf_8
XFILLER_31_950 VPWR VGND sg13cmos5l_fill_2
XFILLER_31_961 VPWR VGND sg13cmos5l_decap_4
X_09061_ _09061_/Y _09061_/A _09066_/B VPWR VGND sg13cmos5l_nand2_1
XFILLER_30_471 VPWR VGND sg13cmos5l_decap_8
XFILLER_30_482 VPWR VGND sg13cmos5l_fill_2
XFILLER_31_983 VPWR VGND sg13cmos5l_decap_8
X_06273_ _06273_/Y _11518_/Q _09270_/A VPWR VGND sg13cmos5l_nor2b_1
X_08012_ _11095_/D _08339_/A1 _08011_/B _08011_/Y VPWR VGND sg13cmos5l_a21oi_1
X_11340__1561 _11340_/RESET_B VPWR VGND sg13cmos5l_tiehi
XFILLER_89_438 VPWR VGND sg13cmos5l_fill_2
X_09963_ _09963_/Y _05983_/Y _09981_/B _09982_/B1 _09962_/Y VPWR VGND sg13cmos5l_a22oi_1
Xhold2002 _07790_/A _10987_/Q VPWR VGND sg13cmos5l_dlygate4sd3_1
X_08914_ _08961_/A _08914_/A _08921_/B VPWR VGND sg13cmos5l_xnor2_1
Xhold2013 _08092_/A _11135_/Q VPWR VGND sg13cmos5l_dlygate4sd3_1
XFILLER_103_259 VPWR VGND sg13cmos5l_decap_8
XFILLER_98_972 VPWR VGND sg13cmos5l_decap_8
X_09894_ _09894_/Y _10979_/Q _09894_/B VPWR VGND sg13cmos5l_nand2_1
XFILLER_69_151 VPWR VGND sg13cmos5l_decap_8
Xhold2024 _06963_/A _11650_/Q VPWR VGND sg13cmos5l_dlygate4sd3_1
Xhold2035 _07022_/A _11667_/Q VPWR VGND sg13cmos5l_dlygate4sd3_1
XFILLER_100_922 VPWR VGND sg13cmos5l_fill_2
Xhold2068 _11565_/D _10743_/Y VPWR VGND sg13cmos5l_dlygate4sd3_1
Xhold2079 _10755_/A _11573_/Q VPWR VGND sg13cmos5l_dlygate4sd3_1
XFILLER_85_644 VPWR VGND sg13cmos5l_fill_1
XFILLER_57_324 VPWR VGND sg13cmos5l_decap_8
X_08845_ _11430_/D _08843_/Y _08844_/Y _08834_/Y VPWR VGND sg13cmos5l_o21ai_1
Xhold2057 _07938_/A _11059_/Q VPWR VGND sg13cmos5l_dlygate4sd3_1
Xhold2046 _07014_/A _11665_/Q VPWR VGND sg13cmos5l_dlygate4sd3_1
X_08776_ _08776_/Y _08653_/Y _08774_/Y _08775_/Y VPWR VGND sg13cmos5l_a21oi_1
XFILLER_27_14 VPWR VGND sg13cmos5l_decap_4
XFILLER_100_999 VPWR VGND sg13cmos5l_decap_8
X_05988_ _10828_/D _10791_/A _06855_/A _06821_/A VPWR VGND sg13cmos5l_or3_1
X_07727_ _10956_/D _08512_/A1 _07750_/B _07726_/Y VPWR VGND sg13cmos5l_a21oi_1
XFILLER_38_593 VPWR VGND sg13cmos5l_decap_4
XFILLER_25_232 VPWR VGND sg13cmos5l_fill_1
X_07658_ _07658_/Y _07658_/A _07714_/B VPWR VGND sg13cmos5l_nor2_1
XFILLER_81_872 VPWR VGND sg13cmos5l_decap_4
XFILLER_41_725 VPWR VGND sg13cmos5l_fill_1
XFILLER_40_202 VPWR VGND sg13cmos5l_decap_8
XFILLER_25_243 VPWR VGND sg13cmos5l_fill_2
XFILLER_25_254 VPWR VGND sg13cmos5l_fill_2
XFILLER_26_799 VPWR VGND sg13cmos5l_decap_8
XFILLER_43_35 VPWR VGND sg13cmos5l_fill_1
X_07589_ _07589_/X _07651_/S _10816_/Q VPWR VGND sg13cmos5l_and2_1
Xclkbuf_4_8_0_clk clkbuf_4_8_0_clk/X clkbuf_0_clk/X VPWR VGND sg13cmos5l_buf_8
X_06609_ _06609_/Y _06282_/X _06283_/Y _06631_/S VPWR VGND sg13cmos5l_a21oi_1
X_09328_ _09328_/Y _09346_/A _09336_/B _09379_/B VPWR VGND sg13cmos5l_o21ai_1
XFILLER_22_972 VPWR VGND sg13cmos5l_fill_2
XFILLER_22_983 VPWR VGND sg13cmos5l_decap_8
X_10914__1068 _10914_/RESET_B VPWR VGND sg13cmos5l_tiehi
X_09259_ _09976_/A _09259_/A _09259_/B VPWR VGND sg13cmos5l_nand2_1
XFILLER_4_114 VPWR VGND sg13cmos5l_decap_8
XFILLER_4_147 VPWR VGND sg13cmos5l_decap_8
X_11221_ _11221_/Q clkload40/A _11221_/D _11221_/RESET_B VPWR VGND sg13cmos5l_dfrbpq_1
X_11152_ _11152_/Q _11668_/CLK _11152_/D _11152_/RESET_B VPWR VGND sg13cmos5l_dfrbpq_1
X_10103_ _11502_/D _06146_/A _10115_/A2 _10102_/Y VPWR VGND sg13cmos5l_a21o_1
X_11083_ _11083_/Q clkload32/A _11083_/D _11083_/RESET_B VPWR VGND sg13cmos5l_dfrbpq_1
XFILLER_103_793 VPWR VGND sg13cmos5l_fill_2
X_10034_ _10034_/Y _11112_/Q _10034_/B VPWR VGND sg13cmos5l_nand2_1
X_11203__1698 _11203_/RESET_B VPWR VGND sg13cmos5l_tiehi
XFILLER_76_622 VPWR VGND sg13cmos5l_fill_1
Xhold2580 _11607_/D _06822_/Y VPWR VGND sg13cmos5l_dlygate4sd3_1
XFILLER_48_368 VPWR VGND sg13cmos5l_decap_4
Xhold2591 _07341_/A _10874_/Q VPWR VGND sg13cmos5l_dlygate4sd3_1
XFILLER_95_1010 VPWR VGND sg13cmos5l_decap_8
XFILLER_57_891 VPWR VGND sg13cmos5l_decap_4
Xhold1890 _11437_/D _08935_/Y VPWR VGND sg13cmos5l_dlygate4sd3_1
XFILLER_44_563 VPWR VGND sg13cmos5l_fill_1
X_10936_ _10936_/Q _11349_/CLK _10936_/D _10936_/RESET_B VPWR VGND sg13cmos5l_dfrbpq_1
XFILLER_16_254 VPWR VGND sg13cmos5l_fill_1
XFILLER_32_714 VPWR VGND sg13cmos5l_decap_4
X_10867_ _10867_/Q clkload13/A _10867_/D _10867_/RESET_B VPWR VGND sg13cmos5l_dfrbpq_1
XFILLER_31_257 VPWR VGND sg13cmos5l_decap_4
XFILLER_83_7 VPWR VGND sg13cmos5l_decap_8
X_10798_ _10798_/Q clkload18/A _10798_/D _10798_/RESET_B VPWR VGND sg13cmos5l_dfrbpq_1
XFILLER_12_471 VPWR VGND sg13cmos5l_fill_2
XFILLER_31_279 VPWR VGND sg13cmos5l_decap_4
XFILLER_9_998 VPWR VGND sg13cmos5l_decap_8
X_11419_ _11419_/Q clkload53/A _11419_/D _11419_/RESET_B VPWR VGND sg13cmos5l_dfrbpq_1
XFILLER_99_747 VPWR VGND sg13cmos5l_decap_8
XFILLER_87_909 VPWR VGND sg13cmos5l_fill_1
XFILLER_3_180 VPWR VGND sg13cmos5l_fill_2
XFILLER_101_719 VPWR VGND sg13cmos5l_decap_4
XFILLER_98_268 VPWR VGND sg13cmos5l_decap_8
X_06960_ _06960_/Y _07008_/A _07034_/B _06959_/Y VPWR VGND sg13cmos5l_o21ai_1
Xclkbuf_leaf_3_clk clkload12/A clkbuf_4_1_0_clk/X VPWR VGND sg13cmos5l_buf_8
X_06891_ _11630_/D _11699_/D hold2781/X _08640_/A VPWR VGND sg13cmos5l_mux2_1
X_05911_ _05911_/Y _09557_/A VPWR VGND sg13cmos5l_inv_1
X_08630_ _11377_/D _07389_/B _08630_/B VPWR VGND sg13cmos5l_nand2b_1
XFILLER_66_176 VPWR VGND sg13cmos5l_fill_2
XFILLER_55_839 VPWR VGND sg13cmos5l_decap_8
X_08561_ _08561_/Y _08561_/A _08563_/B VPWR VGND sg13cmos5l_nor2_1
X_11358__1543 _11358_/RESET_B VPWR VGND sg13cmos5l_tiehi
X_08492_ _08492_/Y _08492_/A _08504_/B VPWR VGND sg13cmos5l_nand2_1
X_07512_ _10900_/D _07526_/B _08071_/A1 _07511_/Y VPWR VGND sg13cmos5l_a21oi_1
X_07443_ _07443_/Y _11558_/Q _11556_/Q VPWR VGND sg13cmos5l_nand2b_1
XFILLER_62_393 VPWR VGND sg13cmos5l_fill_1
XFILLER_22_202 VPWR VGND sg13cmos5l_decap_8
XFILLER_50_577 VPWR VGND sg13cmos5l_decap_8
XFILLER_22_268 VPWR VGND sg13cmos5l_fill_1
X_09113_ _09113_/Y _09104_/A _09112_/Y _05939_/A VPWR VGND sg13cmos5l_o21ai_1
X_07374_ _07374_/Y _11445_/Q _07380_/B VPWR VGND sg13cmos5l_nand2_1
X_11540__1493 _11540_/RESET_B VPWR VGND sg13cmos5l_tiehi
XFILLER_10_419 VPWR VGND sg13cmos5l_fill_1
XFILLER_13_16 VPWR VGND sg13cmos5l_decap_8
X_06325_ _06325_/Y _11513_/Q _09830_/A VPWR VGND sg13cmos5l_nor2_1
X_06256_ _10620_/A _11514_/Q _09246_/A VPWR VGND sg13cmos5l_xor2_1
X_09044_ _09069_/C _09056_/A _09068_/A VPWR VGND sg13cmos5l_xnor2_1
XFILLER_104_513 VPWR VGND sg13cmos5l_decap_4
X_06187_ _06187_/Y _07008_/A _09317_/A VPWR VGND sg13cmos5l_nor2_1
XFILLER_77_419 VPWR VGND sg13cmos5l_fill_2
X_09946_ _09946_/Y _09830_/A _10055_/A _09920_/Y _09945_/Y VPWR VGND sg13cmos5l_a22oi_1
X_09877_ _09877_/Y _11362_/Q _09984_/B VPWR VGND sg13cmos5l_nand2_1
XFILLER_86_964 VPWR VGND sg13cmos5l_decap_4
XFILLER_86_953 VPWR VGND sg13cmos5l_fill_2
XFILLER_57_121 VPWR VGND sg13cmos5l_decap_8
XFILLER_57_154 VPWR VGND sg13cmos5l_fill_2
X_08828_ _08828_/Y _08825_/Y _08827_/X _10719_/B VPWR VGND sg13cmos5l_a21oi_1
X_08759_ _09118_/A _08759_/A _08759_/B VPWR VGND sg13cmos5l_nand2_1
XFILLER_73_658 VPWR VGND sg13cmos5l_fill_2
XFILLER_72_146 VPWR VGND sg13cmos5l_fill_1
XFILLER_41_500 VPWR VGND sg13cmos5l_fill_2
XFILLER_26_552 VPWR VGND sg13cmos5l_decap_8
XFILLER_26_563 VPWR VGND sg13cmos5l_decap_4
X_10721_ _10721_/Y hold2727/X _10730_/B _10783_/B VPWR VGND sg13cmos5l_o21ai_1
XFILLER_54_894 VPWR VGND sg13cmos5l_fill_2
XFILLER_53_393 VPWR VGND sg13cmos5l_decap_4
XFILLER_41_555 VPWR VGND sg13cmos5l_fill_1
XFILLER_9_206 VPWR VGND sg13cmos5l_fill_1
X_10652_ _10652_/X _10652_/A _10653_/C VPWR VGND sg13cmos5l_and2_1
XFILLER_103_1003 VPWR VGND sg13cmos5l_decap_8
X_10583_ _10584_/C _10583_/A _10583_/B _10583_/C VPWR VGND sg13cmos5l_nand3_1
XFILLER_70_88 VPWR VGND sg13cmos5l_decap_4
XFILLER_5_412 VPWR VGND sg13cmos5l_decap_8
XFILLER_10_997 VPWR VGND sg13cmos5l_decap_8
XFILLER_5_434 VPWR VGND sg13cmos5l_decap_4
X_11204_ _11204_/Q _11339_/CLK _11204_/D _11204_/RESET_B VPWR VGND sg13cmos5l_dfrbpq_1
X_11135_ _11135_/Q clkload58/A _11135_/D _11135_/RESET_B VPWR VGND sg13cmos5l_dfrbpq_1
XFILLER_95_238 VPWR VGND sg13cmos5l_fill_1
XFILLER_95_227 VPWR VGND sg13cmos5l_decap_8
XFILLER_77_920 VPWR VGND sg13cmos5l_decap_8
XFILLER_1_684 VPWR VGND sg13cmos5l_decap_4
X_11066_ _11066_/Q clkload41/A _11066_/D _11066_/RESET_B VPWR VGND sg13cmos5l_dfrbpq_1
XFILLER_95_63 VPWR VGND sg13cmos5l_decap_4
X_10017_ _10024_/B _10017_/A _10017_/B _10017_/C VPWR VGND sg13cmos5l_nor3_1
XFILLER_76_430 VPWR VGND sg13cmos5l_fill_1
XFILLER_48_143 VPWR VGND sg13cmos5l_fill_1
XFILLER_23_1026 VPWR VGND sg13cmos5l_fill_2
XFILLER_92_934 VPWR VGND sg13cmos5l_decap_4
XFILLER_76_463 VPWR VGND sg13cmos5l_fill_2
XFILLER_64_625 VPWR VGND sg13cmos5l_fill_1
XFILLER_63_102 VPWR VGND sg13cmos5l_fill_2
XFILLER_91_455 VPWR VGND sg13cmos5l_fill_1
XFILLER_91_422 VPWR VGND sg13cmos5l_decap_4
XFILLER_64_669 VPWR VGND sg13cmos5l_decap_8
XFILLER_48_198 VPWR VGND sg13cmos5l_decap_8
XFILLER_36_338 VPWR VGND sg13cmos5l_fill_2
XFILLER_92_989 VPWR VGND sg13cmos5l_decap_8
X_10919_ _10919_/Q _11364_/CLK _10919_/D _10919_/RESET_B VPWR VGND sg13cmos5l_dfrbpq_1
XFILLER_60_853 VPWR VGND sg13cmos5l_fill_2
XFILLER_32_555 VPWR VGND sg13cmos5l_decap_4
XFILLER_60_886 VPWR VGND sg13cmos5l_fill_2
XFILLER_9_762 VPWR VGND sg13cmos5l_decap_8
X_07090_ _07090_/X _11735_/Q hold2703/X _07098_/B VPWR VGND sg13cmos5l_mux2_1
X_06110_ _06110_/Y _06114_/A _06576_/B _06109_/Y VPWR VGND sg13cmos5l_o21ai_1
XFILLER_8_250 VPWR VGND sg13cmos5l_fill_1
X_06041_ _06045_/C _06041_/A _06041_/B _06041_/C _06041_/D VPWR VGND sg13cmos5l_nand4_1
XFILLER_101_505 VPWR VGND sg13cmos5l_fill_1
Xfanout207 _08169_/B _08116_/Y VPWR VGND sg13cmos5l_buf_1
X_09800_ _09800_/Y _09797_/Y _09799_/Y _10049_/A1 VPWR VGND sg13cmos5l_o21ai_1
X_07992_ _11085_/D _08384_/A1 _08005_/B _07991_/Y VPWR VGND sg13cmos5l_a21oi_1
Xfanout229 _07893_/B _07877_/B VPWR VGND sg13cmos5l_buf_1
Xfanout218 _08031_/B _08007_/B VPWR VGND sg13cmos5l_buf_1
X_06943_ _06943_/Y _08621_/B _06943_/B _06943_/C _06943_/D VPWR VGND sg13cmos5l_nand4_1
X_09731_ _09731_/Y _09731_/A _09731_/B _09731_/C VPWR VGND sg13cmos5l_nand3_1
XFILLER_95_750 VPWR VGND sg13cmos5l_fill_2
X_11576__1387 _11576_/RESET_B VPWR VGND sg13cmos5l_tiehi
XFILLER_68_975 VPWR VGND sg13cmos5l_fill_1
X_06874_ _06875_/D _06874_/A _06874_/B _06874_/C _06874_/D VPWR VGND sg13cmos5l_nand4_1
X_09662_ _09662_/Y _11290_/Q _09850_/A2 _09661_/Y VPWR VGND sg13cmos5l_o21ai_1
XFILLER_28_839 VPWR VGND sg13cmos5l_fill_2
XFILLER_82_422 VPWR VGND sg13cmos5l_fill_1
XFILLER_55_647 VPWR VGND sg13cmos5l_decap_8
XFILLER_55_636 VPWR VGND sg13cmos5l_fill_2
X_08613_ _08628_/A _08614_/A _08616_/A VPWR VGND sg13cmos5l_nand2_1
X_09593_ _09593_/Y _11096_/Q _09593_/B VPWR VGND sg13cmos5l_nand2_1
XFILLER_82_455 VPWR VGND sg13cmos5l_fill_1
XFILLER_70_617 VPWR VGND sg13cmos5l_decap_8
XFILLER_39_1000 VPWR VGND sg13cmos5l_decap_8
XFILLER_36_861 VPWR VGND sg13cmos5l_fill_1
XFILLER_36_850 VPWR VGND sg13cmos5l_fill_1
X_08544_ _11356_/D fanout81/X _08543_/B _08543_/Y VPWR VGND sg13cmos5l_a21oi_1
XFILLER_35_371 VPWR VGND sg13cmos5l_fill_2
X_08475_ _11322_/D fanout96/X _08488_/B _08474_/Y VPWR VGND sg13cmos5l_o21ai_1
XFILLER_24_48 VPWR VGND sg13cmos5l_fill_1
XFILLER_11_728 VPWR VGND sg13cmos5l_decap_8
X_07426_ _10888_/D _07425_/B _07424_/Y _07425_/Y VPWR VGND sg13cmos5l_a21oi_1
X_07357_ _07357_/Y _07355_/Y _08722_/A _07376_/A2 VPWR VGND sg13cmos5l_a21oi_1
X_06308_ _06308_/Y _10268_/A _10433_/A VPWR VGND sg13cmos5l_nand2b_1
X_09027_ _09027_/Y _09028_/B _09036_/B VPWR VGND sg13cmos5l_nor2b_1
X_07288_ _07288_/Y _07383_/B _07286_/Y _07287_/Y VPWR VGND sg13cmos5l_a21oi_1
XFILLER_3_938 VPWR VGND sg13cmos5l_decap_8
X_06239_ _06240_/A _06224_/Y _06239_/B VPWR VGND sg13cmos5l_nand2b_1
XFILLER_105_855 VPWR VGND sg13cmos5l_decap_8
XFILLER_104_332 VPWR VGND sg13cmos5l_decap_8
XFILLER_2_426 VPWR VGND sg13cmos5l_fill_1
XFILLER_49_23 VPWR VGND sg13cmos5l_decap_8
Xfanout730 _10250_/B _11508_/Q VPWR VGND sg13cmos5l_buf_1
Xfanout741 _10426_/B1 hold2917/X VPWR VGND sg13cmos5l_buf_1
X_09929_ _09929_/Y _11044_/Q _09934_/B _10015_/B1 VPWR VGND sg13cmos5l_a21oi_1
XFILLER_58_430 VPWR VGND sg13cmos5l_fill_1
Xfanout763 _06310_/B _11475_/Q VPWR VGND sg13cmos5l_buf_1
Xfanout752 _10433_/A _10479_/A VPWR VGND sg13cmos5l_buf_1
X_11084__1817 _11084_/RESET_B VPWR VGND sg13cmos5l_tiehi
Xfanout774 _09214_/A _11468_/Q VPWR VGND sg13cmos5l_buf_1
Xfanout785 _09376_/A hold2929/X VPWR VGND sg13cmos5l_buf_1
XFILLER_105_84 VPWR VGND sg13cmos5l_decap_8
XFILLER_74_934 VPWR VGND sg13cmos5l_decap_4
XFILLER_73_400 VPWR VGND sg13cmos5l_fill_1
Xfanout796 _10591_/A _11417_/Q VPWR VGND sg13cmos5l_buf_1
X_11120__1781 _11120_/RESET_B VPWR VGND sg13cmos5l_tiehi
X_11755__916 _11755_/RESET_B VPWR VGND sg13cmos5l_tiehi
XFILLER_61_617 VPWR VGND sg13cmos5l_fill_2
XFILLER_46_669 VPWR VGND sg13cmos5l_fill_2
XFILLER_33_308 VPWR VGND sg13cmos5l_fill_2
XFILLER_60_127 VPWR VGND sg13cmos5l_fill_2
XFILLER_60_116 VPWR VGND sg13cmos5l_fill_2
XFILLER_54_691 VPWR VGND sg13cmos5l_fill_2
XFILLER_42_820 VPWR VGND sg13cmos5l_fill_1
XFILLER_81_32 VPWR VGND sg13cmos5l_fill_1
XFILLER_81_21 VPWR VGND sg13cmos5l_decap_8
X_11753_ _11753_/Q clkload21/A _11753_/D _11753_/RESET_B VPWR VGND sg13cmos5l_dfrbpq_1
X_11684_ _11684_/Q clkload23/A _11684_/D _11684_/RESET_B VPWR VGND sg13cmos5l_dfrbpq_1
X_10704_ _10704_/Y _10704_/A _10704_/B _10704_/C _10704_/D VPWR VGND sg13cmos5l_nand4_1
X_10635_ _10635_/Y _11419_/Q _10856_/Q _10606_/Y _10633_/C _10634_/Y VPWR VGND sg13cmos5l_a221oi_1
X_10820__957 _10820_/RESET_B VPWR VGND sg13cmos5l_tiehi
X_10566_ _10567_/B _10566_/A _10566_/B VPWR VGND sg13cmos5l_and2_1
XFILLER_10_794 VPWR VGND sg13cmos5l_fill_2
XFILLER_53_8 VPWR VGND sg13cmos5l_fill_1
X_10497_ _10497_/Y _05867_/Y _05974_/Y _10478_/D VPWR VGND sg13cmos5l_o21ai_1
XFILLER_5_286 VPWR VGND sg13cmos5l_decap_8
XFILLER_69_728 VPWR VGND sg13cmos5l_decap_4
X_11118_ _11118_/Q clkload16/A _11118_/D _11118_/RESET_B VPWR VGND sg13cmos5l_dfrbpq_1
XFILLER_96_569 VPWR VGND sg13cmos5l_fill_1
XFILLER_77_750 VPWR VGND sg13cmos5l_decap_4
XFILLER_65_901 VPWR VGND sg13cmos5l_fill_1
X_11049_ _11049_/Q clkload50/A _11049_/D _11049_/RESET_B VPWR VGND sg13cmos5l_dfrbpq_1
XFILLER_77_783 VPWR VGND sg13cmos5l_fill_1
Xinput7 input7/X ui_in[14] VPWR VGND sg13cmos5l_buf_1
XFILLER_37_614 VPWR VGND sg13cmos5l_decap_8
XFILLER_65_956 VPWR VGND sg13cmos5l_fill_1
XFILLER_64_477 VPWR VGND sg13cmos5l_fill_1
X_06590_ _06590_/Y _06590_/A _06590_/B VPWR VGND sg13cmos5l_xnor2_1
XFILLER_18_894 VPWR VGND sg13cmos5l_fill_2
X_10873__1109 _10873_/RESET_B VPWR VGND sg13cmos5l_tiehi
XFILLER_51_149 VPWR VGND sg13cmos5l_decap_4
XFILLER_32_341 VPWR VGND sg13cmos5l_fill_1
XFILLER_60_661 VPWR VGND sg13cmos5l_decap_8
X_08260_ _11216_/D _08520_/A1 _08263_/B _08259_/Y VPWR VGND sg13cmos5l_a21oi_1
XFILLER_32_363 VPWR VGND sg13cmos5l_fill_1
X_07211_ _07211_/Y _10691_/B _05944_/A hold2830/X _08916_/B1 _07210_/X VPWR VGND sg13cmos5l_a221oi_1
X_08191_ _11182_/D _08321_/A1 _08198_/B _08190_/Y VPWR VGND sg13cmos5l_o21ai_1
XFILLER_20_558 VPWR VGND sg13cmos5l_decap_4
XFILLER_32_385 VPWR VGND sg13cmos5l_decap_8
X_07142_ _11736_/D _05886_/Y _07142_/A2 _07141_/Y VPWR VGND sg13cmos5l_a21oi_1
X_11162__1739 _11162_/RESET_B VPWR VGND sg13cmos5l_tiehi
X_07073_ _07073_/Y _07077_/A _07081_/B VPWR VGND sg13cmos5l_nor2_1
X_06024_ _07786_/A _10707_/A _10783_/B VPWR VGND sg13cmos5l_nand2_1
XFILLER_0_908 VPWR VGND sg13cmos5l_decap_8
X_07975_ _11077_/D fanout57/X _07974_/B _07974_/Y VPWR VGND sg13cmos5l_o21ai_1
XFILLER_19_26 VPWR VGND sg13cmos5l_fill_2
XFILLER_101_379 VPWR VGND sg13cmos5l_decap_4
X_06926_ _06926_/Y _06835_/B _06925_/Y _06924_/Y VPWR VGND sg13cmos5l_o21ai_1
X_09714_ _09714_/X _11260_/Q _11228_/Q _11196_/Q _11164_/Q _09708_/S _09715_/B1 VPWR
+ VGND sg13cmos5l_mux4_1
X_06857_ _06857_/Y _06857_/A _06861_/B VPWR VGND sg13cmos5l_nand2_1
XFILLER_56_956 VPWR VGND sg13cmos5l_fill_1
XFILLER_55_444 VPWR VGND sg13cmos5l_fill_2
X_09645_ _09645_/Y _09645_/A _09725_/B VPWR VGND sg13cmos5l_nand2_1
XFILLER_76_1019 VPWR VGND sg13cmos5l_fill_1
XFILLER_56_989 VPWR VGND sg13cmos5l_fill_2
XFILLER_16_809 VPWR VGND sg13cmos5l_fill_2
X_06788_ _06879_/C _06820_/C _06820_/B _06825_/A VPWR VGND sg13cmos5l_nor3_1
XFILLER_70_414 VPWR VGND sg13cmos5l_decap_4
XFILLER_55_488 VPWR VGND sg13cmos5l_decap_4
XFILLER_36_691 VPWR VGND sg13cmos5l_decap_4
X_09576_ _09576_/Y _11351_/Q _09576_/B VPWR VGND sg13cmos5l_nand2_1
X_10849__1144 _10849_/RESET_B VPWR VGND sg13cmos5l_tiehi
X_11435__1420 _11435_/RESET_B VPWR VGND sg13cmos5l_tiehi
X_08527_ _08527_/Y _08527_/A _08527_/B VPWR VGND sg13cmos5l_nor2_1
XFILLER_24_864 VPWR VGND sg13cmos5l_fill_2
X_08458_ _08458_/Y _08458_/A _08468_/B VPWR VGND sg13cmos5l_nand2_1
XFILLER_24_875 VPWR VGND sg13cmos5l_decap_4
X_11486__1211 _11486_/RESET_B VPWR VGND sg13cmos5l_tiehi
X_07409_ _07409_/Y _11547_/Q _08762_/A VPWR VGND sg13cmos5l_nand2_1
XFILLER_51_13 VPWR VGND sg13cmos5l_decap_4
XFILLER_50_182 VPWR VGND sg13cmos5l_fill_2
XFILLER_50_171 VPWR VGND sg13cmos5l_fill_2
X_10420_ _10420_/Y _10537_/A _10420_/B VPWR VGND sg13cmos5l_nand2_1
XFILLER_11_569 VPWR VGND sg13cmos5l_fill_1
X_08389_ _08389_/Y _08389_/A _08403_/B VPWR VGND sg13cmos5l_nor2_1
XFILLER_100_1006 VPWR VGND sg13cmos5l_decap_8
X_11138__1763 _11138_/RESET_B VPWR VGND sg13cmos5l_tiehi
X_10351_ _10365_/B _10365_/A _10351_/B _10351_/C VPWR VGND sg13cmos5l_nor3_1
XFILLER_3_713 VPWR VGND sg13cmos5l_decap_8
X_10282_ _10288_/B _10282_/A _10282_/B VPWR VGND sg13cmos5l_xor2_1
XFILLER_2_223 VPWR VGND sg13cmos5l_decap_4
XFILLER_105_663 VPWR VGND sg13cmos5l_decap_8
XFILLER_104_140 VPWR VGND sg13cmos5l_decap_8
XFILLER_78_503 VPWR VGND sg13cmos5l_decap_4
XFILLER_3_779 VPWR VGND sg13cmos5l_fill_1
XFILLER_3_757 VPWR VGND sg13cmos5l_fill_2
XFILLER_2_245 VPWR VGND sg13cmos5l_decap_8
XFILLER_105_696 VPWR VGND sg13cmos5l_decap_8
XFILLER_78_525 VPWR VGND sg13cmos5l_decap_4
Xfanout560 _07430_/A2 _06948_/Y VPWR VGND sg13cmos5l_buf_1
Xfanout582 _06425_/B _06396_/Y VPWR VGND sg13cmos5l_buf_1
Xfanout571 _06927_/B _07191_/A2 VPWR VGND sg13cmos5l_buf_1
Xfanout593 _07150_/A2 _06127_/X VPWR VGND sg13cmos5l_buf_1
XFILLER_59_783 VPWR VGND sg13cmos5l_decap_4
XFILLER_76_87 VPWR VGND sg13cmos5l_fill_2
XFILLER_19_658 VPWR VGND sg13cmos5l_decap_8
XFILLER_62_926 VPWR VGND sg13cmos5l_decap_8
XFILLER_62_904 VPWR VGND sg13cmos5l_decap_8
XFILLER_34_606 VPWR VGND sg13cmos5l_fill_1
XFILLER_92_42 VPWR VGND sg13cmos5l_decap_8
XFILLER_46_488 VPWR VGND sg13cmos5l_decap_8
XFILLER_61_469 VPWR VGND sg13cmos5l_fill_1
XFILLER_14_330 VPWR VGND sg13cmos5l_fill_2
XFILLER_26_190 VPWR VGND sg13cmos5l_fill_2
X_11736_ _11736_/Q clkload22/A _11736_/D _11736_/RESET_B VPWR VGND sg13cmos5l_dfrbpq_1
XFILLER_30_834 VPWR VGND sg13cmos5l_fill_2
X_11667_ _11667_/Q _11668_/CLK _11667_/D _11667_/RESET_B VPWR VGND sg13cmos5l_dfrbpq_1
XFILLER_30_878 VPWR VGND sg13cmos5l_fill_1
X_11598_ _11598_/Q clkload27/A _11598_/D _11598_/RESET_B VPWR VGND sg13cmos5l_dfrbpq_1
X_10618_ _10620_/B _10611_/A _10611_/B _06257_/Y VPWR VGND sg13cmos5l_o21ai_1
X_10549_ _10549_/Y fanout84/X _10548_/X _10488_/A VPWR VGND sg13cmos5l_o21ai_1
XFILLER_6_573 VPWR VGND sg13cmos5l_fill_1
XFILLER_44_4 VPWR VGND sg13cmos5l_decap_4
Xhold2409 _08555_/A _11362_/Q VPWR VGND sg13cmos5l_dlygate4sd3_1
X_10927__1055 _10927_/RESET_B VPWR VGND sg13cmos5l_tiehi
XFILLER_97_867 VPWR VGND sg13cmos5l_fill_1
XFILLER_57_709 VPWR VGND sg13cmos5l_fill_2
XFILLER_99_1019 VPWR VGND sg13cmos5l_decap_8
XFILLER_97_889 VPWR VGND sg13cmos5l_decap_8
XFILLER_84_517 VPWR VGND sg13cmos5l_decap_4
XFILLER_84_506 VPWR VGND sg13cmos5l_fill_2
X_07760_ _07760_/Y _07760_/A _07760_/B VPWR VGND sg13cmos5l_nor2_1
X_06711_ _06718_/B _06368_/Y _06373_/C _06376_/Y VPWR VGND sg13cmos5l_a21o_1
X_07691_ _10939_/D fanout82/X _07712_/B _07690_/Y VPWR VGND sg13cmos5l_a21oi_1
X_09430_ _09430_/Y _09537_/A _09430_/B VPWR VGND sg13cmos5l_nor2_1
XFILLER_80_723 VPWR VGND sg13cmos5l_decap_4
XFILLER_65_797 VPWR VGND sg13cmos5l_decap_8
XFILLER_37_477 VPWR VGND sg13cmos5l_decap_8
X_06642_ _06642_/X _06642_/A _06642_/B VPWR VGND sg13cmos5l_xor2_1
XFILLER_25_628 VPWR VGND sg13cmos5l_decap_8
XFILLER_52_458 VPWR VGND sg13cmos5l_decap_8
X_09361_ _09361_/Y _10895_/Q _09363_/B _09601_/B1 VPWR VGND sg13cmos5l_a21oi_1
X_11216__1685 _11216_/RESET_B VPWR VGND sg13cmos5l_tiehi
X_06573_ _06575_/A _06573_/A1 _11679_/Q _11663_/Q _06133_/B VPWR VGND sg13cmos5l_a22oi_1
XFILLER_24_127 VPWR VGND sg13cmos5l_fill_1
X_08312_ _08312_/Y _08312_/A _08364_/B VPWR VGND sg13cmos5l_nand2_1
X_09292_ _09292_/X _11273_/Q _11241_/Q _11209_/Q _11177_/Q _10007_/B _10046_/B1 VPWR
+ VGND sg13cmos5l_mux4_1
XFILLER_33_683 VPWR VGND sg13cmos5l_decap_4
X_08243_ _11208_/D fanout52/X _08242_/B _08242_/Y VPWR VGND sg13cmos5l_o21ai_1
XANTENNA_12 fanout246/X VPWR VGND sg13cmos5l_antennanp
XFILLER_20_333 VPWR VGND sg13cmos5l_decap_4
XFILLER_32_193 VPWR VGND sg13cmos5l_decap_8
X_08174_ _11174_/D fanout55/X _08173_/B _08173_/Y VPWR VGND sg13cmos5l_a21oi_1
X_11717__1246 _11717_/RESET_B VPWR VGND sg13cmos5l_tiehi
X_07125_ _07125_/Y hold2823/X _07126_/A2 _07163_/B1 VPWR VGND sg13cmos5l_o21ai_1
XFILLER_106_427 VPWR VGND sg13cmos5l_decap_8
X_07056_ _07056_/Y _06994_/Y _07055_/Y _07062_/S VPWR VGND sg13cmos5l_a21oi_1
X_06007_ _06044_/A _11600_/Q _11599_/Q _11597_/Q _06007_/D VPWR VGND sg13cmos5l_nor4_1
XFILLER_0_716 VPWR VGND sg13cmos5l_decap_4
X_10992__990 _10992_/RESET_B VPWR VGND sg13cmos5l_tiehi
Xhold2910 _11515_/D _10148_/X VPWR VGND sg13cmos5l_dlygate4sd3_1
Xhold2932 _06267_/A _11511_/Q VPWR VGND sg13cmos5l_dlygate4sd3_1
Xhold2921 hold2921/X _11394_/Q VPWR VGND sg13cmos5l_dlygate4sd3_1
XFILLER_101_154 VPWR VGND sg13cmos5l_decap_8
XFILLER_87_355 VPWR VGND sg13cmos5l_decap_4
Xhold2943 hold2943/X _10550_/X VPWR VGND sg13cmos5l_dlygate4sd3_1
Xhold2954 _09326_/A _11462_/Q VPWR VGND sg13cmos5l_dlygate4sd3_1
X_11627__1339 _11627_/RESET_B VPWR VGND sg13cmos5l_tiehi
XFILLER_68_580 VPWR VGND sg13cmos5l_fill_1
X_07958_ _07958_/Y _07958_/A _07958_/B VPWR VGND sg13cmos5l_nand2_1
XFILLER_29_945 VPWR VGND sg13cmos5l_fill_2
XFILLER_29_956 VPWR VGND sg13cmos5l_decap_8
X_06909_ _06913_/A _06868_/A _06917_/B _06908_/Y VPWR VGND sg13cmos5l_a21oi_1
X_07889_ _07889_/Y _07889_/A _07909_/B VPWR VGND sg13cmos5l_nor2_1
XFILLER_55_241 VPWR VGND sg13cmos5l_fill_2
XFILLER_55_230 VPWR VGND sg13cmos5l_decap_8
XFILLER_46_57 VPWR VGND sg13cmos5l_fill_1
XFILLER_44_915 VPWR VGND sg13cmos5l_fill_2
XFILLER_83_572 VPWR VGND sg13cmos5l_decap_8
XFILLER_56_797 VPWR VGND sg13cmos5l_decap_4
XFILLER_43_425 VPWR VGND sg13cmos5l_fill_1
XFILLER_43_414 VPWR VGND sg13cmos5l_decap_8
X_09628_ _09628_/Y _11097_/Q _09652_/S VPWR VGND sg13cmos5l_nand2_1
XFILLER_28_488 VPWR VGND sg13cmos5l_decap_8
XFILLER_102_63 VPWR VGND sg13cmos5l_decap_8
X_09559_ _09642_/B _09559_/A _09721_/B VPWR VGND sg13cmos5l_nor2_1
XFILLER_71_789 VPWR VGND sg13cmos5l_decap_4
XFILLER_11_300 VPWR VGND sg13cmos5l_decap_4
XFILLER_23_171 VPWR VGND sg13cmos5l_decap_8
X_11521_ _11521_/Q clkload14/A _11521_/D _11521_/RESET_B VPWR VGND sg13cmos5l_dfrbpq_1
X_11452_ _11452_/Q clkload53/A _11452_/D _11452_/RESET_B VPWR VGND sg13cmos5l_dfrbpq_1
X_11383_ _11383_/Q _11713_/CLK _11383_/D _11383_/RESET_B VPWR VGND sg13cmos5l_dfrbpq_1
X_10403_ _10408_/B _10422_/A _10403_/B _10403_/C _10403_/D VPWR VGND sg13cmos5l_nand4_1
X_10334_ _10334_/Y _10334_/A _10334_/B VPWR VGND sg13cmos5l_nand2_1
XFILLER_3_543 VPWR VGND sg13cmos5l_decap_8
XFILLER_2_0 VPWR VGND sg13cmos5l_decap_8
XFILLER_106_994 VPWR VGND sg13cmos5l_decap_8
XFILLER_87_42 VPWR VGND sg13cmos5l_decap_4
X_10265_ _10273_/A _10265_/A _10265_/B _10265_/C VPWR VGND sg13cmos5l_or3_1
XFILLER_87_86 VPWR VGND sg13cmos5l_fill_1
X_10196_ _10196_/Y hold2613/X _10172_/Y _10173_/Y hold2680/X _10226_/C1 VPWR VGND
+ sg13cmos5l_a221oi_1
XFILLER_66_528 VPWR VGND sg13cmos5l_fill_1
Xfanout390 _09989_/A _10017_/A VPWR VGND sg13cmos5l_buf_1
XFILLER_94_859 VPWR VGND sg13cmos5l_fill_2
XFILLER_94_848 VPWR VGND sg13cmos5l_decap_4
XFILLER_93_325 VPWR VGND sg13cmos5l_fill_1
XFILLER_19_400 VPWR VGND sg13cmos5l_fill_1
XFILLER_47_764 VPWR VGND sg13cmos5l_fill_2
XFILLER_19_444 VPWR VGND sg13cmos5l_decap_8
XFILLER_19_499 VPWR VGND sg13cmos5l_fill_1
XFILLER_62_745 VPWR VGND sg13cmos5l_fill_1
XFILLER_46_296 VPWR VGND sg13cmos5l_decap_8
XFILLER_34_436 VPWR VGND sg13cmos5l_fill_1
XFILLER_62_789 VPWR VGND sg13cmos5l_decap_8
XFILLER_61_277 VPWR VGND sg13cmos5l_decap_4
X_12768_ _12768_/X _12768_/A VPWR VGND sg13cmos5l_buf_1
X_10826__963 _10826_/RESET_B VPWR VGND sg13cmos5l_tiehi
X_11719_ _11719_/Q _11766_/CLK _11719_/D _11719_/RESET_B VPWR VGND sg13cmos5l_dfrbpq_1
XFILLER_30_664 VPWR VGND sg13cmos5l_fill_1
Xinput10 input10/X ui_in[2] VPWR VGND sg13cmos5l_buf_1
X_10833__1176 _10833_/RESET_B VPWR VGND sg13cmos5l_tiehi
X_08930_ _08954_/C _08930_/A _08930_/B _08930_/C _08930_/D VPWR VGND sg13cmos5l_or4_1
X_11470__1243 _11470_/RESET_B VPWR VGND sg13cmos5l_tiehi
Xhold2217 _07895_/A _11038_/Q VPWR VGND sg13cmos5l_dlygate4sd3_1
X_08861_ _08862_/B _08861_/A _08861_/B _08861_/C _08861_/D VPWR VGND sg13cmos5l_nor4_1
Xhold2206 _08145_/A _11160_/Q VPWR VGND sg13cmos5l_dlygate4sd3_1
Xhold2228 _07867_/A _11024_/Q VPWR VGND sg13cmos5l_dlygate4sd3_1
Xhold2239 _08405_/A _11288_/Q VPWR VGND sg13cmos5l_dlygate4sd3_1
X_07812_ _07812_/Y _07812_/A _07814_/B VPWR VGND sg13cmos5l_nand2_1
XFILLER_85_848 VPWR VGND sg13cmos5l_decap_4
X_08792_ _08793_/B _11636_/Q _08817_/B VPWR VGND sg13cmos5l_or2_1
XFILLER_38_764 VPWR VGND sg13cmos5l_fill_2
XFILLER_37_230 VPWR VGND sg13cmos5l_fill_1
X_07743_ _10964_/D _08071_/A1 _07746_/B _07742_/Y VPWR VGND sg13cmos5l_a21oi_1
XFILLER_93_870 VPWR VGND sg13cmos5l_decap_8
X_07674_ _07674_/Y _07674_/A _07676_/B VPWR VGND sg13cmos5l_nor2_1
XFILLER_26_926 VPWR VGND sg13cmos5l_fill_2
XFILLER_26_937 VPWR VGND sg13cmos5l_fill_1
XFILLER_92_391 VPWR VGND sg13cmos5l_fill_1
X_11623__1345 _11623_/RESET_B VPWR VGND sg13cmos5l_tiehi
XFILLER_53_745 VPWR VGND sg13cmos5l_decap_8
X_09413_ _09413_/Y _10961_/Q _09708_/S _09707_/S1 VPWR VGND sg13cmos5l_a21oi_1
X_06625_ _06625_/Y _06639_/A _06625_/B _06625_/C VPWR VGND sg13cmos5l_nand3_1
XFILLER_53_778 VPWR VGND sg13cmos5l_fill_1
XFILLER_41_929 VPWR VGND sg13cmos5l_fill_1
XFILLER_80_597 VPWR VGND sg13cmos5l_fill_1
X_06556_ _06557_/B _06133_/A _11673_/Q _10867_/Q _06134_/A VPWR VGND sg13cmos5l_a22oi_1
X_09344_ _09345_/B _09344_/A _09344_/B VPWR VGND sg13cmos5l_nor2_1
X_09275_ _09275_/Y _11621_/Q _11613_/Q VPWR VGND sg13cmos5l_nor2_1
X_06487_ _10693_/C _10713_/A _09303_/A VPWR VGND sg13cmos5l_or2_1
XFILLER_21_664 VPWR VGND sg13cmos5l_fill_1
X_08226_ _08226_/Y _08226_/A _08236_/B VPWR VGND sg13cmos5l_nand2_1
X_08157_ _08157_/Y _08157_/A _08171_/B VPWR VGND sg13cmos5l_nor2_1
XFILLER_106_224 VPWR VGND sg13cmos5l_decap_8
X_07108_ _11719_/D _05887_/Y _07108_/A2 _07107_/Y VPWR VGND sg13cmos5l_a21oi_1
X_08088_ _08088_/Y _08088_/A _08088_/B VPWR VGND sg13cmos5l_nand2_1
X_07039_ _07039_/Y _07038_/B _07037_/Y _07038_/Y VPWR VGND sg13cmos5l_o21ai_1
X_10050_ _10051_/B _09933_/A _10045_/X _10049_/Y VPWR VGND sg13cmos5l_o21ai_1
XFILLER_103_975 VPWR VGND sg13cmos5l_decap_8
XFILLER_75_303 VPWR VGND sg13cmos5l_decap_8
Xhold2740 _06490_/B _06489_/Y VPWR VGND sg13cmos5l_dlygate4sd3_1
Xhold2762 hold2762/X _11419_/Q VPWR VGND sg13cmos5l_dlygate4sd3_1
Xhold2751 _11710_/D _07094_/Y VPWR VGND sg13cmos5l_dlygate4sd3_1
Xhold2773 _10842_/D _07216_/Y VPWR VGND sg13cmos5l_dlygate4sd3_1
Xhold2795 hold2795/X _11716_/Q VPWR VGND sg13cmos5l_dlygate4sd3_1
Xhold2784 _06174_/A _11495_/Q VPWR VGND sg13cmos5l_dlygate4sd3_1
X_10952_ _10952_/Q clkload56/A _10952_/D _10952_/RESET_B VPWR VGND sg13cmos5l_dfrbpq_1
XFILLER_44_701 VPWR VGND sg13cmos5l_fill_2
XFILLER_29_797 VPWR VGND sg13cmos5l_decap_4
X_10883_ _10883_/Q clkload13/A _10883_/D _10883_/RESET_B VPWR VGND sg13cmos5l_dfrbpq_1
XFILLER_44_789 VPWR VGND sg13cmos5l_decap_8
XFILLER_31_417 VPWR VGND sg13cmos5l_decap_4
XFILLER_106_1001 VPWR VGND sg13cmos5l_decap_8
XFILLER_40_973 VPWR VGND sg13cmos5l_fill_2
X_11504_ _11504_/Q clkload38/A _11504_/D _11504_/RESET_B VPWR VGND sg13cmos5l_dfrbpq_1
XFILLER_8_679 VPWR VGND sg13cmos5l_decap_8
X_11435_ _11435_/Q _11535_/CLK _11435_/D _11435_/RESET_B VPWR VGND sg13cmos5l_dfrbpq_1
X_11366_ _11366_/Q clkload53/A _11366_/D _11366_/RESET_B VPWR VGND sg13cmos5l_dfrbpq_1
XFILLER_98_63 VPWR VGND sg13cmos5l_decap_8
X_10317_ _10318_/B _10317_/A _10317_/B _10317_/C VPWR VGND sg13cmos5l_nand3_1
X_11297_ _11297_/Q _11361_/CLK _11297_/D _11297_/RESET_B VPWR VGND sg13cmos5l_dfrbpq_1
XFILLER_106_791 VPWR VGND sg13cmos5l_decap_8
X_10248_ _10248_/X _10282_/A _10282_/B VPWR VGND sg13cmos5l_or2_1
XFILLER_26_1002 VPWR VGND sg13cmos5l_decap_4
XFILLER_66_314 VPWR VGND sg13cmos5l_fill_1
X_10179_ _10179_/Y _10174_/Y _10175_/Y _10178_/Y _09309_/Y _06953_/A VPWR VGND sg13cmos5l_a221oi_1
XFILLER_82_829 VPWR VGND sg13cmos5l_fill_2
XFILLER_47_561 VPWR VGND sg13cmos5l_decap_8
XFILLER_19_252 VPWR VGND sg13cmos5l_decap_4
XFILLER_35_734 VPWR VGND sg13cmos5l_fill_2
XFILLER_34_211 VPWR VGND sg13cmos5l_fill_1
X_06410_ _06410_/Y _06387_/B _06408_/C _06409_/Y VPWR VGND sg13cmos5l_a21oi_1
XFILLER_50_726 VPWR VGND sg13cmos5l_decap_4
XFILLER_35_778 VPWR VGND sg13cmos5l_fill_2
X_11097__1804 _11097_/RESET_B VPWR VGND sg13cmos5l_tiehi
X_07390_ _10882_/D _07389_/B _07388_/Y _07389_/Y VPWR VGND sg13cmos5l_a21oi_1
X_06341_ _10691_/D _06144_/X _06272_/Y _06339_/Y _06340_/X VPWR VGND sg13cmos5l_a22oi_1
X_09060_ _09066_/B _09068_/A _09068_/B _09068_/D VPWR VGND sg13cmos5l_nand3_1
X_06272_ _06272_/Y _06272_/A _06272_/B _06272_/C _06272_/D VPWR VGND sg13cmos5l_nand4_1
X_08011_ _08011_/Y _08011_/A _08011_/B VPWR VGND sg13cmos5l_nor2_1
XFILLER_104_728 VPWR VGND sg13cmos5l_decap_8
X_09962_ _09962_/Y _11365_/Q _09962_/B VPWR VGND sg13cmos5l_nand2_1
Xhold2003 _07922_/A _11051_/Q VPWR VGND sg13cmos5l_dlygate4sd3_1
XFILLER_103_238 VPWR VGND sg13cmos5l_decap_8
X_08913_ _08915_/A _08913_/A _08913_/B VPWR VGND sg13cmos5l_nand2_1
X_09893_ _09893_/Y _09253_/A _09891_/Y _09892_/Y VPWR VGND sg13cmos5l_o21ai_1
Xhold2014 _08338_/A _11255_/Q VPWR VGND sg13cmos5l_dlygate4sd3_1
Xhold2025 _11650_/D _06964_/Y VPWR VGND sg13cmos5l_dlygate4sd3_1
Xhold2036 _11667_/D _07023_/Y VPWR VGND sg13cmos5l_dlygate4sd3_1
Xhold2058 _06803_/A _11601_/Q VPWR VGND sg13cmos5l_dlygate4sd3_1
XFILLER_57_303 VPWR VGND sg13cmos5l_decap_8
X_08844_ _08844_/Y _08880_/A1 _08841_/A _08856_/B1 VPWR VGND sg13cmos5l_o21ai_1
Xhold2069 _07026_/A _11668_/Q VPWR VGND sg13cmos5l_dlygate4sd3_1
Xhold2047 _11665_/D _07015_/Y VPWR VGND sg13cmos5l_dlygate4sd3_1
XFILLER_100_978 VPWR VGND sg13cmos5l_decap_8
X_05987_ _05987_/Y _11337_/Q VPWR VGND sg13cmos5l_inv_1
X_08775_ _08775_/Y _08653_/Y _08774_/Y _06078_/A VPWR VGND sg13cmos5l_o21ai_1
XFILLER_73_829 VPWR VGND sg13cmos5l_fill_2
XFILLER_72_328 VPWR VGND sg13cmos5l_fill_1
XFILLER_26_723 VPWR VGND sg13cmos5l_decap_4
X_07726_ _07726_/Y _07726_/A _07750_/B VPWR VGND sg13cmos5l_nor2_1
XFILLER_65_380 VPWR VGND sg13cmos5l_fill_1
X_07657_ _10922_/D _08508_/A1 _07714_/B _07656_/Y VPWR VGND sg13cmos5l_a21oi_1
XFILLER_80_361 VPWR VGND sg13cmos5l_fill_1
XFILLER_14_907 VPWR VGND sg13cmos5l_fill_1
XFILLER_14_929 VPWR VGND sg13cmos5l_decap_8
XFILLER_26_778 VPWR VGND sg13cmos5l_decap_8
X_07588_ _07588_/Y _07588_/A _07607_/B VPWR VGND sg13cmos5l_nor2_1
XFILLER_41_759 VPWR VGND sg13cmos5l_fill_1
XFILLER_41_737 VPWR VGND sg13cmos5l_decap_8
X_06608_ _10798_/D _06668_/A1 _06605_/X _06607_/Y VPWR VGND sg13cmos5l_o21ai_1
X_09327_ _09379_/B _10173_/A _09336_/B VPWR VGND sg13cmos5l_nand2_1
XFILLER_43_69 VPWR VGND sg13cmos5l_fill_2
XFILLER_40_258 VPWR VGND sg13cmos5l_fill_1
X_06539_ _06539_/Y _06539_/A _06539_/B VPWR VGND sg13cmos5l_nand2_1
XFILLER_22_951 VPWR VGND sg13cmos5l_fill_1
XFILLER_21_461 VPWR VGND sg13cmos5l_fill_2
X_09258_ _09259_/B _09246_/A _10856_/Q _09254_/C _09256_/Y _09257_/Y VPWR VGND sg13cmos5l_a221oi_1
X_10922__1060 _10922_/RESET_B VPWR VGND sg13cmos5l_tiehi
X_09189_ _09325_/B _09189_/A _10831_/Q VPWR VGND sg13cmos5l_xor2_1
X_08209_ _11191_/D _08339_/A1 _08208_/B _08208_/Y VPWR VGND sg13cmos5l_o21ai_1
X_11220_ _11220_/Q clkload10/A _11220_/D _11220_/RESET_B VPWR VGND sg13cmos5l_dfrbpq_1
X_11151_ _11151_/Q clkload44/A _11151_/D _11151_/RESET_B VPWR VGND sg13cmos5l_dfrbpq_1
XFILLER_0_321 VPWR VGND sg13cmos5l_decap_4
X_10102_ _10102_/Y _10114_/A1 _09640_/B _10101_/Y VPWR VGND sg13cmos5l_a21oi_1
X_11082_ _11082_/Q _11646_/CLK _11082_/D _11082_/RESET_B VPWR VGND sg13cmos5l_dfrbpq_1
X_11175__1726 _11175_/RESET_B VPWR VGND sg13cmos5l_tiehi
XFILLER_95_409 VPWR VGND sg13cmos5l_fill_2
XFILLER_89_962 VPWR VGND sg13cmos5l_decap_4
XFILLER_1_866 VPWR VGND sg13cmos5l_decap_8
X_11211__1690 _11211_/RESET_B VPWR VGND sg13cmos5l_tiehi
X_10033_ _10033_/Y _10033_/A _10033_/B VPWR VGND sg13cmos5l_nand2_1
XFILLER_0_376 VPWR VGND sg13cmos5l_decap_8
XFILLER_84_21 VPWR VGND sg13cmos5l_decap_8
Xhold2570 _11587_/D _10773_/Y VPWR VGND sg13cmos5l_dlygate4sd3_1
Xhold2581 _10731_/B _11753_/Q VPWR VGND sg13cmos5l_dlygate4sd3_1
XFILLER_64_818 VPWR VGND sg13cmos5l_fill_1
Xhold2592 _10874_/D _07342_/Y VPWR VGND sg13cmos5l_dlygate4sd3_1
Xhold1880 _08322_/A _11247_/Q VPWR VGND sg13cmos5l_dlygate4sd3_1
Xhold1891 _08100_/A _11139_/Q VPWR VGND sg13cmos5l_dlygate4sd3_1
XFILLER_56_380 VPWR VGND sg13cmos5l_decap_8
XFILLER_72_873 VPWR VGND sg13cmos5l_fill_2
XFILLER_72_862 VPWR VGND sg13cmos5l_decap_8
XFILLER_56_1028 VPWR VGND sg13cmos5l_fill_1
XFILLER_56_1017 VPWR VGND sg13cmos5l_decap_8
X_10935_ _10935_/Q _11347_/CLK _10935_/D _10935_/RESET_B VPWR VGND sg13cmos5l_dfrbpq_1
X_10866_ _10866_/Q clkload12/A _10866_/D _10866_/RESET_B VPWR VGND sg13cmos5l_dfrbpq_1
X_10797_ _10797_/Q clkload13/A _10797_/D _10797_/RESET_B VPWR VGND sg13cmos5l_dfrbpq_1
XFILLER_40_781 VPWR VGND sg13cmos5l_decap_8
XFILLER_9_933 VPWR VGND sg13cmos5l_fill_1
XFILLER_40_792 VPWR VGND sg13cmos5l_fill_2
XFILLER_9_977 VPWR VGND sg13cmos5l_decap_8
XFILLER_8_476 VPWR VGND sg13cmos5l_fill_1
X_11418_ _11418_/Q clkload47/A _11418_/D _11418_/RESET_B VPWR VGND sg13cmos5l_dfrbpq_1
X_11349_ _11349_/Q _11349_/CLK _11349_/D _11349_/RESET_B VPWR VGND sg13cmos5l_dfrbpq_1
XFILLER_101_709 VPWR VGND sg13cmos5l_fill_1
XFILLER_98_258 VPWR VGND sg13cmos5l_decap_4
XFILLER_67_601 VPWR VGND sg13cmos5l_decap_4
XFILLER_100_219 VPWR VGND sg13cmos5l_fill_1
XFILLER_95_943 VPWR VGND sg13cmos5l_decap_8
X_06890_ _06890_/X _11731_/Q hold2687/X _07091_/S VPWR VGND sg13cmos5l_mux2_1
XFILLER_39_303 VPWR VGND sg13cmos5l_decap_8
X_05910_ _05910_/Y _09721_/A VPWR VGND sg13cmos5l_inv_1
XFILLER_95_965 VPWR VGND sg13cmos5l_decap_8
XFILLER_67_656 VPWR VGND sg13cmos5l_fill_2
XFILLER_66_122 VPWR VGND sg13cmos5l_decap_8
XFILLER_39_336 VPWR VGND sg13cmos5l_decap_8
XFILLER_27_509 VPWR VGND sg13cmos5l_fill_1
XFILLER_54_306 VPWR VGND sg13cmos5l_fill_2
XFILLER_39_369 VPWR VGND sg13cmos5l_decap_8
X_08560_ _11364_/D fanout59/X _08559_/B _08559_/Y VPWR VGND sg13cmos5l_a21oi_1
XFILLER_48_892 VPWR VGND sg13cmos5l_decap_8
XFILLER_47_391 VPWR VGND sg13cmos5l_decap_4
X_10964__1018 _10964_/RESET_B VPWR VGND sg13cmos5l_tiehi
X_08491_ _11330_/D fanout63/X _08498_/B _08490_/Y VPWR VGND sg13cmos5l_o21ai_1
X_07511_ _07511_/Y _07511_/A _07526_/B VPWR VGND sg13cmos5l_nor2_1
XFILLER_90_681 VPWR VGND sg13cmos5l_decap_4
X_07442_ _07442_/Y _11558_/Q _11556_/Q VPWR VGND sg13cmos5l_nor2b_1
X_07373_ _07373_/Y _11541_/Q _08730_/A VPWR VGND sg13cmos5l_nand2_1
X_09112_ _09112_/Y _09118_/A _09112_/B VPWR VGND sg13cmos5l_xnor2_1
X_06324_ _06324_/Y _11514_/Q _09246_/A VPWR VGND sg13cmos5l_nand2b_1
X_11253__1648 _11253_/RESET_B VPWR VGND sg13cmos5l_tiehi
X_06255_ _06255_/Y _11514_/Q _09246_/A VPWR VGND sg13cmos5l_nor2_1
X_09043_ _09043_/Y _09043_/A _09068_/A VPWR VGND sg13cmos5l_nand2_1
X_06186_ _06628_/A _06351_/A _06353_/C VPWR VGND sg13cmos5l_nand2_1
XFILLER_104_547 VPWR VGND sg13cmos5l_fill_1
X_09945_ _09945_/Y _09298_/Y _09937_/Y _09944_/Y VPWR VGND sg13cmos5l_a21oi_1
XFILLER_85_420 VPWR VGND sg13cmos5l_fill_2
X_09876_ _09876_/X _11266_/Q _11234_/Q _11202_/Q _11170_/Q _09984_/B _09990_/S1 VPWR
+ VGND sg13cmos5l_mux4_1
XFILLER_57_100 VPWR VGND sg13cmos5l_decap_8
XFILLER_85_431 VPWR VGND sg13cmos5l_decap_8
X_08827_ _08827_/X _11380_/Q _08827_/B VPWR VGND sg13cmos5l_xor2_1
XFILLER_38_69 VPWR VGND sg13cmos5l_decap_8
XFILLER_100_775 VPWR VGND sg13cmos5l_fill_1
XFILLER_85_464 VPWR VGND sg13cmos5l_decap_8
X_08758_ _08759_/B _08762_/A _08758_/B VPWR VGND sg13cmos5l_nand2_1
X_07709_ _10948_/D fanout59/X _07714_/B _07708_/Y VPWR VGND sg13cmos5l_a21oi_1
XFILLER_54_46 VPWR VGND sg13cmos5l_fill_1
XFILLER_53_350 VPWR VGND sg13cmos5l_decap_8
X_08689_ _08690_/B _08689_/A _08689_/B VPWR VGND sg13cmos5l_nand2_1
X_10720_ _10720_/Y _10720_/A _10730_/B VPWR VGND sg13cmos5l_nor2b_1
XFILLER_41_512 VPWR VGND sg13cmos5l_fill_1
XFILLER_14_759 VPWR VGND sg13cmos5l_decap_4
X_10651_ _10651_/Y _10653_/A _10857_/Q _10653_/C VPWR VGND sg13cmos5l_a21oi_1
XFILLER_41_589 VPWR VGND sg13cmos5l_fill_1
XFILLER_13_269 VPWR VGND sg13cmos5l_fill_1
XFILLER_16_1012 VPWR VGND sg13cmos5l_decap_8
XFILLER_70_56 VPWR VGND sg13cmos5l_fill_1
X_10582_ _10622_/A _10583_/A _10583_/B _10583_/C VPWR VGND sg13cmos5l_a21o_1
X_11393__1504 _11393_/RESET_B VPWR VGND sg13cmos5l_tiehi
XFILLER_10_965 VPWR VGND sg13cmos5l_fill_2
XFILLER_10_976 VPWR VGND sg13cmos5l_decap_8
X_11229__1672 _11229_/RESET_B VPWR VGND sg13cmos5l_tiehi
XFILLER_6_947 VPWR VGND sg13cmos5l_decap_4
XFILLER_102_0 VPWR VGND sg13cmos5l_decap_8
X_11203_ _11203_/Q clkload49/A _11203_/D _11203_/RESET_B VPWR VGND sg13cmos5l_dfrbpq_1
XFILLER_79_21 VPWR VGND sg13cmos5l_decap_8
XFILLER_5_479 VPWR VGND sg13cmos5l_fill_2
XFILLER_96_718 VPWR VGND sg13cmos5l_fill_1
X_11134_ _11134_/Q clkload58/A _11134_/D _11134_/RESET_B VPWR VGND sg13cmos5l_dfrbpq_1
X_11515__1153 _11515_/RESET_B VPWR VGND sg13cmos5l_tiehi
XFILLER_62_1021 VPWR VGND sg13cmos5l_decap_8
X_11065_ _11065_/Q clkload40/A _11065_/D _11065_/RESET_B VPWR VGND sg13cmos5l_dfrbpq_1
XFILLER_95_42 VPWR VGND sg13cmos5l_decap_8
X_10016_ _10017_/C _10012_/Y _10013_/Y _10014_/Y _10015_/Y _10016_/C1 VPWR VGND sg13cmos5l_a221oi_1
XFILLER_76_442 VPWR VGND sg13cmos5l_decap_8
XFILLER_0_195 VPWR VGND sg13cmos5l_fill_2
XFILLER_49_678 VPWR VGND sg13cmos5l_decap_4
XFILLER_92_957 VPWR VGND sg13cmos5l_decap_4
XFILLER_64_659 VPWR VGND sg13cmos5l_decap_4
XFILLER_64_637 VPWR VGND sg13cmos5l_fill_2
XFILLER_29_391 VPWR VGND sg13cmos5l_fill_2
XFILLER_51_309 VPWR VGND sg13cmos5l_fill_1
X_10918_ _10918_/Q clkload54/A _10918_/D _10918_/RESET_B VPWR VGND sg13cmos5l_dfrbpq_1
XFILLER_60_821 VPWR VGND sg13cmos5l_decap_8
XFILLER_71_191 VPWR VGND sg13cmos5l_fill_1
XFILLER_44_394 VPWR VGND sg13cmos5l_fill_2
X_10849_ _10849_/Q _11715_/CLK _10849_/D _10849_/RESET_B VPWR VGND sg13cmos5l_dfrbpq_1
XFILLER_8_240 VPWR VGND sg13cmos5l_fill_1
X_06040_ _06041_/D _11623_/Q _11620_/Q VPWR VGND sg13cmos5l_nor2_1
XFILLER_5_980 VPWR VGND sg13cmos5l_decap_8
X_11543__1487 _11543_/RESET_B VPWR VGND sg13cmos5l_tiehi
X_07991_ _07991_/Y _07991_/A _08005_/B VPWR VGND sg13cmos5l_nor2_1
Xfanout219 _08023_/B _08007_/B VPWR VGND sg13cmos5l_buf_1
Xfanout208 _08163_/B _08145_/B VPWR VGND sg13cmos5l_buf_1
Xclkbuf_4_7_0_clk clkload2/A clkbuf_0_clk/X VPWR VGND sg13cmos5l_buf_8
X_06942_ _06943_/D _11688_/D _11689_/D VPWR VGND sg13cmos5l_and2_1
X_09730_ _09731_/C _09729_/B _09729_/C _09729_/A VPWR VGND sg13cmos5l_a21o_1
XFILLER_95_795 VPWR VGND sg13cmos5l_fill_1
X_06873_ _06874_/D _11703_/Q _11686_/Q _06873_/C _06873_/D VPWR VGND sg13cmos5l_nor4_1
X_09661_ _09661_/Y _05971_/Y _09734_/B _09735_/B1 _09660_/Y VPWR VGND sg13cmos5l_a22oi_1
X_08612_ _08621_/D _08620_/A _08612_/B VPWR VGND sg13cmos5l_nand2_1
XFILLER_54_136 VPWR VGND sg13cmos5l_decap_8
XFILLER_27_339 VPWR VGND sg13cmos5l_decap_8
X_09592_ _09592_/Y _09591_/Y _09620_/B VPWR VGND sg13cmos5l_nand2b_1
X_11307__1594 _11307_/RESET_B VPWR VGND sg13cmos5l_tiehi
X_08543_ _08543_/Y _08543_/A _08543_/B VPWR VGND sg13cmos5l_nor2_1
XFILLER_51_821 VPWR VGND sg13cmos5l_decap_8
XFILLER_36_895 VPWR VGND sg13cmos5l_decap_4
XFILLER_35_361 VPWR VGND sg13cmos5l_decap_4
XFILLER_23_512 VPWR VGND sg13cmos5l_decap_8
XFILLER_50_331 VPWR VGND sg13cmos5l_decap_8
X_08474_ _08474_/Y _08474_/A _08488_/B VPWR VGND sg13cmos5l_nand2_1
XFILLER_23_545 VPWR VGND sg13cmos5l_fill_1
XFILLER_51_887 VPWR VGND sg13cmos5l_decap_8
XFILLER_50_375 VPWR VGND sg13cmos5l_decap_4
X_07425_ _07425_/Y _07425_/A _07425_/B VPWR VGND sg13cmos5l_nor2_1
X_07356_ _08722_/A _08990_/A _07362_/B VPWR VGND sg13cmos5l_nand2_1
XFILLER_10_228 VPWR VGND sg13cmos5l_fill_1
X_07287_ _07287_/Y _07287_/A _07383_/B VPWR VGND sg13cmos5l_nor2_1
X_06307_ _06307_/Y _06371_/B _06306_/Y _06305_/Y VPWR VGND sg13cmos5l_o21ai_1
X_09026_ _09026_/Y _09061_/A _09034_/B VPWR VGND sg13cmos5l_nor2_1
X_06238_ _06239_/B _06721_/A _06713_/A _06709_/A _06709_/B VPWR VGND sg13cmos5l_nor4_1
XFILLER_105_834 VPWR VGND sg13cmos5l_decap_8
XFILLER_105_823 VPWR VGND sg13cmos5l_decap_8
XFILLER_6_7 VPWR VGND sg13cmos5l_decap_8
X_06169_ _06179_/B _06657_/A _06649_/A VPWR VGND sg13cmos5l_nor2_1
XFILLER_104_388 VPWR VGND sg13cmos5l_decap_8
X_09928_ _09928_/Y _11076_/Q _10012_/B VPWR VGND sg13cmos5l_nand2_1
Xfanout742 _09268_/A hold2908/X VPWR VGND sg13cmos5l_buf_1
XFILLER_77_228 VPWR VGND sg13cmos5l_fill_1
XFILLER_59_932 VPWR VGND sg13cmos5l_fill_2
Xfanout731 _10267_/B _10426_/A1 VPWR VGND sg13cmos5l_buf_1
Xfanout720 _07527_/S _07447_/S VPWR VGND sg13cmos5l_buf_1
XFILLER_59_965 VPWR VGND sg13cmos5l_fill_1
Xfanout753 _10250_/A _10479_/A VPWR VGND sg13cmos5l_buf_1
Xfanout775 _09583_/A hold2851/X VPWR VGND sg13cmos5l_buf_1
Xfanout764 _06229_/B _10295_/A VPWR VGND sg13cmos5l_buf_1
XFILLER_105_63 VPWR VGND sg13cmos5l_decap_8
XFILLER_65_23 VPWR VGND sg13cmos5l_decap_8
X_09859_ _09860_/C _09942_/A _09855_/Y _09858_/Y VPWR VGND sg13cmos5l_o21ai_1
Xfanout786 _09180_/A _11459_/Q VPWR VGND sg13cmos5l_buf_1
Xfanout797 _10513_/A _11411_/Q VPWR VGND sg13cmos5l_buf_1
XFILLER_18_317 VPWR VGND sg13cmos5l_fill_2
XFILLER_73_412 VPWR VGND sg13cmos5l_fill_1
XFILLER_46_648 VPWR VGND sg13cmos5l_fill_2
XFILLER_45_114 VPWR VGND sg13cmos5l_fill_2
XFILLER_45_169 VPWR VGND sg13cmos5l_decap_4
XFILLER_45_147 VPWR VGND sg13cmos5l_decap_8
XFILLER_92_1003 VPWR VGND sg13cmos5l_decap_4
XFILLER_54_670 VPWR VGND sg13cmos5l_fill_1
X_11752_ _11752_/Q clkload21/A _11752_/D _11752_/RESET_B VPWR VGND sg13cmos5l_dfrbpq_1
XFILLER_14_556 VPWR VGND sg13cmos5l_fill_1
X_10703_ _10704_/D _10703_/A _10703_/B _11757_/Q VPWR VGND sg13cmos5l_nor3_1
X_11683_ _11683_/Q _11767_/CLK _11683_/D _11683_/RESET_B VPWR VGND sg13cmos5l_dfrbpq_1
XFILLER_41_375 VPWR VGND sg13cmos5l_decap_4
X_10634_ _10634_/Y _07623_/A _05984_/Y _10628_/A VPWR VGND sg13cmos5l_a21oi_1
X_10565_ _11542_/D _10449_/Y _10564_/X _10560_/X VPWR VGND sg13cmos5l_o21ai_1
X_10496_ _10568_/A _11410_/Q _10847_/Q VPWR VGND sg13cmos5l_xnor2_1
XFILLER_46_8 VPWR VGND sg13cmos5l_decap_4
XFILLER_2_983 VPWR VGND sg13cmos5l_decap_8
X_11117_ _11117_/Q clkload34/A _11117_/D _11117_/RESET_B VPWR VGND sg13cmos5l_dfrbpq_1
XFILLER_96_559 VPWR VGND sg13cmos5l_decap_4
XFILLER_68_239 VPWR VGND sg13cmos5l_fill_2
XFILLER_49_420 VPWR VGND sg13cmos5l_fill_2
XFILLER_7_1021 VPWR VGND sg13cmos5l_decap_8
X_11048_ _11048_/Q clkload51/A _11048_/D _11048_/RESET_B VPWR VGND sg13cmos5l_dfrbpq_1
Xinput8 input8/X ui_in[15] VPWR VGND sg13cmos5l_buf_1
XFILLER_49_475 VPWR VGND sg13cmos5l_decap_4
XFILLER_37_604 VPWR VGND sg13cmos5l_fill_1
XFILLER_76_283 VPWR VGND sg13cmos5l_decap_4
XFILLER_65_968 VPWR VGND sg13cmos5l_fill_1
XFILLER_37_659 VPWR VGND sg13cmos5l_decap_4
XFILLER_36_158 VPWR VGND sg13cmos5l_decap_8
XFILLER_91_286 VPWR VGND sg13cmos5l_fill_1
XFILLER_51_106 VPWR VGND sg13cmos5l_decap_8
X_10881__1101 _10881_/RESET_B VPWR VGND sg13cmos5l_tiehi
XFILLER_33_832 VPWR VGND sg13cmos5l_decap_8
XFILLER_51_139 VPWR VGND sg13cmos5l_fill_1
XFILLER_17_394 VPWR VGND sg13cmos5l_decap_8
XFILLER_20_504 VPWR VGND sg13cmos5l_decap_4
X_07210_ _07210_/X _11641_/Q _07210_/B VPWR VGND sg13cmos5l_and2_1
X_08190_ _08190_/Y _08190_/A _08198_/B VPWR VGND sg13cmos5l_nand2_1
XFILLER_20_526 VPWR VGND sg13cmos5l_decap_8
X_07141_ _07141_/Y hold2746/X _07142_/A2 _07155_/B1 VPWR VGND sg13cmos5l_o21ai_1
XFILLER_106_609 VPWR VGND sg13cmos5l_decap_8
X_11170__1731 _11170_/RESET_B VPWR VGND sg13cmos5l_tiehi
X_07072_ _07081_/B _07076_/B _07072_/B VPWR VGND sg13cmos5l_nor2_1
XFILLER_10_18 VPWR VGND sg13cmos5l_decap_8
XFILLER_105_119 VPWR VGND sg13cmos5l_decap_8
X_06023_ _06023_/X _10707_/A _10783_/B VPWR VGND sg13cmos5l_and2_1
XFILLER_101_336 VPWR VGND sg13cmos5l_fill_2
XFILLER_101_325 VPWR VGND sg13cmos5l_decap_8
XFILLER_68_740 VPWR VGND sg13cmos5l_decap_8
XFILLER_59_239 VPWR VGND sg13cmos5l_decap_8
X_07974_ _07974_/Y _07974_/A _07974_/B VPWR VGND sg13cmos5l_nand2_1
XFILLER_19_38 VPWR VGND sg13cmos5l_decap_8
X_06925_ _06925_/Y _06804_/B _06874_/A _06841_/Y VPWR VGND sg13cmos5l_a21oi_1
XFILLER_68_762 VPWR VGND sg13cmos5l_decap_8
X_09713_ _09713_/Y _09846_/A1 _09707_/X _09633_/A VPWR VGND sg13cmos5l_a21oi_1
X_06856_ _11618_/D _06820_/Y _06851_/Y _06855_/Y VPWR VGND sg13cmos5l_o21ai_1
XFILLER_55_412 VPWR VGND sg13cmos5l_fill_2
X_09644_ _09644_/Y _09644_/A _09724_/B VPWR VGND sg13cmos5l_nand2_1
XFILLER_82_242 VPWR VGND sg13cmos5l_decap_4
XFILLER_71_905 VPWR VGND sg13cmos5l_decap_4
X_06787_ _06801_/B _06820_/C _06820_/B VPWR VGND sg13cmos5l_nor2_1
XFILLER_82_286 VPWR VGND sg13cmos5l_fill_1
X_09575_ _09575_/X _11255_/Q _11223_/Q _11191_/Q _11159_/Q _09440_/B _09575_/S1 VPWR
+ VGND sg13cmos5l_mux4_1
X_08526_ _11347_/D _08526_/A1 _08527_/B _08525_/Y VPWR VGND sg13cmos5l_a21oi_1
X_08457_ _11313_/D _08457_/A1 _08466_/B _08456_/Y VPWR VGND sg13cmos5l_o21ai_1
XFILLER_50_194 VPWR VGND sg13cmos5l_fill_2
X_07408_ _10885_/D _07407_/B _07406_/Y _07407_/Y VPWR VGND sg13cmos5l_a21oi_1
X_08388_ _11279_/D _08453_/A1 _08405_/B _08387_/Y VPWR VGND sg13cmos5l_a21oi_1
X_07339_ _07339_/Y _07337_/Y _07338_/Y _07340_/A2 VPWR VGND sg13cmos5l_a21oi_1
X_10350_ _10351_/C _10333_/A _10334_/Y _10378_/A VPWR VGND sg13cmos5l_a21oi_1
X_09009_ _09028_/B _09036_/A _09036_/D VPWR VGND sg13cmos5l_nand2_1
X_10281_ _10281_/X _10282_/A _10282_/B VPWR VGND sg13cmos5l_and2_1
XFILLER_105_642 VPWR VGND sg13cmos5l_decap_8
XFILLER_2_268 VPWR VGND sg13cmos5l_fill_2
XFILLER_104_196 VPWR VGND sg13cmos5l_decap_8
Xfanout550 _08616_/A _08612_/B VPWR VGND sg13cmos5l_buf_1
Xfanout561 _10760_/S _10762_/S VPWR VGND sg13cmos5l_buf_1
XFILLER_76_55 VPWR VGND sg13cmos5l_decap_4
Xfanout572 _07191_/A2 _06781_/Y VPWR VGND sg13cmos5l_buf_1
Xfanout583 _06400_/B _06401_/B VPWR VGND sg13cmos5l_buf_1
XFILLER_59_762 VPWR VGND sg13cmos5l_decap_8
XFILLER_47_924 VPWR VGND sg13cmos5l_decap_8
XFILLER_86_581 VPWR VGND sg13cmos5l_decap_8
XFILLER_74_710 VPWR VGND sg13cmos5l_decap_4
Xfanout594 _07132_/A2 _07108_/A2 VPWR VGND sg13cmos5l_buf_1
XFILLER_92_21 VPWR VGND sg13cmos5l_decap_8
XFILLER_73_242 VPWR VGND sg13cmos5l_decap_8
XFILLER_15_810 VPWR VGND sg13cmos5l_fill_2
XFILLER_15_821 VPWR VGND sg13cmos5l_fill_1
XFILLER_27_670 VPWR VGND sg13cmos5l_decap_8
X_11735_ _11735_/Q _11766_/CLK _11735_/D _11735_/RESET_B VPWR VGND sg13cmos5l_dfrbpq_1
XFILLER_42_673 VPWR VGND sg13cmos5l_decap_8
XFILLER_14_364 VPWR VGND sg13cmos5l_decap_8
XFILLER_15_865 VPWR VGND sg13cmos5l_fill_2
XFILLER_70_993 VPWR VGND sg13cmos5l_decap_8
XFILLER_30_824 VPWR VGND sg13cmos5l_fill_1
X_11666_ _11666_/Q clkload7/A _11666_/D _11666_/RESET_B VPWR VGND sg13cmos5l_dfrbpq_1
X_11597_ _11597_/Q _11646_/CLK _11597_/D _11597_/RESET_B VPWR VGND sg13cmos5l_dfrbpq_1
X_10617_ _11545_/D _10628_/B _10609_/Y _10616_/Y VPWR VGND sg13cmos5l_a21o_1
X_10548_ _10548_/X _11738_/Q _10548_/B VPWR VGND sg13cmos5l_and2_1
X_10479_ _10525_/B _10479_/A _10479_/B _10479_/C VPWR VGND sg13cmos5l_nand3_1
XFILLER_96_312 VPWR VGND sg13cmos5l_decap_8
XFILLER_37_4 VPWR VGND sg13cmos5l_fill_2
XFILLER_2_791 VPWR VGND sg13cmos5l_fill_2
XFILLER_2_780 VPWR VGND sg13cmos5l_decap_8
XFILLER_77_570 VPWR VGND sg13cmos5l_decap_8
XFILLER_65_710 VPWR VGND sg13cmos5l_decap_4
X_06710_ _06710_/Y _06710_/A _06710_/B VPWR VGND sg13cmos5l_nor2_1
X_07690_ _07690_/Y _07690_/A _07712_/B VPWR VGND sg13cmos5l_nor2_1
X_11188__1713 _11188_/RESET_B VPWR VGND sg13cmos5l_tiehi
X_06641_ _06641_/Y _06171_/Y _06400_/D _06401_/C VPWR VGND sg13cmos5l_a21oi_1
X_11380__1518 _11380_/RESET_B VPWR VGND sg13cmos5l_tiehi
X_09360_ _09360_/Y _10927_/Q _09600_/B VPWR VGND sg13cmos5l_nand2_1
X_06572_ _06572_/Y _06572_/A _06572_/B VPWR VGND sg13cmos5l_nand2_1
X_09291_ _09291_/Y _10043_/C1 _09290_/X _10044_/A VPWR VGND sg13cmos5l_a21oi_1
X_08311_ _08311_/Y _08311_/A _08311_/B VPWR VGND sg13cmos5l_nand2_1
XFILLER_33_651 VPWR VGND sg13cmos5l_fill_1
X_08242_ _08242_/Y _08242_/A _08242_/B VPWR VGND sg13cmos5l_nand2_1
XANTENNA_13 _06476_/A VPWR VGND sg13cmos5l_antennanp
XFILLER_61_993 VPWR VGND sg13cmos5l_decap_4
XFILLER_32_161 VPWR VGND sg13cmos5l_fill_2
XFILLER_21_868 VPWR VGND sg13cmos5l_decap_8
X_08173_ _08173_/Y _08173_/A _08173_/B VPWR VGND sg13cmos5l_nor2_1
XFILLER_106_406 VPWR VGND sg13cmos5l_decap_8
X_11743__1194 _11743_/RESET_B VPWR VGND sg13cmos5l_tiehi
X_07124_ _11727_/D _05878_/Y _07130_/A2 _07123_/Y VPWR VGND sg13cmos5l_a21oi_1
X_11438__1414 _11438_/RESET_B VPWR VGND sg13cmos5l_tiehi
X_07055_ _07055_/Y _11516_/Q _07055_/B VPWR VGND sg13cmos5l_nand2_1
X_06006_ _06007_/D _06803_/A _10723_/A VPWR VGND sg13cmos5l_or2_1
XFILLER_102_612 VPWR VGND sg13cmos5l_decap_4
XFILLER_99_172 VPWR VGND sg13cmos5l_fill_2
XFILLER_88_813 VPWR VGND sg13cmos5l_fill_2
XFILLER_87_301 VPWR VGND sg13cmos5l_fill_2
X_11489__1205 _11489_/RESET_B VPWR VGND sg13cmos5l_tiehi
Xhold2900 hold2900/X _11632_/Q VPWR VGND sg13cmos5l_dlygate4sd3_1
XFILLER_43_1019 VPWR VGND sg13cmos5l_fill_1
Xhold2911 _09218_/A _11470_/Q VPWR VGND sg13cmos5l_dlygate4sd3_1
Xhold2922 hold2922/X _11462_/Q VPWR VGND sg13cmos5l_dlygate4sd3_1
XFILLER_102_678 VPWR VGND sg13cmos5l_decap_8
XFILLER_101_133 VPWR VGND sg13cmos5l_decap_8
Xhold2933 hold2933/X _11474_/Q VPWR VGND sg13cmos5l_dlygate4sd3_1
X_07957_ _11068_/D fanout80/X _07966_/B _07956_/Y VPWR VGND sg13cmos5l_o21ai_1
Xhold2944 _06150_/B _11470_/Q VPWR VGND sg13cmos5l_dlygate4sd3_1
X_06908_ _06908_/Y _06908_/A _06917_/B VPWR VGND sg13cmos5l_nor2_1
X_11635__1331 _11635_/RESET_B VPWR VGND sg13cmos5l_tiehi
XFILLER_44_905 VPWR VGND sg13cmos5l_fill_2
X_07888_ _11034_/D fanout97/X _07893_/B _07887_/Y VPWR VGND sg13cmos5l_a21oi_1
XFILLER_28_434 VPWR VGND sg13cmos5l_decap_8
X_06839_ _06848_/B _07201_/A _07205_/A _07210_/B _06839_/D VPWR VGND sg13cmos5l_or4_1
XFILLER_71_713 VPWR VGND sg13cmos5l_fill_1
X_09627_ _09633_/B _09623_/Y _09624_/Y _09625_/Y _09626_/Y _09738_/A1 VPWR VGND sg13cmos5l_a221oi_1
XFILLER_102_42 VPWR VGND sg13cmos5l_decap_8
X_09558_ _09563_/B _09884_/A _09558_/B _09558_/C VPWR VGND sg13cmos5l_nor3_1
X_08509_ _08509_/Y _08509_/A _08559_/B VPWR VGND sg13cmos5l_nor2_1
X_11520_ _11520_/Q clkload14/A _11520_/D _11520_/RESET_B VPWR VGND sg13cmos5l_dfrbpq_1
XFILLER_11_312 VPWR VGND sg13cmos5l_decap_8
XFILLER_24_695 VPWR VGND sg13cmos5l_fill_1
X_09489_ _09490_/B _09488_/A _09488_/B _09345_/A VPWR VGND sg13cmos5l_a21oi_1
XFILLER_8_806 VPWR VGND sg13cmos5l_decap_4
X_10977__1005 _10977_/RESET_B VPWR VGND sg13cmos5l_tiehi
X_11451_ _11451_/Q clkload53/A _11451_/D _11451_/RESET_B VPWR VGND sg13cmos5l_dfrbpq_1
XFILLER_11_367 VPWR VGND sg13cmos5l_decap_4
XFILLER_11_389 VPWR VGND sg13cmos5l_decap_4
X_11382_ _11382_/Q clkload30/A _11382_/D _11382_/RESET_B VPWR VGND sg13cmos5l_dfrbpq_1
X_10402_ _10402_/X _10453_/B _10402_/B VPWR VGND sg13cmos5l_xor2_1
X_10333_ _10333_/Y _10333_/A VPWR VGND sg13cmos5l_inv_1
XFILLER_11_94 VPWR VGND sg13cmos5l_decap_4
XFILLER_106_973 VPWR VGND sg13cmos5l_decap_8
XFILLER_105_461 VPWR VGND sg13cmos5l_decap_8
XFILLER_87_21 VPWR VGND sg13cmos5l_decap_8
X_11266__1635 _11266_/RESET_B VPWR VGND sg13cmos5l_tiehi
XFILLER_79_824 VPWR VGND sg13cmos5l_decap_4
X_10264_ _10264_/Y _10265_/A _10265_/B _10265_/C VPWR VGND sg13cmos5l_nor3_1
X_10195_ _10195_/Y _09180_/A _09335_/B _10194_/X _10353_/A VPWR VGND sg13cmos5l_a22oi_1
XFILLER_94_816 VPWR VGND sg13cmos5l_fill_2
XFILLER_38_209 VPWR VGND sg13cmos5l_decap_8
Xfanout391 _10017_/A _06467_/Y VPWR VGND sg13cmos5l_buf_1
Xfanout380 _07243_/B1 _07169_/Y VPWR VGND sg13cmos5l_buf_1
XFILLER_47_721 VPWR VGND sg13cmos5l_fill_1
XFILLER_35_905 VPWR VGND sg13cmos5l_fill_1
XFILLER_46_275 VPWR VGND sg13cmos5l_fill_1
XFILLER_62_757 VPWR VGND sg13cmos5l_decap_8
XFILLER_34_448 VPWR VGND sg13cmos5l_decap_8
XFILLER_15_673 VPWR VGND sg13cmos5l_decap_8
XFILLER_14_172 VPWR VGND sg13cmos5l_fill_1
XFILLER_30_621 VPWR VGND sg13cmos5l_fill_2
X_12767_ _12767_/X _12767_/A VPWR VGND sg13cmos5l_buf_1
X_11718_ _11718_/Q _11766_/CLK _11718_/D _11718_/RESET_B VPWR VGND sg13cmos5l_dfrbpq_1
Xinput11 input11/X ui_in[3] VPWR VGND sg13cmos5l_buf_1
X_11649_ _11649_/Q _11668_/CLK _11649_/D _11649_/RESET_B VPWR VGND sg13cmos5l_dfrbpq_1
XFILLER_7_861 VPWR VGND sg13cmos5l_fill_2
Xhold2207 _07648_/A _10921_/Q VPWR VGND sg13cmos5l_dlygate4sd3_1
Xhold2218 _08173_/A _11174_/Q VPWR VGND sg13cmos5l_dlygate4sd3_1
X_08860_ _08862_/A _08835_/Y _08848_/Y _08847_/Y VPWR VGND sg13cmos5l_o21ai_1
Xhold2229 _07700_/A _10944_/Q VPWR VGND sg13cmos5l_dlygate4sd3_1
XFILLER_96_142 VPWR VGND sg13cmos5l_decap_8
X_07811_ _10997_/D _08073_/A1 _07826_/B _07810_/Y VPWR VGND sg13cmos5l_o21ai_1
XFILLER_78_890 VPWR VGND sg13cmos5l_decap_8
X_08791_ _08791_/Y _08793_/A VPWR VGND sg13cmos5l_inv_1
XFILLER_93_860 VPWR VGND sg13cmos5l_fill_1
XFILLER_84_348 VPWR VGND sg13cmos5l_decap_8
XFILLER_37_220 VPWR VGND sg13cmos5l_decap_4
X_07742_ _07742_/Y _07742_/A _07746_/B VPWR VGND sg13cmos5l_nor2_1
XFILLER_38_776 VPWR VGND sg13cmos5l_decap_8
X_07673_ _10930_/D _08524_/A1 _07676_/B _07672_/Y VPWR VGND sg13cmos5l_a21oi_1
XFILLER_37_286 VPWR VGND sg13cmos5l_fill_2
X_09412_ _09412_/Y _10993_/Q _09841_/B VPWR VGND sg13cmos5l_nand2_1
X_06624_ _06626_/A _06351_/B _06351_/C _06639_/A VPWR VGND sg13cmos5l_a21oi_1
XFILLER_26_949 VPWR VGND sg13cmos5l_decap_8
XFILLER_80_554 VPWR VGND sg13cmos5l_fill_2
X_09343_ _11459_/D _09346_/A _09354_/B _09342_/Y VPWR VGND sg13cmos5l_a21o_1
XFILLER_12_109 VPWR VGND sg13cmos5l_fill_2
XFILLER_52_289 VPWR VGND sg13cmos5l_decap_4
X_06555_ _06557_/A _06564_/A1 _11657_/Q _10883_/Q _06134_/B VPWR VGND sg13cmos5l_a22oi_1
XFILLER_33_481 VPWR VGND sg13cmos5l_decap_4
X_09274_ _09283_/B _06014_/C _11757_/Q VPWR VGND sg13cmos5l_nand2b_1
X_06486_ _10164_/B _10161_/B _10162_/A VPWR VGND sg13cmos5l_nor2_1
X_11344__1557 _11344_/RESET_B VPWR VGND sg13cmos5l_tiehi
XFILLER_21_654 VPWR VGND sg13cmos5l_fill_1
X_08225_ _11199_/D fanout74/X _08242_/B _08224_/Y VPWR VGND sg13cmos5l_o21ai_1
X_08156_ _11165_/D fanout78/X _08155_/B _08155_/Y VPWR VGND sg13cmos5l_a21oi_1
XFILLER_106_203 VPWR VGND sg13cmos5l_decap_8
X_07107_ _07107_/Y _06908_/A _07108_/A2 _07145_/B1 VPWR VGND sg13cmos5l_o21ai_1
XFILLER_10_1018 VPWR VGND sg13cmos5l_decap_8
XFILLER_106_7 VPWR VGND sg13cmos5l_decap_8
X_08087_ _11132_/D fanout80/X _08096_/B _08086_/Y VPWR VGND sg13cmos5l_o21ai_1
X_07038_ _07038_/Y _07038_/A _07038_/B VPWR VGND sg13cmos5l_nand2_1
XFILLER_103_954 VPWR VGND sg13cmos5l_decap_8
XFILLER_88_643 VPWR VGND sg13cmos5l_decap_8
Xhold2730 _07194_/B _11381_/Q VPWR VGND sg13cmos5l_dlygate4sd3_1
XFILLER_57_35 VPWR VGND sg13cmos5l_fill_1
Xhold2741 hold2741/X _11413_/Q VPWR VGND sg13cmos5l_dlygate4sd3_1
XFILLER_48_518 VPWR VGND sg13cmos5l_decap_8
XFILLER_88_698 VPWR VGND sg13cmos5l_decap_8
Xhold2763 _06003_/B _11757_/Q VPWR VGND sg13cmos5l_dlygate4sd3_1
XFILLER_76_849 VPWR VGND sg13cmos5l_fill_1
Xhold2774 hold2774/X _11637_/Q VPWR VGND sg13cmos5l_dlygate4sd3_1
Xhold2752 hold2752/X _11739_/Q VPWR VGND sg13cmos5l_dlygate4sd3_1
XFILLER_57_68 VPWR VGND sg13cmos5l_decap_4
X_08989_ _11441_/D _08987_/Y _08988_/Y _08979_/Y VPWR VGND sg13cmos5l_o21ai_1
Xhold2796 hold2796/X _11378_/Q VPWR VGND sg13cmos5l_dlygate4sd3_1
Xhold2785 _11495_/D _10082_/X VPWR VGND sg13cmos5l_dlygate4sd3_1
X_10951_ _10951_/Q clkload49/A _10951_/D _10951_/RESET_B VPWR VGND sg13cmos5l_dfrbpq_1
XFILLER_44_713 VPWR VGND sg13cmos5l_decap_4
XFILLER_73_34 VPWR VGND sg13cmos5l_decap_8
XFILLER_44_735 VPWR VGND sg13cmos5l_decap_8
X_10882_ _10882_/Q _11767_/CLK _10882_/D _10882_/RESET_B VPWR VGND sg13cmos5l_dfrbpq_1
XFILLER_44_768 VPWR VGND sg13cmos5l_decap_8
XFILLER_43_267 VPWR VGND sg13cmos5l_decap_4
XFILLER_43_289 VPWR VGND sg13cmos5l_decap_8
XFILLER_40_985 VPWR VGND sg13cmos5l_decap_4
X_11503_ _11503_/Q clkload38/A _11503_/D _11503_/RESET_B VPWR VGND sg13cmos5l_dfrbpq_1
X_11434_ _11434_/Q clkload19/A _11434_/D _11434_/RESET_B VPWR VGND sg13cmos5l_dfrbpq_1
XFILLER_8_658 VPWR VGND sg13cmos5l_decap_8
XFILLER_22_82 VPWR VGND sg13cmos5l_fill_1
XFILLER_98_42 VPWR VGND sg13cmos5l_decap_8
X_11365_ _11365_/Q clkload54/A _11365_/D _11365_/RESET_B VPWR VGND sg13cmos5l_dfrbpq_1
XFILLER_4_842 VPWR VGND sg13cmos5l_decap_8
XFILLER_106_770 VPWR VGND sg13cmos5l_decap_8
XFILLER_98_407 VPWR VGND sg13cmos5l_fill_1
X_11296_ _11296_/Q clkload56/A _11296_/D _11296_/RESET_B VPWR VGND sg13cmos5l_dfrbpq_1
X_10316_ _10334_/B _10317_/A _10317_/B _10317_/C VPWR VGND sg13cmos5l_a21o_1
XFILLER_105_280 VPWR VGND sg13cmos5l_decap_8
X_10247_ _10282_/B _10250_/B _10247_/B _10252_/C VPWR VGND sg13cmos5l_nand3_1
XFILLER_3_396 VPWR VGND sg13cmos5l_decap_8
X_10178_ _10178_/Y _10703_/A _10177_/X _10168_/B VPWR VGND sg13cmos5l_a21oi_1
XFILLER_39_518 VPWR VGND sg13cmos5l_decap_8
X_11422__1446 _11422_/RESET_B VPWR VGND sg13cmos5l_tiehi
XFILLER_93_189 VPWR VGND sg13cmos5l_fill_1
XFILLER_47_90 VPWR VGND sg13cmos5l_decap_4
X_11473__1237 _11473_/RESET_B VPWR VGND sg13cmos5l_tiehi
XFILLER_35_713 VPWR VGND sg13cmos5l_decap_8
XFILLER_47_584 VPWR VGND sg13cmos5l_fill_2
XFILLER_16_971 VPWR VGND sg13cmos5l_fill_2
XFILLER_34_245 VPWR VGND sg13cmos5l_fill_2
XFILLER_72_1001 VPWR VGND sg13cmos5l_fill_1
X_06340_ _06340_/X _05912_/Y _05857_/Y _06340_/S VPWR VGND sg13cmos5l_mux2_1
X_11591__1423 _11591_/RESET_B VPWR VGND sg13cmos5l_tiehi
X_06271_ _06272_/D _06443_/A _10672_/A _06328_/C _06271_/D VPWR VGND sg13cmos5l_and4_1
XFILLER_30_451 VPWR VGND sg13cmos5l_fill_2
X_08010_ _11094_/D _08075_/A1 _08031_/B _08009_/Y VPWR VGND sg13cmos5l_a21oi_1
XFILLER_8_95 VPWR VGND sg13cmos5l_decap_8
XFILLER_104_707 VPWR VGND sg13cmos5l_decap_8
X_09961_ _09961_/X _11269_/Q _11237_/Q _11205_/Q _11173_/Q _09962_/B _09991_/B1 VPWR
+ VGND sg13cmos5l_mux4_1
XFILLER_103_217 VPWR VGND sg13cmos5l_decap_8
X_08912_ _08913_/B _11385_/Q _08896_/B _08907_/C _08910_/Y _08911_/Y VPWR VGND sg13cmos5l_a221oi_1
XFILLER_100_902 VPWR VGND sg13cmos5l_fill_2
Xhold2004 _08370_/A _11271_/Q VPWR VGND sg13cmos5l_dlygate4sd3_1
Xhold2015 _07838_/A _11011_/Q VPWR VGND sg13cmos5l_dlygate4sd3_1
X_09892_ _09892_/Y _09253_/A _09891_/Y _10032_/A VPWR VGND sg13cmos5l_a21oi_1
Xhold2026 _07936_/A _11058_/Q VPWR VGND sg13cmos5l_dlygate4sd3_1
XFILLER_100_924 VPWR VGND sg13cmos5l_fill_1
XFILLER_98_996 VPWR VGND sg13cmos5l_decap_8
Xhold2059 _11601_/D _06805_/Y VPWR VGND sg13cmos5l_dlygate4sd3_1
X_08843_ _08843_/Y _08867_/A _08839_/X _08853_/B _08842_/Y _10719_/C VPWR VGND sg13cmos5l_a221oi_1
Xhold2037 _08358_/A _11265_/Q VPWR VGND sg13cmos5l_dlygate4sd3_1
Xhold2048 _06967_/A _11652_/Q VPWR VGND sg13cmos5l_dlygate4sd3_1
X_11667__1297 _11667_/RESET_B VPWR VGND sg13cmos5l_tiehi
X_05986_ _05986_/Y _11336_/Q VPWR VGND sg13cmos5l_inv_1
X_08774_ _08774_/Y _08774_/A _08774_/B _11634_/Q VPWR VGND sg13cmos5l_nand3_1
XFILLER_57_359 VPWR VGND sg13cmos5l_fill_1
XFILLER_38_540 VPWR VGND sg13cmos5l_fill_2
X_07725_ _10955_/D _08053_/A1 _07780_/B _07724_/Y VPWR VGND sg13cmos5l_a21oi_1
XFILLER_66_893 VPWR VGND sg13cmos5l_fill_2
XFILLER_65_392 VPWR VGND sg13cmos5l_decap_4
XFILLER_25_223 VPWR VGND sg13cmos5l_decap_8
X_07656_ _07656_/Y _07656_/A _07714_/B VPWR VGND sg13cmos5l_nor2_1
XFILLER_53_576 VPWR VGND sg13cmos5l_fill_2
XFILLER_41_716 VPWR VGND sg13cmos5l_decap_8
XFILLER_25_245 VPWR VGND sg13cmos5l_fill_1
XFILLER_25_256 VPWR VGND sg13cmos5l_fill_1
X_07587_ _10911_/D _07607_/B fanout74/X _07581_/Y VPWR VGND sg13cmos5l_a21oi_1
XFILLER_80_373 VPWR VGND sg13cmos5l_decap_4
X_06607_ _06607_/Y _06182_/B _06614_/A _06400_/D _06605_/A _06606_/Y VPWR VGND sg13cmos5l_a221oi_1
X_09326_ _09326_/Y _09326_/A _09335_/B _09456_/B VPWR VGND sg13cmos5l_nand3_1
X_06538_ _06539_/B _06571_/A1 _11667_/Q _10861_/Q _06574_/B2 VPWR VGND sg13cmos5l_a22oi_1
X_09257_ _09257_/Y _09856_/A _05984_/Y _09948_/B VPWR VGND sg13cmos5l_a21oi_1
X_08208_ _08208_/Y _08208_/A _08208_/B VPWR VGND sg13cmos5l_nand2_1
X_06469_ _06469_/Y _11116_/Q _09600_/B _09688_/S1 VPWR VGND sg13cmos5l_a21oi_1
X_09188_ _09325_/A _09185_/Y _09321_/B _09184_/Y VPWR VGND sg13cmos5l_o21ai_1
X_08139_ _08139_/Y _08139_/A _08155_/B VPWR VGND sg13cmos5l_nor2_1
X_11150_ _11150_/Q _11668_/CLK _11150_/D _11150_/RESET_B VPWR VGND sg13cmos5l_dfrbpq_1
XFILLER_0_311 VPWR VGND sg13cmos5l_fill_1
XFILLER_1_845 VPWR VGND sg13cmos5l_decap_8
X_10101_ _10101_/Y _10114_/A1 _05970_/A _10131_/A2 VPWR VGND sg13cmos5l_o21ai_1
X_11081_ _11081_/Q clkload50/A _11081_/D _11081_/RESET_B VPWR VGND sg13cmos5l_dfrbpq_1
XFILLER_0_355 VPWR VGND sg13cmos5l_decap_8
XFILLER_0_344 VPWR VGND sg13cmos5l_fill_2
X_10032_ _10033_/B _10032_/A _10032_/B VPWR VGND sg13cmos5l_nor2_1
XFILLER_76_613 VPWR VGND sg13cmos5l_decap_8
XFILLER_49_849 VPWR VGND sg13cmos5l_decap_8
Xhold2571 _06831_/B _11714_/Q VPWR VGND sg13cmos5l_dlygate4sd3_1
Xhold2560 hold2560/X _11686_/Q VPWR VGND sg13cmos5l_dlygate4sd3_1
Xhold2582 _11756_/D _06063_/Y VPWR VGND sg13cmos5l_dlygate4sd3_1
XFILLER_75_123 VPWR VGND sg13cmos5l_fill_1
Xhold1881 _08108_/A _11143_/Q VPWR VGND sg13cmos5l_dlygate4sd3_1
Xhold2593 _10747_/A _11568_/Q VPWR VGND sg13cmos5l_dlygate4sd3_1
XFILLER_75_167 VPWR VGND sg13cmos5l_fill_2
XFILLER_1_1016 VPWR VGND sg13cmos5l_decap_8
Xhold1870 _08478_/A _11324_/Q VPWR VGND sg13cmos5l_dlygate4sd3_1
XFILLER_44_510 VPWR VGND sg13cmos5l_fill_2
Xhold1892 _08200_/A _11187_/Q VPWR VGND sg13cmos5l_dlygate4sd3_1
XFILLER_1_1027 VPWR VGND sg13cmos5l_fill_2
XFILLER_90_159 VPWR VGND sg13cmos5l_fill_1
X_11712__1252 _11712_/RESET_B VPWR VGND sg13cmos5l_tiehi
XFILLER_72_852 VPWR VGND sg13cmos5l_decap_4
XFILLER_71_351 VPWR VGND sg13cmos5l_decap_4
X_10934_ _10934_/Q clkload33/A _10934_/D _10934_/RESET_B VPWR VGND sg13cmos5l_dfrbpq_1
X_10865_ _10865_/Q clkload8/A _10865_/D _10865_/RESET_B VPWR VGND sg13cmos5l_dfrbpq_1
XFILLER_31_204 VPWR VGND sg13cmos5l_fill_1
XFILLER_71_395 VPWR VGND sg13cmos5l_decap_4
XFILLER_31_248 VPWR VGND sg13cmos5l_fill_1
X_10796_ _10796_/Q clkload13/A _10796_/D _10796_/RESET_B VPWR VGND sg13cmos5l_dfrbpq_1
XFILLER_12_440 VPWR VGND sg13cmos5l_fill_1
XFILLER_33_70 VPWR VGND sg13cmos5l_fill_1
X_11417_ _11417_/Q clkload47/A _11417_/D _11417_/RESET_B VPWR VGND sg13cmos5l_dfrbpq_1
X_11348_ _11348_/Q clkload16/A _11348_/D _11348_/RESET_B VPWR VGND sg13cmos5l_dfrbpq_1
XFILLER_95_900 VPWR VGND sg13cmos5l_decap_4
XFILLER_79_440 VPWR VGND sg13cmos5l_fill_2
X_11279_ _11279_/Q clkload44/A _11279_/D _11279_/RESET_B VPWR VGND sg13cmos5l_dfrbpq_1
XFILLER_95_911 VPWR VGND sg13cmos5l_fill_1
XFILLER_48_882 VPWR VGND sg13cmos5l_fill_2
XFILLER_48_860 VPWR VGND sg13cmos5l_decap_8
XFILLER_75_690 VPWR VGND sg13cmos5l_decap_8
XFILLER_63_841 VPWR VGND sg13cmos5l_fill_2
X_10972__1010 _10972_/RESET_B VPWR VGND sg13cmos5l_tiehi
X_07510_ _07510_/Y _07530_/A _07509_/Y _07508_/Y VPWR VGND sg13cmos5l_o21ai_1
X_08490_ _08490_/Y _08490_/A _08498_/B VPWR VGND sg13cmos5l_nand2_1
X_07441_ _07441_/Y _07441_/A _07640_/B VPWR VGND sg13cmos5l_nor2_1
XFILLER_95_0 VPWR VGND sg13cmos5l_decap_8
XFILLER_50_557 VPWR VGND sg13cmos5l_decap_8
X_07372_ _07372_/Y _07371_/B _07370_/Y hold2540/X VPWR VGND sg13cmos5l_a21oi_1
XFILLER_22_259 VPWR VGND sg13cmos5l_decap_8
X_09111_ _09111_/Y _09120_/B _09111_/B VPWR VGND sg13cmos5l_xnor2_1
X_06323_ _06323_/Y _10597_/A _06322_/Y _06321_/Y VPWR VGND sg13cmos5l_o21ai_1
X_06254_ _10641_/A _11514_/Q _09246_/A VPWR VGND sg13cmos5l_nand2_1
X_09042_ _09042_/Y _09042_/A _09055_/B VPWR VGND sg13cmos5l_nand2_1
X_11399__1492 _11399_/RESET_B VPWR VGND sg13cmos5l_tiehi
X_11261__1640 _11261_/RESET_B VPWR VGND sg13cmos5l_tiehi
X_06185_ _06353_/C _07036_/A _06185_/B VPWR VGND sg13cmos5l_nand2_1
XFILLER_104_526 VPWR VGND sg13cmos5l_decap_8
XFILLER_104_559 VPWR VGND sg13cmos5l_decap_8
X_09944_ _09944_/Y _09944_/A _09944_/B VPWR VGND sg13cmos5l_nand2_1
X_09875_ _09875_/Y _10044_/A _09875_/B _09875_/C VPWR VGND sg13cmos5l_nor3_1
XFILLER_85_410 VPWR VGND sg13cmos5l_fill_1
XFILLER_38_15 VPWR VGND sg13cmos5l_decap_8
XFILLER_100_743 VPWR VGND sg13cmos5l_fill_2
XFILLER_58_657 VPWR VGND sg13cmos5l_decap_4
X_08826_ _08861_/A _11380_/Q _08827_/B VPWR VGND sg13cmos5l_nor2_1
XFILLER_85_454 VPWR VGND sg13cmos5l_decap_4
XFILLER_79_1018 VPWR VGND sg13cmos5l_fill_2
XFILLER_73_616 VPWR VGND sg13cmos5l_decap_4
XFILLER_58_679 VPWR VGND sg13cmos5l_fill_1
XFILLER_39_871 VPWR VGND sg13cmos5l_fill_1
XFILLER_72_126 VPWR VGND sg13cmos5l_fill_2
X_08757_ _11419_/D _08757_/A VPWR VGND sg13cmos5l_inv_1
XFILLER_66_690 VPWR VGND sg13cmos5l_decap_8
X_05969_ _05969_/Y _11321_/Q VPWR VGND sg13cmos5l_inv_1
X_07708_ _07708_/Y _07708_/A _07714_/B VPWR VGND sg13cmos5l_nor2_1
X_08688_ _11403_/D _08688_/A VPWR VGND sg13cmos5l_inv_1
X_07639_ _07639_/Y _07638_/A _08762_/B _07636_/Y _07638_/Y VPWR VGND sg13cmos5l_a22oi_1
XFILLER_54_896 VPWR VGND sg13cmos5l_fill_1
XFILLER_41_502 VPWR VGND sg13cmos5l_fill_1
X_10650_ _10653_/C _11421_/Q _10858_/Q VPWR VGND sg13cmos5l_xor2_1
XFILLER_41_546 VPWR VGND sg13cmos5l_decap_8
XFILLER_70_35 VPWR VGND sg13cmos5l_decap_8
X_09309_ _09309_/Y _10235_/B _10162_/A VPWR VGND sg13cmos5l_nand2_1
X_10581_ _10583_/C _10581_/A _10581_/B VPWR VGND sg13cmos5l_xnor2_1
XFILLER_6_937 VPWR VGND sg13cmos5l_fill_1
XFILLER_6_926 VPWR VGND sg13cmos5l_decap_8
X_11202_ _11202_/Q clkload52/A _11202_/D _11202_/RESET_B VPWR VGND sg13cmos5l_dfrbpq_1
XFILLER_79_66 VPWR VGND sg13cmos5l_fill_2
X_11133_ _11133_/Q clkload42/A _11133_/D _11133_/RESET_B VPWR VGND sg13cmos5l_dfrbpq_1
XFILLER_103_570 VPWR VGND sg13cmos5l_decap_4
XFILLER_95_21 VPWR VGND sg13cmos5l_decap_8
XFILLER_89_782 VPWR VGND sg13cmos5l_decap_4
XFILLER_1_664 VPWR VGND sg13cmos5l_decap_8
XFILLER_1_675 VPWR VGND sg13cmos5l_fill_1
X_11124__1777 _11124_/RESET_B VPWR VGND sg13cmos5l_tiehi
X_11064_ _11064_/Q _11349_/CLK _11064_/D _11064_/RESET_B VPWR VGND sg13cmos5l_dfrbpq_1
X_10015_ _10015_/Y _10919_/Q _10007_/B _10015_/B1 VPWR VGND sg13cmos5l_a21oi_1
XFILLER_76_421 VPWR VGND sg13cmos5l_fill_1
XFILLER_49_657 VPWR VGND sg13cmos5l_fill_2
XFILLER_49_646 VPWR VGND sg13cmos5l_decap_8
XFILLER_23_1028 VPWR VGND sg13cmos5l_fill_1
XFILLER_76_465 VPWR VGND sg13cmos5l_fill_1
XFILLER_48_167 VPWR VGND sg13cmos5l_fill_2
Xhold2390 _07566_/A _10908_/Q VPWR VGND sg13cmos5l_dlygate4sd3_1
XFILLER_91_446 VPWR VGND sg13cmos5l_decap_8
XFILLER_63_137 VPWR VGND sg13cmos5l_decap_4
XFILLER_63_104 VPWR VGND sg13cmos5l_fill_1
XFILLER_17_521 VPWR VGND sg13cmos5l_fill_1
XFILLER_63_159 VPWR VGND sg13cmos5l_fill_2
XFILLER_45_874 VPWR VGND sg13cmos5l_decap_8
XFILLER_45_852 VPWR VGND sg13cmos5l_decap_4
XFILLER_17_532 VPWR VGND sg13cmos5l_decap_8
XFILLER_60_833 VPWR VGND sg13cmos5l_fill_1
X_10917_ _10917_/Q _11355_/CLK _10917_/D _10917_/RESET_B VPWR VGND sg13cmos5l_dfrbpq_1
XFILLER_44_80 VPWR VGND sg13cmos5l_fill_1
X_10848_ _10848_/Q clkload36/A _10848_/D _10848_/RESET_B VPWR VGND sg13cmos5l_dfrbpq_1
XFILLER_32_579 VPWR VGND sg13cmos5l_fill_2
X_10779_ _10779_/Y _11696_/D _11697_/D _11698_/D _10779_/D VPWR VGND sg13cmos5l_nor4_1
XFILLER_40_590 VPWR VGND sg13cmos5l_decap_8
XFILLER_12_292 VPWR VGND sg13cmos5l_decap_8
XFILLER_5_970 VPWR VGND sg13cmos5l_fill_1
Xfanout209 _08155_/B _08145_/B VPWR VGND sg13cmos5l_buf_1
X_07990_ _11084_/D _08317_/A1 _08007_/B _07989_/Y VPWR VGND sg13cmos5l_a21oi_1
X_06941_ _06941_/Y _06931_/B _06940_/Y _06939_/Y VPWR VGND sg13cmos5l_o21ai_1
XFILLER_67_421 VPWR VGND sg13cmos5l_fill_2
XFILLER_39_112 VPWR VGND sg13cmos5l_decap_8
X_09660_ _09660_/Y _11354_/Q _09840_/S VPWR VGND sg13cmos5l_nand2_1
X_06872_ _06873_/D _11702_/Q _11685_/Q VPWR VGND sg13cmos5l_nand2b_1
X_08611_ _08625_/A _08611_/A _08611_/B _08611_/C VPWR VGND sg13cmos5l_nor3_1
XFILLER_55_627 VPWR VGND sg13cmos5l_decap_4
XFILLER_39_178 VPWR VGND sg13cmos5l_decap_8
X_10913__1069 _10913_/RESET_B VPWR VGND sg13cmos5l_tiehi
XFILLER_27_318 VPWR VGND sg13cmos5l_decap_4
X_09591_ _09591_/Y _09590_/A _09590_/B _09731_/A VPWR VGND sg13cmos5l_o21ai_1
X_08542_ _11355_/D fanout82/X _08563_/B _08541_/Y VPWR VGND sg13cmos5l_a21oi_1
XFILLER_54_159 VPWR VGND sg13cmos5l_fill_2
XFILLER_54_148 VPWR VGND sg13cmos5l_decap_8
X_11279__1622 _11279_/RESET_B VPWR VGND sg13cmos5l_tiehi
XFILLER_36_841 VPWR VGND sg13cmos5l_decap_8
XFILLER_35_373 VPWR VGND sg13cmos5l_fill_1
X_08473_ _11321_/D fanout98/X _08488_/B _08472_/Y VPWR VGND sg13cmos5l_o21ai_1
X_07424_ _07424_/Y _09268_/A _07430_/A2 _07423_/Y VPWR VGND sg13cmos5l_a21oi_1
XFILLER_63_693 VPWR VGND sg13cmos5l_fill_2
XFILLER_62_170 VPWR VGND sg13cmos5l_decap_8
XFILLER_51_866 VPWR VGND sg13cmos5l_decap_4
XFILLER_51_844 VPWR VGND sg13cmos5l_fill_1
XFILLER_10_207 VPWR VGND sg13cmos5l_fill_2
XFILLER_23_579 VPWR VGND sg13cmos5l_decap_8
XFILLER_31_590 VPWR VGND sg13cmos5l_decap_8
X_07355_ _07355_/Y _11538_/Q _08721_/A VPWR VGND sg13cmos5l_nand2_1
X_11202__1699 _11202_/RESET_B VPWR VGND sg13cmos5l_tiehi
X_06306_ _06306_/Y _06216_/A _10267_/C VPWR VGND sg13cmos5l_nand2b_1
X_07286_ _07286_/Y _09456_/A _07304_/A2 _07285_/Y VPWR VGND sg13cmos5l_a21oi_1
X_09025_ _09034_/B _09069_/A _09023_/Y VPWR VGND sg13cmos5l_nor2b_1
X_06237_ _06709_/B _10437_/A _10329_/A VPWR VGND sg13cmos5l_nor2_1
XFILLER_105_802 VPWR VGND sg13cmos5l_decap_8
X_06168_ _06649_/A _06168_/A _06650_/A VPWR VGND sg13cmos5l_nor2_1
X_06099_ _06103_/A _10881_/Q _10880_/Q _10874_/Q _07347_/A VPWR VGND sg13cmos5l_nor4_1
XFILLER_104_367 VPWR VGND sg13cmos5l_decap_8
X_09927_ _09927_/Y _11140_/Q _10012_/B _09932_/S1 VPWR VGND sg13cmos5l_a21oi_1
XFILLER_77_207 VPWR VGND sg13cmos5l_fill_2
Xfanout710 _10776_/A hold2898/X VPWR VGND sg13cmos5l_buf_1
Xfanout721 _07447_/S _11557_/Q VPWR VGND sg13cmos5l_buf_1
Xfanout732 _10250_/D _10426_/A1 VPWR VGND sg13cmos5l_buf_1
XFILLER_105_42 VPWR VGND sg13cmos5l_decap_8
Xfanout743 _09262_/A _10656_/A VPWR VGND sg13cmos5l_buf_1
XFILLER_58_443 VPWR VGND sg13cmos5l_decap_8
Xfanout754 _10479_/A _11478_/Q VPWR VGND sg13cmos5l_buf_1
Xfanout776 _09559_/A _11467_/Q VPWR VGND sg13cmos5l_buf_1
Xfanout765 _10295_/A _11474_/Q VPWR VGND sg13cmos5l_buf_1
XFILLER_86_774 VPWR VGND sg13cmos5l_fill_2
XFILLER_74_903 VPWR VGND sg13cmos5l_fill_2
XFILLER_65_13 VPWR VGND sg13cmos5l_fill_2
X_09858_ _09858_/Y _10562_/A _09911_/B _09857_/X _09858_/B2 VPWR VGND sg13cmos5l_a22oi_1
XFILLER_46_605 VPWR VGND sg13cmos5l_decap_8
Xfanout798 _10477_/A _11408_/Q VPWR VGND sg13cmos5l_buf_1
Xfanout787 _09346_/A hold2867/X VPWR VGND sg13cmos5l_buf_1
X_09789_ _09795_/B _09785_/Y _09786_/Y _09787_/Y _09788_/Y _10038_/C1 VPWR VGND sg13cmos5l_a221oi_1
X_08809_ _08809_/Y _08832_/A1 _08817_/C _08856_/B1 VPWR VGND sg13cmos5l_o21ai_1
XFILLER_39_690 VPWR VGND sg13cmos5l_decap_8
XFILLER_73_457 VPWR VGND sg13cmos5l_decap_4
X_11465__1341 _11465_/RESET_B VPWR VGND sg13cmos5l_tiehi
X_11518__1147 _11518_/RESET_B VPWR VGND sg13cmos5l_tiehi
X_11751_ _11751_/Q clkload24/A _11751_/D _11751_/RESET_B VPWR VGND sg13cmos5l_dfrbpq_1
XFILLER_61_619 VPWR VGND sg13cmos5l_fill_1
X_11024__901 _11024_/RESET_B VPWR VGND sg13cmos5l_tiehi
XFILLER_27_896 VPWR VGND sg13cmos5l_fill_2
XFILLER_92_1026 VPWR VGND sg13cmos5l_fill_2
X_10702_ _11552_/D _10700_/Y _10701_/Y _10691_/Y VPWR VGND sg13cmos5l_o21ai_1
XFILLER_53_170 VPWR VGND sg13cmos5l_fill_1
XFILLER_42_844 VPWR VGND sg13cmos5l_decap_4
X_11682_ _11682_/Q _11767_/CLK _11682_/D _11682_/RESET_B VPWR VGND sg13cmos5l_dfrbpq_1
X_10633_ _10633_/Y _10578_/B _10633_/B _10633_/C VPWR VGND sg13cmos5l_nand3b_1
X_10564_ _10564_/X _10566_/B _10564_/B VPWR VGND sg13cmos5l_xor2_1
X_10495_ _10495_/Y hold2933/X _10495_/A2 _10493_/Y _10494_/Y _10508_/B1 VPWR VGND
+ sg13cmos5l_a221oi_1
XFILLER_69_719 VPWR VGND sg13cmos5l_decap_4
XFILLER_69_708 VPWR VGND sg13cmos5l_fill_1
X_11357__1544 _11357_/RESET_B VPWR VGND sg13cmos5l_tiehi
XFILLER_7_1000 VPWR VGND sg13cmos5l_decap_8
XFILLER_2_962 VPWR VGND sg13cmos5l_decap_8
X_11116_ _11116_/Q _11352_/CLK _11116_/D _11116_/RESET_B VPWR VGND sg13cmos5l_dfrbpq_1
XFILLER_49_410 VPWR VGND sg13cmos5l_decap_4
XFILLER_1_483 VPWR VGND sg13cmos5l_decap_8
X_11047_ _11047_/Q _11364_/CLK _11047_/D _11047_/RESET_B VPWR VGND sg13cmos5l_dfrbpq_1
XFILLER_49_454 VPWR VGND sg13cmos5l_decap_8
XFILLER_92_722 VPWR VGND sg13cmos5l_fill_1
XFILLER_65_936 VPWR VGND sg13cmos5l_fill_1
Xinput9 input9/X ui_in[1] VPWR VGND sg13cmos5l_buf_1
XFILLER_49_498 VPWR VGND sg13cmos5l_decap_4
XFILLER_37_627 VPWR VGND sg13cmos5l_fill_1
XFILLER_92_777 VPWR VGND sg13cmos5l_fill_1
XFILLER_17_340 VPWR VGND sg13cmos5l_fill_2
XFILLER_92_788 VPWR VGND sg13cmos5l_decap_4
X_11572__1395 _11572_/RESET_B VPWR VGND sg13cmos5l_tiehi
XFILLER_52_619 VPWR VGND sg13cmos5l_decap_8
XFILLER_33_811 VPWR VGND sg13cmos5l_decap_4
Xclkbuf_leaf_71_clk clkload9/A clkbuf_4_0_0_clk/X VPWR VGND sg13cmos5l_buf_8
XFILLER_20_549 VPWR VGND sg13cmos5l_decap_4
X_07140_ _11735_/D _05887_/Y _07142_/A2 _07139_/Y VPWR VGND sg13cmos5l_a21oi_1
XFILLER_9_550 VPWR VGND sg13cmos5l_decap_8
X_07071_ _07071_/Y _07071_/A _07071_/B _10469_/C VPWR VGND sg13cmos5l_nand3_1
X_06022_ _06022_/Y _06022_/A _06022_/B VPWR VGND sg13cmos5l_nand2_1
XFILLER_102_816 VPWR VGND sg13cmos5l_decap_4
XFILLER_59_218 VPWR VGND sg13cmos5l_decap_8
X_07973_ _11076_/D fanout60/X _07978_/B _07972_/Y VPWR VGND sg13cmos5l_o21ai_1
XFILLER_59_229 VPWR VGND sg13cmos5l_fill_1
X_09712_ _09712_/Y _09715_/B1 _09708_/X _09711_/Y VPWR VGND sg13cmos5l_o21ai_1
XFILLER_19_28 VPWR VGND sg13cmos5l_fill_1
X_06924_ _06924_/Y _06924_/A _06933_/B VPWR VGND sg13cmos5l_nand2_1
XFILLER_28_605 VPWR VGND sg13cmos5l_fill_2
X_06855_ _06855_/Y _06855_/A _06861_/B VPWR VGND sg13cmos5l_nand2_1
XFILLER_83_733 VPWR VGND sg13cmos5l_decap_8
XFILLER_68_796 VPWR VGND sg13cmos5l_fill_2
X_09643_ _09724_/B _09643_/A _09668_/B VPWR VGND sg13cmos5l_nand2_1
XFILLER_55_446 VPWR VGND sg13cmos5l_fill_1
X_09574_ _09574_/Y _09574_/A1 _09568_/X _09574_/B1 VPWR VGND sg13cmos5l_a21oi_1
XFILLER_27_137 VPWR VGND sg13cmos5l_decap_4
X_06786_ _06786_/Y _10727_/A _10763_/S VPWR VGND sg13cmos5l_nand2_1
XFILLER_82_276 VPWR VGND sg13cmos5l_fill_1
XFILLER_64_991 VPWR VGND sg13cmos5l_decap_8
X_08525_ _08525_/Y _08525_/A _08527_/B VPWR VGND sg13cmos5l_nor2_1
XFILLER_35_38 VPWR VGND sg13cmos5l_fill_1
XFILLER_23_310 VPWR VGND sg13cmos5l_decap_8
XFILLER_23_332 VPWR VGND sg13cmos5l_decap_8
Xclkbuf_leaf_62_clk clkload38/A clkload3/A VPWR VGND sg13cmos5l_buf_8
X_11729__1222 _11729_/RESET_B VPWR VGND sg13cmos5l_tiehi
XFILLER_51_663 VPWR VGND sg13cmos5l_fill_1
XFILLER_50_140 VPWR VGND sg13cmos5l_fill_1
X_08456_ _08456_/Y _08456_/A _08466_/B VPWR VGND sg13cmos5l_nand2_1
XFILLER_23_354 VPWR VGND sg13cmos5l_decap_8
XFILLER_51_685 VPWR VGND sg13cmos5l_fill_2
XFILLER_50_184 VPWR VGND sg13cmos5l_fill_1
X_07407_ _07407_/Y _07407_/A _07407_/B VPWR VGND sg13cmos5l_nor2_1
X_08387_ _08387_/Y _08387_/A _08405_/B VPWR VGND sg13cmos5l_nor2_1
XFILLER_23_376 VPWR VGND sg13cmos5l_decap_4
X_07338_ _07338_/Y _08948_/A _07362_/B VPWR VGND sg13cmos5l_nand2_1
XFILLER_13_1027 VPWR VGND sg13cmos5l_fill_2
X_07269_ _07269_/Y _07269_/A _07359_/B VPWR VGND sg13cmos5l_nor2_1
XFILLER_105_621 VPWR VGND sg13cmos5l_decap_8
X_09008_ _09008_/Y _09018_/B _09008_/B VPWR VGND sg13cmos5l_xnor2_1
X_10280_ _10288_/A _10290_/A _10290_/B _10257_/Y VPWR VGND sg13cmos5l_a21oi_1
XFILLER_2_203 VPWR VGND sg13cmos5l_decap_8
XFILLER_78_516 VPWR VGND sg13cmos5l_fill_1
X_11761__922 _11761_/RESET_B VPWR VGND sg13cmos5l_tiehi
XFILLER_104_175 VPWR VGND sg13cmos5l_decap_8
Xfanout540 _08721_/A _08730_/A VPWR VGND sg13cmos5l_buf_1
Xfanout551 _06956_/B _07262_/A2 VPWR VGND sg13cmos5l_buf_1
Xfanout562 _10762_/S _07191_/A2 VPWR VGND sg13cmos5l_buf_1
Xfanout584 _06665_/B _06401_/B VPWR VGND sg13cmos5l_buf_1
Xfanout573 _06400_/D _06401_/D VPWR VGND sg13cmos5l_buf_1
XFILLER_74_722 VPWR VGND sg13cmos5l_decap_4
Xfanout595 _07130_/A2 _07108_/A2 VPWR VGND sg13cmos5l_buf_1
XFILLER_18_159 VPWR VGND sg13cmos5l_fill_1
XFILLER_15_833 VPWR VGND sg13cmos5l_fill_2
Xclkbuf_leaf_53_clk clkload40/A clkbuf_4_10_0_clk/X VPWR VGND sg13cmos5l_buf_8
X_11734_ _11734_/Q clkload14/A _11734_/D _11734_/RESET_B VPWR VGND sg13cmos5l_dfrbpq_1
XFILLER_26_192 VPWR VGND sg13cmos5l_fill_1
XFILLER_41_151 VPWR VGND sg13cmos5l_fill_2
X_11665_ _11665_/Q clkload7/A _11665_/D _11665_/RESET_B VPWR VGND sg13cmos5l_dfrbpq_1
Xclkbuf_4_6_0_clk clkbuf_4_6_0_clk/X clkbuf_0_clk/X VPWR VGND sg13cmos5l_buf_8
X_10616_ _10616_/Y _10685_/A _10616_/B _10616_/C VPWR VGND sg13cmos5l_nor3_1
X_11596_ _11596_/Q clkload29/A _11596_/D _11596_/RESET_B VPWR VGND sg13cmos5l_dfrbpq_1
XFILLER_6_520 VPWR VGND sg13cmos5l_decap_8
X_10547_ _10547_/Y _10479_/A _10547_/A2 _10546_/Y _10584_/A _10614_/C1 VPWR VGND sg13cmos5l_a221oi_1
XFILLER_6_553 VPWR VGND sg13cmos5l_fill_2
XFILLER_6_531 VPWR VGND sg13cmos5l_fill_2
XFILLER_51_7 VPWR VGND sg13cmos5l_fill_2
X_10478_ _10486_/B _10537_/A _10478_/B _10478_/C _10478_/D VPWR VGND sg13cmos5l_nand4_1
XFILLER_97_858 VPWR VGND sg13cmos5l_decap_4
XFILLER_49_240 VPWR VGND sg13cmos5l_decap_8
XFILLER_2_42 VPWR VGND sg13cmos5l_fill_1
XFILLER_77_593 VPWR VGND sg13cmos5l_fill_1
XFILLER_38_936 VPWR VGND sg13cmos5l_fill_2
XFILLER_38_925 VPWR VGND sg13cmos5l_fill_2
XFILLER_92_530 VPWR VGND sg13cmos5l_fill_1
X_06640_ _06642_/B _06640_/A _06640_/B VPWR VGND sg13cmos5l_nor2_1
XFILLER_53_928 VPWR VGND sg13cmos5l_decap_8
Xclkbuf_leaf_44_clk clkload47/A clkbuf_4_12_0_clk/X VPWR VGND sg13cmos5l_buf_8
XFILLER_52_427 VPWR VGND sg13cmos5l_fill_2
X_06571_ _06572_/B _06571_/A1 _11678_/Q _10888_/Q _06571_/B2 VPWR VGND sg13cmos5l_a22oi_1
X_09290_ _09290_/X _11145_/Q _11113_/Q _11081_/Q _11049_/Q _10034_/B _10046_/B1 VPWR
+ VGND sg13cmos5l_mux4_1
X_08310_ _11241_/D fanout50/X _08309_/B _08309_/Y VPWR VGND sg13cmos5l_a21oi_1
X_08241_ _11207_/D fanout54/X _08242_/B _08240_/Y VPWR VGND sg13cmos5l_o21ai_1
XANTENNA_14 fanout422/X VPWR VGND sg13cmos5l_antennanp
XFILLER_32_151 VPWR VGND sg13cmos5l_decap_8
XFILLER_32_173 VPWR VGND sg13cmos5l_fill_1
X_10845__1152 _10845_/RESET_B VPWR VGND sg13cmos5l_tiehi
X_11083__1818 _11083_/RESET_B VPWR VGND sg13cmos5l_tiehi
X_08172_ _11173_/D fanout58/X _08171_/B _08171_/Y VPWR VGND sg13cmos5l_a21oi_1
XFILLER_20_379 VPWR VGND sg13cmos5l_fill_1
XFILLER_21_18 VPWR VGND sg13cmos5l_fill_1
X_07123_ _07123_/Y hold2613/X _07130_/A2 _07155_/B1 VPWR VGND sg13cmos5l_o21ai_1
XFILLER_9_391 VPWR VGND sg13cmos5l_decap_4
X_11502__1179 _11502_/RESET_B VPWR VGND sg13cmos5l_tiehi
X_07054_ _07054_/X hold2519/X _07030_/B _07053_/Y VPWR VGND sg13cmos5l_a21o_1
X_06005_ _09283_/A _10704_/A _11758_/Q VPWR VGND sg13cmos5l_nand2b_1
XFILLER_99_151 VPWR VGND sg13cmos5l_decap_8
XFILLER_0_707 VPWR VGND sg13cmos5l_fill_1
XFILLER_102_646 VPWR VGND sg13cmos5l_fill_1
XFILLER_102_624 VPWR VGND sg13cmos5l_fill_2
XFILLER_101_112 VPWR VGND sg13cmos5l_decap_8
Xhold2901 hold2901/X _11744_/Q VPWR VGND sg13cmos5l_dlygate4sd3_1
Xhold2923 hold2923/X _11765_/Q VPWR VGND sg13cmos5l_dlygate4sd3_1
Xhold2912 _11470_/D _09619_/Y VPWR VGND sg13cmos5l_dlygate4sd3_1
Xhold2934 _10551_/B _10851_/Q VPWR VGND sg13cmos5l_dlygate4sd3_1
Xhold2945 _10536_/A _11412_/Q VPWR VGND sg13cmos5l_dlygate4sd3_1
X_07956_ _07956_/Y _07956_/A _07966_/B VPWR VGND sg13cmos5l_nand2_1
XFILLER_101_189 VPWR VGND sg13cmos5l_decap_8
XFILLER_68_571 VPWR VGND sg13cmos5l_decap_8
X_06907_ _06907_/Y _05944_/Y _06807_/Y _06906_/Y VPWR VGND sg13cmos5l_o21ai_1
XFILLER_46_48 VPWR VGND sg13cmos5l_decap_8
X_07887_ _07887_/Y _07887_/A _07893_/B VPWR VGND sg13cmos5l_nor2_1
XFILLER_102_21 VPWR VGND sg13cmos5l_decap_8
XFILLER_83_585 VPWR VGND sg13cmos5l_decap_4
X_06838_ _06838_/Y _06838_/A _06927_/B VPWR VGND sg13cmos5l_nand2_1
XFILLER_56_777 VPWR VGND sg13cmos5l_decap_8
XFILLER_55_265 VPWR VGND sg13cmos5l_decap_8
XFILLER_43_405 VPWR VGND sg13cmos5l_fill_1
X_09626_ _09626_/Y _10905_/Q _09733_/S _09735_/B1 VPWR VGND sg13cmos5l_a21oi_1
X_10810__947 _10810_/RESET_B VPWR VGND sg13cmos5l_tiehi
X_06769_ _06769_/Y _06261_/Y _06401_/D _06775_/B1 VPWR VGND sg13cmos5l_a21oi_1
X_09557_ _09558_/C _09557_/A _09668_/B VPWR VGND sg13cmos5l_nor2_1
X_08508_ _11338_/D _08508_/A1 _08559_/B _08507_/Y VPWR VGND sg13cmos5l_a21oi_1
Xclkbuf_leaf_35_clk clkload56/A clkload6/A VPWR VGND sg13cmos5l_buf_8
XFILLER_71_769 VPWR VGND sg13cmos5l_fill_2
XFILLER_62_25 VPWR VGND sg13cmos5l_fill_2
X_09488_ _09514_/C _09488_/A _09488_/B VPWR VGND sg13cmos5l_or2_1
XFILLER_102_98 VPWR VGND sg13cmos5l_decap_8
X_08439_ _08439_/Y _08439_/A _08439_/B VPWR VGND sg13cmos5l_nor2_1
XFILLER_51_471 VPWR VGND sg13cmos5l_decap_4
X_11021__904 _11021_/RESET_B VPWR VGND sg13cmos5l_tiehi
XFILLER_12_814 VPWR VGND sg13cmos5l_decap_8
X_11450_ _11450_/Q clkload53/A _11450_/D _11450_/RESET_B VPWR VGND sg13cmos5l_dfrbpq_1
X_11381_ _11381_/Q _11713_/CLK _11381_/D _11381_/RESET_B VPWR VGND sg13cmos5l_dfrbpq_1
X_10401_ _10419_/B _10453_/B _10402_/B VPWR VGND sg13cmos5l_or2_1
X_10332_ _10333_/A _11401_/Q _10838_/Q VPWR VGND sg13cmos5l_xor2_1
XFILLER_106_952 VPWR VGND sg13cmos5l_decap_8
XFILLER_11_62 VPWR VGND sg13cmos5l_decap_4
XFILLER_105_440 VPWR VGND sg13cmos5l_decap_8
X_10263_ _10265_/C _10242_/B _10267_/B _10267_/C _10267_/A VPWR VGND sg13cmos5l_a22oi_1
XFILLER_105_495 VPWR VGND sg13cmos5l_decap_8
XFILLER_105_473 VPWR VGND sg13cmos5l_decap_4
X_10194_ _10194_/X _10194_/A _10194_/B VPWR VGND sg13cmos5l_xor2_1
XFILLER_94_806 VPWR VGND sg13cmos5l_fill_2
XFILLER_66_519 VPWR VGND sg13cmos5l_fill_2
XFILLER_98_1010 VPWR VGND sg13cmos5l_decap_8
Xfanout381 _07249_/B1 _07169_/Y VPWR VGND sg13cmos5l_buf_1
Xfanout370 _09404_/B _09805_/A2 VPWR VGND sg13cmos5l_buf_1
XFILLER_4_1014 VPWR VGND sg13cmos5l_decap_8
Xfanout392 _06474_/A _06476_/A VPWR VGND sg13cmos5l_buf_1
XFILLER_47_766 VPWR VGND sg13cmos5l_fill_1
XFILLER_46_232 VPWR VGND sg13cmos5l_decap_8
XFILLER_19_457 VPWR VGND sg13cmos5l_fill_2
XFILLER_47_777 VPWR VGND sg13cmos5l_decap_8
XFILLER_28_980 VPWR VGND sg13cmos5l_decap_4
XFILLER_61_235 VPWR VGND sg13cmos5l_decap_8
XFILLER_15_630 VPWR VGND sg13cmos5l_decap_8
Xclkbuf_leaf_26_clk _11713_/CLK clkbuf_4_6_0_clk/X VPWR VGND sg13cmos5l_buf_8
XFILLER_61_257 VPWR VGND sg13cmos5l_decap_4
XFILLER_61_246 VPWR VGND sg13cmos5l_fill_2
XFILLER_43_961 VPWR VGND sg13cmos5l_decap_8
XFILLER_14_140 VPWR VGND sg13cmos5l_fill_1
XFILLER_30_600 VPWR VGND sg13cmos5l_decap_8
X_12766_ _12766_/X _12766_/A VPWR VGND sg13cmos5l_buf_1
X_11717_ _11717_/Q _11766_/CLK _11717_/D _11717_/RESET_B VPWR VGND sg13cmos5l_dfrbpq_1
XFILLER_14_195 VPWR VGND sg13cmos5l_fill_2
Xinput12 input12/X ui_in[4] VPWR VGND sg13cmos5l_buf_1
X_11648_ _11648_/Q clkload8/A _11648_/D _11648_/RESET_B VPWR VGND sg13cmos5l_dfrbpq_1
X_11579_ _11579_/Q _11646_/CLK _11579_/D _11579_/RESET_B VPWR VGND sg13cmos5l_dfrbpq_1
XFILLER_7_851 VPWR VGND sg13cmos5l_fill_1
XFILLER_11_891 VPWR VGND sg13cmos5l_decap_8
XFILLER_7_895 VPWR VGND sg13cmos5l_fill_2
XFILLER_96_121 VPWR VGND sg13cmos5l_decap_8
Xhold2219 _07780_/A _10983_/Q VPWR VGND sg13cmos5l_dlygate4sd3_1
XFILLER_69_324 VPWR VGND sg13cmos5l_fill_1
Xhold2208 _07488_/A _10897_/Q VPWR VGND sg13cmos5l_dlygate4sd3_1
X_11452__1377 _11452_/RESET_B VPWR VGND sg13cmos5l_tiehi
X_08790_ _08793_/A _11636_/Q _08817_/B VPWR VGND sg13cmos5l_nand2_1
X_07810_ _07810_/Y _07810_/A _07826_/B VPWR VGND sg13cmos5l_nand2_1
X_11746__1188 _11746_/RESET_B VPWR VGND sg13cmos5l_tiehi
XFILLER_38_711 VPWR VGND sg13cmos5l_decap_8
X_07741_ _10963_/D _08526_/A1 _07748_/B _07740_/Y VPWR VGND sg13cmos5l_a21oi_1
XFILLER_38_766 VPWR VGND sg13cmos5l_fill_1
XFILLER_37_265 VPWR VGND sg13cmos5l_fill_2
X_07672_ _07672_/Y _07672_/A _07676_/B VPWR VGND sg13cmos5l_nor2_1
XFILLER_52_202 VPWR VGND sg13cmos5l_fill_2
X_11137__1764 _11137_/RESET_B VPWR VGND sg13cmos5l_tiehi
X_09411_ _09411_/Y _09173_/X _09196_/X _09410_/Y VPWR VGND sg13cmos5l_o21ai_1
X_06623_ _10800_/D _06643_/B1 _06620_/Y _06622_/Y VPWR VGND sg13cmos5l_a21o_1
Xclkbuf_leaf_17_clk clkload26/A clkload1/A VPWR VGND sg13cmos5l_buf_8
XFILLER_52_268 VPWR VGND sg13cmos5l_fill_2
X_09342_ _09342_/Y _09339_/Y _09341_/Y _09354_/B VPWR VGND sg13cmos5l_a21oi_1
X_06554_ _06554_/Y _06554_/A _06554_/B VPWR VGND sg13cmos5l_nand2_1
XFILLER_34_972 VPWR VGND sg13cmos5l_decap_4
XFILLER_33_460 VPWR VGND sg13cmos5l_decap_8
XFILLER_34_994 VPWR VGND sg13cmos5l_fill_2
X_09273_ _09273_/Y _10006_/A _09273_/B _09273_/C VPWR VGND sg13cmos5l_nand3_1
X_06485_ _06507_/A _10162_/A _06087_/A _09858_/B2 VPWR VGND sg13cmos5l_a21oi_1
XFILLER_60_290 VPWR VGND sg13cmos5l_fill_2
X_08224_ _08224_/Y _08224_/A _08242_/B VPWR VGND sg13cmos5l_nand2_1
X_08155_ _08155_/Y _08155_/A _08155_/B VPWR VGND sg13cmos5l_nor2_1
XFILLER_20_176 VPWR VGND sg13cmos5l_fill_2
XFILLER_21_699 VPWR VGND sg13cmos5l_decap_8
X_07106_ _11718_/D _05888_/Y _07120_/A2 _07105_/Y VPWR VGND sg13cmos5l_a21oi_1
X_08086_ _08086_/Y _08086_/A _08096_/B VPWR VGND sg13cmos5l_nand2_1
XFILLER_106_259 VPWR VGND sg13cmos5l_decap_8
XFILLER_0_504 VPWR VGND sg13cmos5l_decap_8
X_07037_ _07037_/Y _11510_/Q _07036_/B _07036_/Y VPWR VGND sg13cmos5l_a21oi_1
XFILLER_103_933 VPWR VGND sg13cmos5l_decap_8
XFILLER_88_666 VPWR VGND sg13cmos5l_fill_2
XFILLER_76_817 VPWR VGND sg13cmos5l_fill_2
Xhold2731 _07196_/A _07194_/Y VPWR VGND sg13cmos5l_dlygate4sd3_1
Xhold2720 hold2720/X _11692_/Q VPWR VGND sg13cmos5l_dlygate4sd3_1
XFILLER_87_176 VPWR VGND sg13cmos5l_fill_1
Xhold2764 _06013_/B _06022_/B VPWR VGND sg13cmos5l_dlygate4sd3_1
XFILLER_75_327 VPWR VGND sg13cmos5l_fill_2
Xhold2753 hold2753/X _11745_/Q VPWR VGND sg13cmos5l_dlygate4sd3_1
Xhold2742 hold2742/X _11741_/Q VPWR VGND sg13cmos5l_dlygate4sd3_1
X_08988_ _08988_/Y _09030_/A1 _08981_/B _09013_/B1 VPWR VGND sg13cmos5l_o21ai_1
X_11556__1453 _11556_/RESET_B VPWR VGND sg13cmos5l_tiehi
Xhold2797 _06527_/A _06526_/Y VPWR VGND sg13cmos5l_dlygate4sd3_1
Xhold2775 hold2775/X _11397_/Q VPWR VGND sg13cmos5l_dlygate4sd3_1
Xheichips26_RiMaX_836 uio_oe[1] VPWR VGND sg13cmos5l_tielo
Xhold2786 hold2786/X _11402_/Q VPWR VGND sg13cmos5l_dlygate4sd3_1
X_07939_ _11059_/D _08331_/A1 _07946_/B _07938_/Y VPWR VGND sg13cmos5l_o21ai_1
XFILLER_28_221 VPWR VGND sg13cmos5l_decap_8
X_10950_ _10950_/Q clkload53/A _10950_/D _10950_/RESET_B VPWR VGND sg13cmos5l_dfrbpq_1
XFILLER_28_254 VPWR VGND sg13cmos5l_decap_8
XFILLER_71_533 VPWR VGND sg13cmos5l_fill_2
XFILLER_43_202 VPWR VGND sg13cmos5l_decap_8
X_09609_ _09610_/B _09693_/A1 _09604_/X _09608_/Y VPWR VGND sg13cmos5l_o21ai_1
X_10881_ _10881_/Q clkload11/A _10881_/D _10881_/RESET_B VPWR VGND sg13cmos5l_dfrbpq_1
XFILLER_28_298 VPWR VGND sg13cmos5l_decap_8
XFILLER_71_566 VPWR VGND sg13cmos5l_fill_1
XFILLER_43_257 VPWR VGND sg13cmos5l_fill_1
XFILLER_43_235 VPWR VGND sg13cmos5l_decap_8
XFILLER_12_644 VPWR VGND sg13cmos5l_decap_8
X_10926__1056 _10926_/RESET_B VPWR VGND sg13cmos5l_tiehi
XFILLER_40_975 VPWR VGND sg13cmos5l_fill_1
X_11502_ _11502_/Q clkload35/A _11502_/D _11502_/RESET_B VPWR VGND sg13cmos5l_dfrbpq_1
X_11433_ _11433_/Q _11528_/CLK _11433_/D _11433_/RESET_B VPWR VGND sg13cmos5l_dfrbpq_1
XFILLER_7_136 VPWR VGND sg13cmos5l_fill_1
XFILLER_98_21 VPWR VGND sg13cmos5l_decap_8
X_11364_ _11364_/Q _11364_/CLK _11364_/D _11364_/RESET_B VPWR VGND sg13cmos5l_dfrbpq_1
X_11295_ _11295_/Q clkload49/A _11295_/D _11295_/RESET_B VPWR VGND sg13cmos5l_dfrbpq_1
X_10315_ _10317_/C _11400_/Q _10837_/Q VPWR VGND sg13cmos5l_xnor2_1
XFILLER_4_876 VPWR VGND sg13cmos5l_fill_2
XFILLER_4_865 VPWR VGND sg13cmos5l_decap_8
XFILLER_3_353 VPWR VGND sg13cmos5l_decap_4
XFILLER_98_98 VPWR VGND sg13cmos5l_decap_8
X_10246_ _10285_/B _10247_/B _10254_/A VPWR VGND sg13cmos5l_nand2_1
X_11215__1686 _11215_/RESET_B VPWR VGND sg13cmos5l_tiehi
XFILLER_94_625 VPWR VGND sg13cmos5l_decap_4
X_10177_ _10177_/X _10177_/A _10830_/Q VPWR VGND sg13cmos5l_xor2_1
XFILLER_19_221 VPWR VGND sg13cmos5l_fill_1
XFILLER_35_736 VPWR VGND sg13cmos5l_fill_1
XFILLER_19_287 VPWR VGND sg13cmos5l_decap_4
XFILLER_34_202 VPWR VGND sg13cmos5l_decap_8
XFILLER_62_544 VPWR VGND sg13cmos5l_fill_1
XFILLER_16_950 VPWR VGND sg13cmos5l_decap_4
XFILLER_34_235 VPWR VGND sg13cmos5l_decap_4
XFILLER_34_257 VPWR VGND sg13cmos5l_decap_8
XFILLER_90_886 VPWR VGND sg13cmos5l_fill_2
X_06270_ _06271_/D _10620_/A _06407_/B _10597_/A _06761_/A VPWR VGND sg13cmos5l_nor4_1
XFILLER_31_997 VPWR VGND sg13cmos5l_decap_8
XFILLER_8_52 VPWR VGND sg13cmos5l_fill_2
XFILLER_7_670 VPWR VGND sg13cmos5l_decap_4
X_09960_ _09960_/Y _09989_/A _09960_/B _09960_/C VPWR VGND sg13cmos5l_nor3_1
Xclkbuf_leaf_6_clk clkload18/A clkload0/A VPWR VGND sg13cmos5l_buf_8
X_08911_ _08911_/Y _05945_/Y _08930_/A _08897_/A VPWR VGND sg13cmos5l_a21oi_1
XFILLER_40_0 VPWR VGND sg13cmos5l_fill_2
Xhold2027 _07844_/A _11014_/Q VPWR VGND sg13cmos5l_dlygate4sd3_1
X_09891_ _09891_/Y _09909_/A hold2920/X _09917_/A VPWR VGND sg13cmos5l_a21oi_1
Xhold2016 _08066_/A _11122_/Q VPWR VGND sg13cmos5l_dlygate4sd3_1
Xhold2005 _08054_/A _11116_/Q VPWR VGND sg13cmos5l_dlygate4sd3_1
XFILLER_100_936 VPWR VGND sg13cmos5l_decap_8
XFILLER_98_986 VPWR VGND sg13cmos5l_decap_4
XFILLER_85_603 VPWR VGND sg13cmos5l_fill_2
XFILLER_69_176 VPWR VGND sg13cmos5l_decap_4
X_08842_ _08842_/Y _08867_/A _08842_/B VPWR VGND sg13cmos5l_nor2_1
Xhold2049 _11652_/D _06968_/Y VPWR VGND sg13cmos5l_dlygate4sd3_1
Xhold2038 _07034_/A _11670_/Q VPWR VGND sg13cmos5l_dlygate4sd3_1
X_08773_ _11423_/D _08773_/A VPWR VGND sg13cmos5l_inv_1
X_05985_ _05985_/Y _11334_/Q VPWR VGND sg13cmos5l_inv_1
X_07724_ _07724_/Y _07724_/A _07780_/B VPWR VGND sg13cmos5l_nor2_1
XFILLER_72_319 VPWR VGND sg13cmos5l_fill_1
X_07655_ _07655_/Y _11561_/Q _07655_/B _07721_/A VPWR VGND sg13cmos5l_nor3_1
XFILLER_65_360 VPWR VGND sg13cmos5l_fill_1
XFILLER_53_555 VPWR VGND sg13cmos5l_decap_8
X_06606_ _06606_/Y _06610_/B _06722_/B VPWR VGND sg13cmos5l_nor2_1
X_07586_ _07586_/Y _07650_/A _08730_/B _07585_/Y VPWR VGND sg13cmos5l_o21ai_1
XFILLER_40_216 VPWR VGND sg13cmos5l_decap_8
XFILLER_25_268 VPWR VGND sg13cmos5l_decap_8
XFILLER_25_279 VPWR VGND sg13cmos5l_fill_1
X_09325_ _09325_/Y _09325_/A _09325_/B VPWR VGND sg13cmos5l_xnor2_1
XFILLER_40_227 VPWR VGND sg13cmos5l_fill_2
X_06537_ _06539_/A _10877_/Q _06571_/B2 _06531_/A _11651_/Q VPWR VGND sg13cmos5l_a22oi_1
X_09256_ _09256_/Y _09919_/B _09256_/B VPWR VGND sg13cmos5l_nor2_1
X_06468_ _06468_/Y _11084_/Q _06468_/B VPWR VGND sg13cmos5l_nand2_1
X_08207_ _11190_/D _08337_/A1 _08208_/B _08206_/Y VPWR VGND sg13cmos5l_o21ai_1
XFILLER_21_474 VPWR VGND sg13cmos5l_decap_8
XFILLER_21_485 VPWR VGND sg13cmos5l_fill_1
XFILLER_21_496 VPWR VGND sg13cmos5l_fill_2
X_06399_ _06399_/X _11619_/Q _11608_/Q VPWR VGND sg13cmos5l_or2_1
X_09187_ _09321_/B _10171_/A _09187_/B VPWR VGND sg13cmos5l_nand2_1
XFILLER_4_128 VPWR VGND sg13cmos5l_fill_1
X_08138_ _11156_/D _08333_/A1 _08141_/B _08137_/Y VPWR VGND sg13cmos5l_a21oi_1
X_08069_ _11123_/D _08331_/A1 _08076_/B _08068_/Y VPWR VGND sg13cmos5l_o21ai_1
X_11080_ _11080_/Q clkload51/A _11080_/D _11080_/RESET_B VPWR VGND sg13cmos5l_dfrbpq_1
XFILLER_1_824 VPWR VGND sg13cmos5l_decap_8
X_10100_ _11501_/D hold2839/X _10115_/A2 _10099_/Y VPWR VGND sg13cmos5l_a21o_1
X_10031_ _10032_/B _10031_/A _10031_/B _10031_/C VPWR VGND sg13cmos5l_nor3_1
XFILLER_88_463 VPWR VGND sg13cmos5l_fill_2
XFILLER_48_305 VPWR VGND sg13cmos5l_fill_1
X_10816__953 _10816_/RESET_B VPWR VGND sg13cmos5l_tiehi
XFILLER_102_284 VPWR VGND sg13cmos5l_fill_1
XFILLER_102_273 VPWR VGND sg13cmos5l_decap_8
XFILLER_88_496 VPWR VGND sg13cmos5l_fill_2
Xhold2583 hold2583/X _11571_/Q VPWR VGND sg13cmos5l_dlygate4sd3_1
Xhold2572 _07250_/B _07249_/Y VPWR VGND sg13cmos5l_dlygate4sd3_1
Xhold2561 hold2561/X _11626_/Q VPWR VGND sg13cmos5l_dlygate4sd3_1
Xhold2550 _06127_/B _11761_/Q VPWR VGND sg13cmos5l_dlygate4sd3_1
Xhold2594 _11568_/D _10750_/Y VPWR VGND sg13cmos5l_dlygate4sd3_1
XFILLER_75_179 VPWR VGND sg13cmos5l_decap_8
Xhold1871 _08948_/A _11439_/Q VPWR VGND sg13cmos5l_dlygate4sd3_1
Xhold1860 _08480_/A _11325_/Q VPWR VGND sg13cmos5l_dlygate4sd3_1
XFILLER_17_703 VPWR VGND sg13cmos5l_fill_2
XFILLER_95_1024 VPWR VGND sg13cmos5l_decap_4
Xhold1882 _08182_/A _11178_/Q VPWR VGND sg13cmos5l_dlygate4sd3_1
XFILLER_84_680 VPWR VGND sg13cmos5l_fill_1
XFILLER_44_500 VPWR VGND sg13cmos5l_fill_1
Xhold1893 _07940_/A _11060_/Q VPWR VGND sg13cmos5l_dlygate4sd3_1
XFILLER_16_213 VPWR VGND sg13cmos5l_decap_4
XFILLER_17_725 VPWR VGND sg13cmos5l_decap_8
XFILLER_29_596 VPWR VGND sg13cmos5l_decap_8
X_10933_ _10933_/Q clkload40/A _10933_/D _10933_/RESET_B VPWR VGND sg13cmos5l_dfrbpq_1
X_10864_ _10864_/Q clkload11/A _10864_/D _10864_/RESET_B VPWR VGND sg13cmos5l_dfrbpq_1
XFILLER_31_216 VPWR VGND sg13cmos5l_decap_8
XFILLER_32_739 VPWR VGND sg13cmos5l_decap_8
X_10795_ _10795_/Q clkload14/A _10795_/D _10795_/RESET_B VPWR VGND sg13cmos5l_dfrbpq_1
XFILLER_13_942 VPWR VGND sg13cmos5l_fill_1
XFILLER_9_924 VPWR VGND sg13cmos5l_decap_8
X_11416_ _11416_/Q clkload47/A _11416_/D _11416_/RESET_B VPWR VGND sg13cmos5l_dfrbpq_1
X_11347_ _11347_/Q _11347_/CLK _11347_/D _11347_/RESET_B VPWR VGND sg13cmos5l_dfrbpq_1
XFILLER_4_695 VPWR VGND sg13cmos5l_decap_8
XFILLER_4_684 VPWR VGND sg13cmos5l_fill_1
XFILLER_4_673 VPWR VGND sg13cmos5l_decap_8
XFILLER_3_172 VPWR VGND sg13cmos5l_decap_4
XFILLER_79_452 VPWR VGND sg13cmos5l_fill_1
XFILLER_79_430 VPWR VGND sg13cmos5l_decap_4
XFILLER_3_194 VPWR VGND sg13cmos5l_decap_8
X_11278_ _11278_/Q clkload16/A _11278_/D _11278_/RESET_B VPWR VGND sg13cmos5l_dfrbpq_1
XFILLER_79_474 VPWR VGND sg13cmos5l_decap_8
XFILLER_66_102 VPWR VGND sg13cmos5l_decap_8
X_10229_ _10317_/A _10229_/A _10836_/Q VPWR VGND sg13cmos5l_nand2_1
XFILLER_94_444 VPWR VGND sg13cmos5l_fill_2
XFILLER_58_90 VPWR VGND sg13cmos5l_decap_8
XFILLER_12_4 VPWR VGND sg13cmos5l_fill_2
XFILLER_95_989 VPWR VGND sg13cmos5l_decap_8
XFILLER_82_628 VPWR VGND sg13cmos5l_decap_4
XFILLER_47_360 VPWR VGND sg13cmos5l_fill_1
XFILLER_90_650 VPWR VGND sg13cmos5l_decap_4
X_07440_ _07440_/Y _08376_/C _07721_/A VPWR VGND sg13cmos5l_nor2_1
XFILLER_62_352 VPWR VGND sg13cmos5l_decap_4
XFILLER_50_525 VPWR VGND sg13cmos5l_decap_4
XFILLER_35_599 VPWR VGND sg13cmos5l_fill_2
XFILLER_22_216 VPWR VGND sg13cmos5l_fill_2
XFILLER_23_717 VPWR VGND sg13cmos5l_decap_8
XFILLER_23_739 VPWR VGND sg13cmos5l_decap_8
X_07371_ _07371_/Y _07371_/A _07371_/B VPWR VGND sg13cmos5l_nor2_1
XFILLER_88_0 VPWR VGND sg13cmos5l_decap_8
X_09110_ _09111_/B _09120_/A _09098_/Y _09094_/X VPWR VGND sg13cmos5l_a21oi_1
X_06322_ _06322_/Y _11511_/Q _06322_/B VPWR VGND sg13cmos5l_nand2b_1
X_09041_ _11445_/D _09039_/Y _09040_/Y _09032_/Y VPWR VGND sg13cmos5l_o21ai_1
XFILLER_31_783 VPWR VGND sg13cmos5l_decap_8
XFILLER_31_794 VPWR VGND sg13cmos5l_fill_1
X_06253_ _06328_/C _10658_/A _10642_/A VPWR VGND sg13cmos5l_nor2_1
X_06184_ _06351_/A _06184_/A _09456_/A VPWR VGND sg13cmos5l_nand2_1
XFILLER_89_238 VPWR VGND sg13cmos5l_decap_8
X_09943_ _09944_/B _10604_/A _09911_/B _09857_/B _09939_/Y _09942_/Y VPWR VGND sg13cmos5l_a221oi_1
X_09874_ _09875_/C _09870_/Y _09871_/Y _09872_/Y _09873_/Y _10038_/C1 VPWR VGND sg13cmos5l_a221oi_1
XFILLER_85_400 VPWR VGND sg13cmos5l_fill_2
XFILLER_58_625 VPWR VGND sg13cmos5l_fill_1
XFILLER_100_722 VPWR VGND sg13cmos5l_decap_8
XFILLER_85_422 VPWR VGND sg13cmos5l_fill_1
XFILLER_57_135 VPWR VGND sg13cmos5l_decap_8
X_08825_ _08825_/Y _08814_/Y _08816_/B _08812_/X VPWR VGND sg13cmos5l_a21oi_1
XFILLER_100_755 VPWR VGND sg13cmos5l_fill_2
XFILLER_45_308 VPWR VGND sg13cmos5l_decap_8
X_08756_ _08757_/A hold2762/X _09093_/B _09102_/B _09106_/B1 VPWR VGND sg13cmos5l_a22oi_1
X_05968_ _10456_/B _09218_/B VPWR VGND sg13cmos5l_inv_1
XFILLER_39_883 VPWR VGND sg13cmos5l_fill_2
XFILLER_38_371 VPWR VGND sg13cmos5l_decap_8
X_07707_ _10947_/D fanout62/X _07718_/B _07706_/Y VPWR VGND sg13cmos5l_a21oi_1
X_05899_ _09830_/A _09968_/A VPWR VGND sg13cmos5l_inv_1
XFILLER_54_853 VPWR VGND sg13cmos5l_fill_2
X_08687_ _08688_/A hold2827/X _08895_/B _08891_/A _08922_/A VPWR VGND sg13cmos5l_a22oi_1
XFILLER_81_683 VPWR VGND sg13cmos5l_decap_8
X_07638_ _07638_/Y _07638_/A _07638_/B VPWR VGND sg13cmos5l_nor2_1
XFILLER_26_588 VPWR VGND sg13cmos5l_fill_2
X_07569_ _07569_/Y _10513_/A _07575_/C _07650_/A VPWR VGND sg13cmos5l_o21ai_1
X_09308_ _09308_/Y _08584_/Y _09316_/B VPWR VGND sg13cmos5l_nand2b_1
XFILLER_103_1017 VPWR VGND sg13cmos5l_decap_8
X_10580_ _10585_/A _06322_/B _10656_/B _10614_/C1 VPWR VGND sg13cmos5l_a21oi_1
XFILLER_103_1028 VPWR VGND sg13cmos5l_fill_1
X_09239_ _09239_/X _09729_/A _09704_/A _09239_/C _09239_/D VPWR VGND sg13cmos5l_or4_1
XFILLER_5_404 VPWR VGND sg13cmos5l_fill_2
X_11201_ _11201_/Q _11265_/CLK _11201_/D _11201_/RESET_B VPWR VGND sg13cmos5l_dfrbpq_1
X_11132_ _11132_/Q _11356_/CLK _11132_/D _11132_/RESET_B VPWR VGND sg13cmos5l_dfrbpq_1
X_11454__1369 _11454_/RESET_B VPWR VGND sg13cmos5l_tiehi
X_11096__1805 _11096_/RESET_B VPWR VGND sg13cmos5l_tiehi
XFILLER_0_120 VPWR VGND sg13cmos5l_decap_8
XFILLER_77_934 VPWR VGND sg13cmos5l_fill_1
X_11063_ _11063_/Q clkload17/A _11063_/D _11063_/RESET_B VPWR VGND sg13cmos5l_dfrbpq_1
X_10014_ _10014_/Y _10951_/Q _10020_/B VPWR VGND sg13cmos5l_nand2_1
XFILLER_89_794 VPWR VGND sg13cmos5l_decap_8
XFILLER_0_197 VPWR VGND sg13cmos5l_fill_1
XFILLER_0_164 VPWR VGND sg13cmos5l_decap_4
XFILLER_23_1007 VPWR VGND sg13cmos5l_fill_1
XFILLER_91_403 VPWR VGND sg13cmos5l_fill_2
Xhold2380 _11570_/D _10752_/Y VPWR VGND sg13cmos5l_dlygate4sd3_1
XFILLER_36_308 VPWR VGND sg13cmos5l_decap_4
Xhold2391 _08553_/A _11361_/Q VPWR VGND sg13cmos5l_dlygate4sd3_1
XFILLER_64_639 VPWR VGND sg13cmos5l_fill_1
XFILLER_91_469 VPWR VGND sg13cmos5l_decap_8
XFILLER_72_650 VPWR VGND sg13cmos5l_decap_8
X_10916_ _10916_/Q _11339_/CLK _10916_/D _10916_/RESET_B VPWR VGND sg13cmos5l_dfrbpq_1
XFILLER_45_886 VPWR VGND sg13cmos5l_decap_8
XFILLER_44_363 VPWR VGND sg13cmos5l_decap_8
XFILLER_32_514 VPWR VGND sg13cmos5l_decap_8
X_10847_ _10847_/Q clkload36/A _10847_/D _10847_/RESET_B VPWR VGND sg13cmos5l_dfrbpq_1
XFILLER_13_750 VPWR VGND sg13cmos5l_fill_1
XFILLER_81_7 VPWR VGND sg13cmos5l_decap_8
X_10778_ _11589_/D _06913_/B _10777_/Y _10776_/Y VPWR VGND sg13cmos5l_o21ai_1
XFILLER_60_91 VPWR VGND sg13cmos5l_decap_8
XFILLER_8_297 VPWR VGND sg13cmos5l_decap_8
XFILLER_5_42 VPWR VGND sg13cmos5l_fill_1
XFILLER_99_547 VPWR VGND sg13cmos5l_fill_2
X_06940_ _06940_/Y _08621_/B _06943_/B _11688_/D _06940_/D VPWR VGND sg13cmos5l_nand4_1
XFILLER_68_912 VPWR VGND sg13cmos5l_fill_2
X_11558__1445 _11558_/RESET_B VPWR VGND sg13cmos5l_tiehi
XFILLER_68_956 VPWR VGND sg13cmos5l_decap_8
X_06871_ _06873_/C _11691_/Q _11699_/Q _11700_/Q _11701_/Q VPWR VGND sg13cmos5l_or4_1
X_08610_ _08611_/C _11554_/Q _08614_/B _08616_/A VPWR VGND sg13cmos5l_nand3b_1
XFILLER_39_135 VPWR VGND sg13cmos5l_decap_8
X_10921__1061 _10921_/RESET_B VPWR VGND sg13cmos5l_tiehi
X_09590_ _09620_/B _09590_/A _09590_/B VPWR VGND sg13cmos5l_nand2_1
X_08541_ _08541_/Y _08541_/A _08563_/B VPWR VGND sg13cmos5l_nor2_1
XFILLER_47_190 VPWR VGND sg13cmos5l_fill_2
XFILLER_39_1014 VPWR VGND sg13cmos5l_decap_8
X_08472_ _08472_/Y _08472_/A _08488_/B VPWR VGND sg13cmos5l_nand2_1
X_07423_ _07423_/Y _07421_/Y _08767_/A _07429_/B1 VPWR VGND sg13cmos5l_a21oi_1
XFILLER_62_182 VPWR VGND sg13cmos5l_decap_8
XFILLER_50_311 VPWR VGND sg13cmos5l_fill_1
XFILLER_35_385 VPWR VGND sg13cmos5l_decap_8
XFILLER_23_536 VPWR VGND sg13cmos5l_decap_8
XFILLER_11_709 VPWR VGND sg13cmos5l_decap_8
XFILLER_23_558 VPWR VGND sg13cmos5l_decap_8
X_11174__1727 _11174_/RESET_B VPWR VGND sg13cmos5l_tiehi
XFILLER_10_219 VPWR VGND sg13cmos5l_decap_8
X_07354_ _10876_/D _07365_/B _07352_/Y _07353_/Y VPWR VGND sg13cmos5l_a21oi_1
X_11210__1691 _11210_/RESET_B VPWR VGND sg13cmos5l_tiehi
X_07285_ _07285_/Y _07283_/Y _07284_/Y _07304_/A2 VPWR VGND sg13cmos5l_a21oi_1
X_06305_ _06305_/Y _10267_/A _10242_/B VPWR VGND sg13cmos5l_nand2b_1
X_09024_ _09024_/Y _09023_/Y _09069_/A VPWR VGND sg13cmos5l_nand2b_1
X_06236_ _10329_/A _06236_/A _09557_/A VPWR VGND sg13cmos5l_and2_1
X_06167_ _06650_/A _11497_/Q _09202_/A VPWR VGND sg13cmos5l_nor2_1
XFILLER_105_869 VPWR VGND sg13cmos5l_decap_8
X_06098_ _11767_/D _06098_/A VPWR VGND sg13cmos5l_inv_1
Xfanout700 _06662_/A _11615_/Q VPWR VGND sg13cmos5l_buf_1
X_09926_ _09926_/Y _11108_/Q _09934_/B VPWR VGND sg13cmos5l_nand2_1
XFILLER_59_923 VPWR VGND sg13cmos5l_fill_1
Xfanout711 _08955_/A _07225_/A1 VPWR VGND sg13cmos5l_buf_1
Xfanout733 _10426_/A1 _06216_/A VPWR VGND sg13cmos5l_buf_1
Xfanout722 _07582_/S _07651_/S VPWR VGND sg13cmos5l_buf_1
XFILLER_105_21 VPWR VGND sg13cmos5l_decap_8
Xfanout744 _09264_/A _06330_/B VPWR VGND sg13cmos5l_buf_1
Xfanout755 _10242_/B _11477_/Q VPWR VGND sg13cmos5l_buf_1
Xfanout766 _09721_/A _10462_/A VPWR VGND sg13cmos5l_buf_1
XFILLER_74_915 VPWR VGND sg13cmos5l_fill_2
X_11511__1161 _11511_/RESET_B VPWR VGND sg13cmos5l_tiehi
X_09857_ _09857_/X _09857_/A _09857_/B VPWR VGND sg13cmos5l_and2_1
Xfanout799 _10229_/A hold2916/X VPWR VGND sg13cmos5l_buf_1
Xfanout788 _09189_/A _11458_/Q VPWR VGND sg13cmos5l_buf_1
Xfanout777 _09202_/A hold2884/X VPWR VGND sg13cmos5l_buf_1
XFILLER_105_98 VPWR VGND sg13cmos5l_decap_8
X_09788_ _09788_/Y _11039_/Q _09814_/S _09987_/B1 VPWR VGND sg13cmos5l_a21oi_1
XFILLER_58_488 VPWR VGND sg13cmos5l_decap_4
X_08808_ _08808_/Y _08819_/A _08805_/X _08807_/Y VPWR VGND sg13cmos5l_a21oi_1
XFILLER_46_628 VPWR VGND sg13cmos5l_fill_2
X_08739_ _08740_/A _10562_/A _08739_/A2 _09068_/A _08739_/B2 VPWR VGND sg13cmos5l_a22oi_1
XFILLER_82_970 VPWR VGND sg13cmos5l_fill_2
X_11750_ _11750_/Q clkload24/A _11750_/D _11750_/RESET_B VPWR VGND sg13cmos5l_dfrbpq_1
XFILLER_42_801 VPWR VGND sg13cmos5l_decap_8
X_10701_ _10701_/Y hold2756/X _10695_/Y _10686_/X VPWR VGND sg13cmos5l_o21ai_1
XFILLER_26_396 VPWR VGND sg13cmos5l_fill_2
XFILLER_81_68 VPWR VGND sg13cmos5l_decap_8
X_11681_ _11681_/Q _11767_/CLK _11681_/D _11681_/RESET_B VPWR VGND sg13cmos5l_dfrbpq_1
X_10632_ _10633_/C _10632_/A _10632_/B VPWR VGND sg13cmos5l_nor2_1
X_10563_ _10564_/B _10566_/A _10553_/Y hold2943/X VPWR VGND sg13cmos5l_a21oi_1
XFILLER_10_742 VPWR VGND sg13cmos5l_fill_1
X_10494_ _10494_/Y _10525_/A _10483_/B _10494_/B1 VPWR VGND sg13cmos5l_a21oi_1
XFILLER_5_223 VPWR VGND sg13cmos5l_decap_8
X_10963__1019 _10963_/RESET_B VPWR VGND sg13cmos5l_tiehi
XFILLER_2_941 VPWR VGND sg13cmos5l_decap_8
X_11115_ _11115_/Q clkload32/A _11115_/D _11115_/RESET_B VPWR VGND sg13cmos5l_dfrbpq_1
XFILLER_104_880 VPWR VGND sg13cmos5l_decap_8
XFILLER_89_591 VPWR VGND sg13cmos5l_fill_2
X_11046_ _11046_/Q clkload53/A _11046_/D _11046_/RESET_B VPWR VGND sg13cmos5l_dfrbpq_1
XFILLER_37_639 VPWR VGND sg13cmos5l_fill_1
X_11252__1649 _11252_/RESET_B VPWR VGND sg13cmos5l_tiehi
XFILLER_80_907 VPWR VGND sg13cmos5l_fill_2
XFILLER_18_842 VPWR VGND sg13cmos5l_fill_1
XFILLER_73_981 VPWR VGND sg13cmos5l_decap_8
XFILLER_17_352 VPWR VGND sg13cmos5l_fill_2
XFILLER_17_363 VPWR VGND sg13cmos5l_decap_8
XFILLER_72_491 VPWR VGND sg13cmos5l_decap_8
XFILLER_45_683 VPWR VGND sg13cmos5l_fill_1
XFILLER_60_686 VPWR VGND sg13cmos5l_decap_4
XFILLER_32_399 VPWR VGND sg13cmos5l_fill_2
X_07070_ _07070_/Y _07070_/A _07389_/B VPWR VGND sg13cmos5l_nor2_1
X_06021_ _06021_/Y _06021_/A _06021_/B _06021_/C VPWR VGND sg13cmos5l_nand3_1
X_10939__1043 _10939_/RESET_B VPWR VGND sg13cmos5l_tiehi
X_07972_ _07972_/Y _07972_/A _07978_/B VPWR VGND sg13cmos5l_nand2_1
XFILLER_68_731 VPWR VGND sg13cmos5l_fill_1
X_09711_ _09711_/Y _09709_/Y _09710_/Y _09846_/A1 VPWR VGND sg13cmos5l_a21oi_1
X_06923_ _11638_/D hold2791/X _06790_/A _10776_/B VPWR VGND sg13cmos5l_mux2_1
XFILLER_68_753 VPWR VGND sg13cmos5l_decap_4
X_06854_ _06854_/Y _06798_/Y _06851_/Y _06853_/Y VPWR VGND sg13cmos5l_o21ai_1
XFILLER_83_712 VPWR VGND sg13cmos5l_decap_8
X_09642_ _09647_/C _09884_/A _09642_/B _09722_/B VPWR VGND sg13cmos5l_nor3_1
X_06785_ _11596_/D hold2662/X _10785_/B _06782_/Y VPWR VGND sg13cmos5l_a21o_1
X_09573_ _09573_/Y _09573_/A1 _09569_/X _09572_/Y VPWR VGND sg13cmos5l_o21ai_1
X_11228__1673 _11228_/RESET_B VPWR VGND sg13cmos5l_tiehi
X_08524_ _11346_/D _08524_/A1 _08527_/B _08523_/Y VPWR VGND sg13cmos5l_a21oi_1
XFILLER_70_428 VPWR VGND sg13cmos5l_fill_2
XFILLER_51_620 VPWR VGND sg13cmos5l_decap_4
XFILLER_35_160 VPWR VGND sg13cmos5l_fill_2
XFILLER_51_653 VPWR VGND sg13cmos5l_fill_2
X_08455_ _11312_/D _08520_/A1 _08468_/B _08454_/Y VPWR VGND sg13cmos5l_o21ai_1
X_07406_ _07406_/Y _09246_/A _07429_/B1 _07405_/Y VPWR VGND sg13cmos5l_a21oi_1
X_08386_ _11278_/D _08516_/A1 _08397_/B _08385_/Y VPWR VGND sg13cmos5l_a21oi_1
XFILLER_13_1006 VPWR VGND sg13cmos5l_decap_8
X_07337_ _07337_/Y _11535_/Q _08730_/A VPWR VGND sg13cmos5l_nand2_1
X_07268_ _07268_/Y _09354_/A _06956_/B _07267_/Y VPWR VGND sg13cmos5l_a21oi_1
XFILLER_105_600 VPWR VGND sg13cmos5l_decap_8
X_07199_ _07200_/B _10837_/Q _06927_/B _07185_/X _07197_/X VPWR VGND sg13cmos5l_a22oi_1
X_09007_ _09008_/B _09020_/A _09007_/B VPWR VGND sg13cmos5l_nand2_1
X_06219_ _06223_/A _10267_/A _10242_/B VPWR VGND sg13cmos5l_or2_1
XFILLER_105_677 VPWR VGND sg13cmos5l_decap_8
XFILLER_104_154 VPWR VGND sg13cmos5l_decap_8
X_11639__1327 _11639_/RESET_B VPWR VGND sg13cmos5l_tiehi
XFILLER_78_539 VPWR VGND sg13cmos5l_decap_4
Xfanout530 _07296_/B _08651_/B VPWR VGND sg13cmos5l_buf_1
Xfanout541 _08730_/A _07251_/X VPWR VGND sg13cmos5l_buf_1
Xfanout563 _10763_/S _06933_/B VPWR VGND sg13cmos5l_buf_1
XFILLER_76_46 VPWR VGND sg13cmos5l_decap_4
X_09909_ _09909_/Y _09909_/A _09970_/B VPWR VGND sg13cmos5l_nor2_1
Xfanout552 _07304_/A2 _07262_/A2 VPWR VGND sg13cmos5l_buf_1
Xfanout574 _06732_/B _06758_/B1 VPWR VGND sg13cmos5l_buf_1
Xfanout585 _06444_/C _06401_/B VPWR VGND sg13cmos5l_buf_1
Xfanout596 _07126_/A2 _07108_/A2 VPWR VGND sg13cmos5l_buf_1
XFILLER_59_797 VPWR VGND sg13cmos5l_fill_1
XFILLER_74_745 VPWR VGND sg13cmos5l_decap_8
XFILLER_62_918 VPWR VGND sg13cmos5l_decap_4
XFILLER_61_406 VPWR VGND sg13cmos5l_decap_8
XFILLER_92_67 VPWR VGND sg13cmos5l_fill_1
XFILLER_92_56 VPWR VGND sg13cmos5l_decap_8
XFILLER_55_992 VPWR VGND sg13cmos5l_fill_2
XFILLER_26_171 VPWR VGND sg13cmos5l_decap_4
X_11733_ _11733_/Q _11766_/CLK _11733_/D _11733_/RESET_B VPWR VGND sg13cmos5l_dfrbpq_1
XFILLER_42_664 VPWR VGND sg13cmos5l_fill_1
XFILLER_30_804 VPWR VGND sg13cmos5l_decap_4
X_11664_ _11664_/Q clkload8/A _11664_/D _11664_/RESET_B VPWR VGND sg13cmos5l_dfrbpq_1
XFILLER_30_815 VPWR VGND sg13cmos5l_decap_8
X_10615_ _10616_/C _05879_/A _10675_/B fanout85/X VPWR VGND sg13cmos5l_a21oi_1
XFILLER_41_196 VPWR VGND sg13cmos5l_fill_2
X_11595_ _11595_/Q _11622_/CLK _11595_/D _11595_/RESET_B VPWR VGND sg13cmos5l_dfrbpq_1
X_11575__1389 _11575_/RESET_B VPWR VGND sg13cmos5l_tiehi
X_10546_ _10546_/Y _10407_/A _10539_/B _10545_/Y VPWR VGND sg13cmos5l_o21ai_1
X_10477_ _10478_/D _10477_/A _10845_/Q _10569_/A VPWR VGND sg13cmos5l_nand3_1
X_11306__1595 _11306_/RESET_B VPWR VGND sg13cmos5l_tiehi
XFILLER_69_517 VPWR VGND sg13cmos5l_decap_8
XFILLER_69_506 VPWR VGND sg13cmos5l_fill_1
XFILLER_69_528 VPWR VGND sg13cmos5l_fill_1
XFILLER_96_347 VPWR VGND sg13cmos5l_decap_4
XFILLER_2_21 VPWR VGND sg13cmos5l_decap_8
XFILLER_65_723 VPWR VGND sg13cmos5l_decap_8
X_11029_ _11029_/Q _11349_/CLK _11029_/D _11029_/RESET_B VPWR VGND sg13cmos5l_dfrbpq_1
XFILLER_66_90 VPWR VGND sg13cmos5l_decap_8
XFILLER_65_756 VPWR VGND sg13cmos5l_decap_8
XFILLER_65_734 VPWR VGND sg13cmos5l_fill_2
XFILLER_37_425 VPWR VGND sg13cmos5l_fill_1
XFILLER_2_98 VPWR VGND sg13cmos5l_fill_2
XFILLER_92_575 VPWR VGND sg13cmos5l_fill_2
XFILLER_75_1000 VPWR VGND sg13cmos5l_fill_2
XFILLER_64_277 VPWR VGND sg13cmos5l_fill_2
XFILLER_52_406 VPWR VGND sg13cmos5l_decap_8
XFILLER_25_609 VPWR VGND sg13cmos5l_decap_8
XFILLER_92_597 VPWR VGND sg13cmos5l_fill_1
XFILLER_80_748 VPWR VGND sg13cmos5l_decap_4
X_06570_ _06572_/A _06531_/A _11662_/Q _10872_/Q _06574_/B2 VPWR VGND sg13cmos5l_a22oi_1
XFILLER_33_620 VPWR VGND sg13cmos5l_fill_1
XFILLER_33_631 VPWR VGND sg13cmos5l_fill_1
XFILLER_61_962 VPWR VGND sg13cmos5l_decap_8
XFILLER_21_804 VPWR VGND sg13cmos5l_fill_1
XFILLER_32_141 VPWR VGND sg13cmos5l_fill_1
X_08240_ _08240_/Y _08240_/A _08242_/B VPWR VGND sg13cmos5l_nand2_1
XFILLER_21_826 VPWR VGND sg13cmos5l_fill_2
XFILLER_32_163 VPWR VGND sg13cmos5l_fill_1
X_08171_ _08171_/Y _08171_/A _08171_/B VPWR VGND sg13cmos5l_nor2_1
XANTENNA_15 fanout422/X VPWR VGND sg13cmos5l_antennanp
X_07122_ _11726_/D _05880_/Y _07122_/A2 _07121_/Y VPWR VGND sg13cmos5l_a21oi_1
X_11091__1810 _11091_/RESET_B VPWR VGND sg13cmos5l_tiehi
X_07053_ _07053_/Y _06990_/Y _07052_/Y _07062_/S VPWR VGND sg13cmos5l_a21oi_1
X_06004_ _10704_/A _11551_/Q _06066_/C _08611_/A VPWR VGND sg13cmos5l_a21oi_1
XFILLER_99_130 VPWR VGND sg13cmos5l_decap_8
XFILLER_88_815 VPWR VGND sg13cmos5l_fill_1
XFILLER_87_303 VPWR VGND sg13cmos5l_fill_1
XFILLER_82_1004 VPWR VGND sg13cmos5l_fill_1
XFILLER_99_174 VPWR VGND sg13cmos5l_fill_1
XFILLER_88_848 VPWR VGND sg13cmos5l_decap_8
X_11592__1415 _11592_/RESET_B VPWR VGND sg13cmos5l_tiehi
Xhold2902 _06194_/A _11488_/Q VPWR VGND sg13cmos5l_dlygate4sd3_1
Xhold2913 _10447_/A _11407_/Q VPWR VGND sg13cmos5l_dlygate4sd3_1
Xhold2946 _09268_/B _10859_/Q VPWR VGND sg13cmos5l_dlygate4sd3_1
X_07955_ _11067_/D fanout83/X _07974_/B _07954_/Y VPWR VGND sg13cmos5l_o21ai_1
Xhold2924 _09187_/B _11637_/Q VPWR VGND sg13cmos5l_dlygate4sd3_1
Xhold2935 hold2935/X _09171_/B VPWR VGND sg13cmos5l_dlygate4sd3_1
XFILLER_101_168 VPWR VGND sg13cmos5l_decap_8
XFILLER_96_892 VPWR VGND sg13cmos5l_decap_8
X_06906_ _06906_/Y _11637_/Q _07182_/C1 _07185_/A _06905_/X VPWR VGND sg13cmos5l_a22oi_1
XFILLER_95_380 VPWR VGND sg13cmos5l_decap_4
XFILLER_46_27 VPWR VGND sg13cmos5l_fill_1
X_07886_ _11033_/D fanout99/X _07893_/B _07885_/Y VPWR VGND sg13cmos5l_a21oi_1
X_09625_ _09625_/Y _10937_/Q _09630_/B VPWR VGND sg13cmos5l_nand2_1
XFILLER_83_553 VPWR VGND sg13cmos5l_fill_1
X_06837_ _11612_/D _06837_/A VPWR VGND sg13cmos5l_inv_1
XFILLER_71_737 VPWR VGND sg13cmos5l_decap_4
X_06768_ _06768_/Y _10597_/A _06768_/B VPWR VGND sg13cmos5l_xnor2_1
X_09556_ _09556_/Y _09693_/A1 _09551_/X _09555_/Y VPWR VGND sg13cmos5l_o21ai_1
XFILLER_102_77 VPWR VGND sg13cmos5l_decap_8
X_08507_ _08507_/Y _08507_/A _08559_/B VPWR VGND sg13cmos5l_nor2_1
X_06699_ _10810_/D _06744_/A1 _06698_/Y _06696_/Y VPWR VGND sg13cmos5l_o21ai_1
XFILLER_24_631 VPWR VGND sg13cmos5l_decap_4
X_09487_ _09488_/B _09208_/B _09487_/B VPWR VGND sg13cmos5l_nand2b_1
X_08438_ _11304_/D fanout51/X _08439_/B _08437_/Y VPWR VGND sg13cmos5l_a21oi_1
XFILLER_51_483 VPWR VGND sg13cmos5l_decap_4
XFILLER_23_152 VPWR VGND sg13cmos5l_fill_1
XFILLER_11_347 VPWR VGND sg13cmos5l_fill_2
X_08369_ _11270_/D fanout55/X _08368_/B _08368_/Y VPWR VGND sg13cmos5l_o21ai_1
XFILLER_7_307 VPWR VGND sg13cmos5l_fill_1
X_11380_ _11380_/Q clkload21/A _11380_/D _11380_/RESET_B VPWR VGND sg13cmos5l_dfrbpq_1
X_10400_ _10402_/B _11404_/Q _10841_/Q _10384_/Y VPWR VGND sg13cmos5l_a21oi_1
X_10331_ _10378_/A _10331_/A _10331_/B VPWR VGND sg13cmos5l_nor2_1
XFILLER_106_931 VPWR VGND sg13cmos5l_decap_8
X_10262_ _10265_/B _10285_/A _10267_/D VPWR VGND sg13cmos5l_nand2_1
XFILLER_3_557 VPWR VGND sg13cmos5l_decap_4
X_10880__1102 _10880_/RESET_B VPWR VGND sg13cmos5l_tiehi
X_10193_ _10194_/B _10187_/A _10187_/B _10184_/X VPWR VGND sg13cmos5l_a21oi_1
XFILLER_87_892 VPWR VGND sg13cmos5l_fill_2
Xfanout393 _10038_/C1 _06476_/A VPWR VGND sg13cmos5l_buf_1
Xfanout382 _07225_/C1 _07166_/X VPWR VGND sg13cmos5l_buf_1
Xfanout360 _10226_/C1 _10707_/C VPWR VGND sg13cmos5l_buf_1
XFILLER_47_712 VPWR VGND sg13cmos5l_decap_8
Xfanout371 _09725_/B _09805_/A2 VPWR VGND sg13cmos5l_buf_1
XFILLER_101_691 VPWR VGND sg13cmos5l_fill_2
XFILLER_93_339 VPWR VGND sg13cmos5l_fill_2
XFILLER_86_391 VPWR VGND sg13cmos5l_fill_1
XFILLER_74_531 VPWR VGND sg13cmos5l_fill_2
XFILLER_47_734 VPWR VGND sg13cmos5l_decap_4
XFILLER_59_1028 VPWR VGND sg13cmos5l_fill_1
XFILLER_59_1006 VPWR VGND sg13cmos5l_fill_2
XFILLER_74_586 VPWR VGND sg13cmos5l_fill_1
XFILLER_43_951 VPWR VGND sg13cmos5l_fill_2
XFILLER_27_491 VPWR VGND sg13cmos5l_fill_1
X_12765_ _12765_/X _12765_/A VPWR VGND sg13cmos5l_buf_1
X_11716_ _11716_/Q _11766_/CLK _11716_/D _11716_/RESET_B VPWR VGND sg13cmos5l_dfrbpq_1
XFILLER_42_450 VPWR VGND sg13cmos5l_fill_1
XFILLER_30_623 VPWR VGND sg13cmos5l_fill_1
Xinput13 input13/X ui_in[5] VPWR VGND sg13cmos5l_buf_1
X_11647_ _12767_/A _11767_/CLK _11647_/D _11647_/RESET_B VPWR VGND sg13cmos5l_dfrbpq_1
X_11578_ _11578_/Q clkload26/A _11578_/D _11578_/RESET_B VPWR VGND sg13cmos5l_dfrbpq_1
X_11768__929 _11768_/RESET_B VPWR VGND sg13cmos5l_tiehi
XFILLER_7_841 VPWR VGND sg13cmos5l_fill_2
X_10529_ _10529_/X _10526_/Y _10527_/Y _10560_/A VPWR VGND sg13cmos5l_a21o_1
XFILLER_42_4 VPWR VGND sg13cmos5l_fill_1
XFILLER_97_634 VPWR VGND sg13cmos5l_decap_4
Xhold2209 _08247_/A _11210_/Q VPWR VGND sg13cmos5l_dlygate4sd3_1
X_10848__1146 _10848_/RESET_B VPWR VGND sg13cmos5l_tiehi
X_11434__1422 _11434_/RESET_B VPWR VGND sg13cmos5l_tiehi
XFILLER_97_667 VPWR VGND sg13cmos5l_decap_8
XFILLER_96_177 VPWR VGND sg13cmos5l_fill_2
X_11485__1213 _11485_/RESET_B VPWR VGND sg13cmos5l_tiehi
X_07740_ _07740_/Y _07740_/A _07748_/B VPWR VGND sg13cmos5l_nor2_1
XFILLER_93_884 VPWR VGND sg13cmos5l_decap_8
X_07671_ _10929_/D _08522_/A1 _07702_/B _07670_/Y VPWR VGND sg13cmos5l_a21oi_1
X_10889__1093 _10889_/RESET_B VPWR VGND sg13cmos5l_tiehi
XFILLER_37_288 VPWR VGND sg13cmos5l_fill_1
XFILLER_18_480 VPWR VGND sg13cmos5l_fill_2
XFILLER_25_428 VPWR VGND sg13cmos5l_decap_4
X_06622_ _06622_/Y _06620_/A _06628_/B _06621_/Y VPWR VGND sg13cmos5l_o21ai_1
X_09410_ _09410_/Y _09173_/X _09196_/X _09345_/A VPWR VGND sg13cmos5l_a21oi_1
XFILLER_53_759 VPWR VGND sg13cmos5l_decap_8
X_09341_ _09341_/Y _06505_/B _09316_/B _09340_/Y _09731_/A VPWR VGND sg13cmos5l_a22oi_1
X_06553_ _06554_/B _06133_/A _11672_/Q _10866_/Q _06134_/A VPWR VGND sg13cmos5l_a22oi_1
X_09272_ _09273_/C _09272_/A _10033_/A _09272_/C VPWR VGND sg13cmos5l_nand3_1
X_06484_ _06490_/A _06505_/A _06484_/B VPWR VGND sg13cmos5l_nand2_1
XFILLER_21_634 VPWR VGND sg13cmos5l_fill_2
X_08223_ _11198_/D fanout76/X _08236_/B _08222_/Y VPWR VGND sg13cmos5l_o21ai_1
XFILLER_20_133 VPWR VGND sg13cmos5l_fill_2
X_08154_ _11164_/D fanout81/X _08153_/B _08153_/Y VPWR VGND sg13cmos5l_a21oi_1
X_08085_ _11131_/D fanout83/X _08104_/B _08084_/Y VPWR VGND sg13cmos5l_o21ai_1
X_07105_ _07105_/Y hold2689/X _07120_/A2 _07071_/A VPWR VGND sg13cmos5l_o21ai_1
XFILLER_106_238 VPWR VGND sg13cmos5l_decap_8
X_07036_ _07036_/Y _07036_/A _07036_/B VPWR VGND sg13cmos5l_nor2_1
XFILLER_103_912 VPWR VGND sg13cmos5l_decap_4
Xhold2732 _10836_/D _07196_/Y VPWR VGND sg13cmos5l_dlygate4sd3_1
Xhold2721 _11692_/D _06884_/X VPWR VGND sg13cmos5l_dlygate4sd3_1
Xhold2710 hold2710/X _11387_/Q VPWR VGND sg13cmos5l_dlygate4sd3_1
XFILLER_103_989 VPWR VGND sg13cmos5l_decap_8
XFILLER_87_166 VPWR VGND sg13cmos5l_fill_1
Xhold2765 _11750_/D _06017_/Y VPWR VGND sg13cmos5l_dlygate4sd3_1
Xclkbuf_4_5_0_clk clkload1/A clkbuf_0_clk/X VPWR VGND sg13cmos5l_buf_8
XFILLER_69_870 VPWR VGND sg13cmos5l_decap_4
Xhold2754 hold2754/X _11740_/Q VPWR VGND sg13cmos5l_dlygate4sd3_1
X_08987_ _08987_/Y _09051_/A1 _08984_/Y _08986_/Y VPWR VGND sg13cmos5l_a21oi_1
Xhold2743 _10220_/A _11398_/Q VPWR VGND sg13cmos5l_dlygate4sd3_1
XFILLER_29_701 VPWR VGND sg13cmos5l_fill_1
Xhold2798 _06330_/B _11484_/Q VPWR VGND sg13cmos5l_dlygate4sd3_1
Xhold2776 hold2776/X _11636_/Q VPWR VGND sg13cmos5l_dlygate4sd3_1
Xheichips26_RiMaX_837 uio_oe[2] VPWR VGND sg13cmos5l_tielo
Xhold2787 hold2787/X _11404_/Q VPWR VGND sg13cmos5l_dlygate4sd3_1
X_07938_ _07938_/Y _07938_/A _07946_/B VPWR VGND sg13cmos5l_nand2_1
XFILLER_29_745 VPWR VGND sg13cmos5l_decap_8
X_07869_ _07869_/Y _07869_/A _07901_/B VPWR VGND sg13cmos5l_nor2_1
XFILLER_29_778 VPWR VGND sg13cmos5l_decap_8
X_10880_ _10880_/Q clkload11/A _10880_/D _10880_/RESET_B VPWR VGND sg13cmos5l_dfrbpq_1
XFILLER_28_277 VPWR VGND sg13cmos5l_decap_8
X_09608_ _09608_/Y _09605_/Y _09607_/Y _09608_/B1 VPWR VGND sg13cmos5l_o21ai_1
X_09539_ _09540_/C _09457_/B _09535_/Y _09538_/Y VPWR VGND sg13cmos5l_o21ai_1
XFILLER_52_781 VPWR VGND sg13cmos5l_decap_4
XFILLER_40_910 VPWR VGND sg13cmos5l_decap_4
XFILLER_12_601 VPWR VGND sg13cmos5l_fill_1
XFILLER_19_1012 VPWR VGND sg13cmos5l_decap_4
XFILLER_106_1015 VPWR VGND sg13cmos5l_decap_8
XFILLER_24_483 VPWR VGND sg13cmos5l_decap_4
X_11501_ _11501_/Q clkload35/A _11501_/D _11501_/RESET_B VPWR VGND sg13cmos5l_dfrbpq_1
X_11432_ _11432_/Q _11528_/CLK _11432_/D _11432_/RESET_B VPWR VGND sg13cmos5l_dfrbpq_1
XFILLER_7_148 VPWR VGND sg13cmos5l_decap_8
X_11363_ _11363_/Q clkload45/A _11363_/D _11363_/RESET_B VPWR VGND sg13cmos5l_dfrbpq_1
XFILLER_3_310 VPWR VGND sg13cmos5l_fill_2
XFILLER_98_77 VPWR VGND sg13cmos5l_decap_8
X_11294_ _11294_/Q _11362_/CLK _11294_/D _11294_/RESET_B VPWR VGND sg13cmos5l_dfrbpq_1
X_10314_ _10334_/A _11400_/Q _10837_/Q VPWR VGND sg13cmos5l_nand2_1
X_11187__1714 _11187_/RESET_B VPWR VGND sg13cmos5l_tiehi
XFILLER_79_634 VPWR VGND sg13cmos5l_fill_2
XFILLER_79_623 VPWR VGND sg13cmos5l_decap_8
X_10245_ _10254_/A _10250_/A _10250_/B _10250_/D VPWR VGND sg13cmos5l_nand3_1
XFILLER_0_0 VPWR VGND sg13cmos5l_decap_8
X_10176_ _10187_/A _11393_/Q _10830_/Q VPWR VGND sg13cmos5l_and2_1
XFILLER_94_604 VPWR VGND sg13cmos5l_decap_4
XFILLER_79_678 VPWR VGND sg13cmos5l_decap_4
XFILLER_78_155 VPWR VGND sg13cmos5l_decap_8
Xfanout190 _08433_/B _08431_/B VPWR VGND sg13cmos5l_buf_1
XFILLER_93_136 VPWR VGND sg13cmos5l_fill_1
X_11716__1248 _11716_/RESET_B VPWR VGND sg13cmos5l_tiehi
XFILLER_74_372 VPWR VGND sg13cmos5l_fill_2
XFILLER_62_534 VPWR VGND sg13cmos5l_decap_4
XFILLER_47_575 VPWR VGND sg13cmos5l_fill_1
XFILLER_90_865 VPWR VGND sg13cmos5l_fill_2
XFILLER_16_940 VPWR VGND sg13cmos5l_fill_2
XFILLER_34_247 VPWR VGND sg13cmos5l_fill_1
XFILLER_62_589 VPWR VGND sg13cmos5l_fill_2
XFILLER_16_984 VPWR VGND sg13cmos5l_decap_8
XFILLER_31_910 VPWR VGND sg13cmos5l_fill_2
XFILLER_31_976 VPWR VGND sg13cmos5l_decap_8
X_11634__1332 _11634_/RESET_B VPWR VGND sg13cmos5l_tiehi
X_09890_ _11480_/D _05901_/Y _09915_/A _09889_/Y VPWR VGND sg13cmos5l_a21oi_1
X_08910_ _08910_/Y _08910_/A _08910_/B VPWR VGND sg13cmos5l_nor2_1
XFILLER_98_965 VPWR VGND sg13cmos5l_decap_8
XFILLER_69_122 VPWR VGND sg13cmos5l_fill_2
X_08841_ _08853_/B _08841_/A _08841_/B VPWR VGND sg13cmos5l_nand2_1
Xhold2006 _08214_/A _11194_/Q VPWR VGND sg13cmos5l_dlygate4sd3_1
Xhold2017 _08206_/A _11190_/Q VPWR VGND sg13cmos5l_dlygate4sd3_1
XFILLER_100_915 VPWR VGND sg13cmos5l_decap_8
XFILLER_97_486 VPWR VGND sg13cmos5l_decap_4
XFILLER_85_626 VPWR VGND sg13cmos5l_decap_8
XFILLER_57_317 VPWR VGND sg13cmos5l_decap_8
Xhold2028 _08936_/A _11438_/Q VPWR VGND sg13cmos5l_dlygate4sd3_1
Xhold2039 _11670_/D _07035_/Y VPWR VGND sg13cmos5l_dlygate4sd3_1
X_10976__1006 _10976_/RESET_B VPWR VGND sg13cmos5l_tiehi
XFILLER_85_637 VPWR VGND sg13cmos5l_decap_8
X_08772_ _08773_/A _10679_/A _08772_/A2 _09150_/B _08772_/B2 VPWR VGND sg13cmos5l_a22oi_1
X_05984_ _05984_/Y _10856_/Q VPWR VGND sg13cmos5l_inv_1
XFILLER_27_18 VPWR VGND sg13cmos5l_fill_2
X_07723_ _10954_/D _08313_/A1 _07780_/B _07722_/Y VPWR VGND sg13cmos5l_a21oi_1
XFILLER_66_851 VPWR VGND sg13cmos5l_decap_4
XFILLER_38_542 VPWR VGND sg13cmos5l_fill_1
X_07654_ _08441_/B _11561_/Q _07655_/B VPWR VGND sg13cmos5l_nor2_1
XFILLER_66_895 VPWR VGND sg13cmos5l_fill_1
XFILLER_38_586 VPWR VGND sg13cmos5l_decap_8
XFILLER_81_865 VPWR VGND sg13cmos5l_decap_8
X_06605_ _06605_/X _06605_/A _06605_/B VPWR VGND sg13cmos5l_xor2_1
XFILLER_81_887 VPWR VGND sg13cmos5l_fill_1
XFILLER_80_386 VPWR VGND sg13cmos5l_fill_2
XFILLER_53_578 VPWR VGND sg13cmos5l_fill_1
X_07585_ _07585_/Y _07597_/C _07584_/X _07650_/A VPWR VGND sg13cmos5l_o21ai_1
X_09324_ _11457_/D _10173_/A _09314_/A _09316_/Y _09323_/X VPWR VGND sg13cmos5l_a22oi_1
X_11265__1636 _11265_/RESET_B VPWR VGND sg13cmos5l_tiehi
X_06536_ _06536_/Y _06536_/A _06536_/B VPWR VGND sg13cmos5l_nand2_1
XFILLER_21_431 VPWR VGND sg13cmos5l_fill_1
X_09255_ _09256_/B _09909_/A _10853_/Q _10854_/Q _09938_/A VPWR VGND sg13cmos5l_a22oi_1
X_06467_ _06467_/Y _06466_/A _06467_/B VPWR VGND sg13cmos5l_nand2b_1
XFILLER_33_291 VPWR VGND sg13cmos5l_decap_4
X_08206_ _08206_/Y _08206_/A _08208_/B VPWR VGND sg13cmos5l_nand2_1
X_06398_ _06628_/B _11619_/Q _11608_/Q VPWR VGND sg13cmos5l_nor2_1
X_09186_ _09321_/A _10235_/B _10830_/Q VPWR VGND sg13cmos5l_xor2_1
XFILLER_5_619 VPWR VGND sg13cmos5l_fill_1
XFILLER_4_107 VPWR VGND sg13cmos5l_decap_8
X_08137_ _08137_/Y _08137_/A _08141_/B VPWR VGND sg13cmos5l_nor2_1
X_08068_ _08068_/Y _08068_/A _08076_/B VPWR VGND sg13cmos5l_nand2_1
X_07019_ _07019_/Y _07018_/B _07017_/Y _07018_/Y VPWR VGND sg13cmos5l_o21ai_1
XFILLER_103_753 VPWR VGND sg13cmos5l_fill_2
XFILLER_103_742 VPWR VGND sg13cmos5l_fill_2
XFILLER_88_431 VPWR VGND sg13cmos5l_decap_8
X_10030_ _11485_/D _09912_/A _10055_/A _10006_/Y _10029_/Y VPWR VGND sg13cmos5l_a22oi_1
XFILLER_102_252 VPWR VGND sg13cmos5l_decap_8
Xhold2540 hold2540/X _07371_/Y VPWR VGND sg13cmos5l_dlygate4sd3_1
Xhold2562 _10733_/B _10732_/Y VPWR VGND sg13cmos5l_dlygate4sd3_1
Xhold2573 hold2573/X _11627_/Q VPWR VGND sg13cmos5l_dlygate4sd3_1
Xhold2551 hold2551/X _11448_/Q VPWR VGND sg13cmos5l_dlygate4sd3_1
XFILLER_29_531 VPWR VGND sg13cmos5l_fill_1
Xhold1861 _08490_/A _11330_/Q VPWR VGND sg13cmos5l_dlygate4sd3_1
Xhold2584 _11571_/D _10753_/X VPWR VGND sg13cmos5l_dlygate4sd3_1
XFILLER_84_35 VPWR VGND sg13cmos5l_fill_2
Xhold2595 _07416_/A _11452_/Q VPWR VGND sg13cmos5l_dlygate4sd3_1
XFILLER_75_169 VPWR VGND sg13cmos5l_fill_1
Xhold1872 _11439_/D _08958_/Y VPWR VGND sg13cmos5l_dlygate4sd3_1
Xhold1850 _07942_/A _11061_/Q VPWR VGND sg13cmos5l_dlygate4sd3_1
XFILLER_95_1003 VPWR VGND sg13cmos5l_decap_8
XFILLER_91_629 VPWR VGND sg13cmos5l_fill_2
XFILLER_72_810 VPWR VGND sg13cmos5l_decap_8
X_10832__1178 _10832_/RESET_B VPWR VGND sg13cmos5l_tiehi
XFILLER_57_884 VPWR VGND sg13cmos5l_decap_8
XFILLER_44_512 VPWR VGND sg13cmos5l_fill_1
X_10932_ _10932_/Q _11347_/CLK _10932_/D _10932_/RESET_B VPWR VGND sg13cmos5l_dfrbpq_1
Xhold1894 _08228_/A _11201_/Q VPWR VGND sg13cmos5l_dlygate4sd3_1
Xhold1883 _08078_/A _11128_/Q VPWR VGND sg13cmos5l_dlygate4sd3_1
XFILLER_71_320 VPWR VGND sg13cmos5l_fill_1
XFILLER_56_394 VPWR VGND sg13cmos5l_decap_8
XFILLER_44_556 VPWR VGND sg13cmos5l_decap_8
XFILLER_17_73 VPWR VGND sg13cmos5l_fill_1
XFILLER_32_707 VPWR VGND sg13cmos5l_decap_8
XFILLER_17_84 VPWR VGND sg13cmos5l_fill_2
X_10863_ _10863_/Q clkload12/A _10863_/D _10863_/RESET_B VPWR VGND sg13cmos5l_dfrbpq_1
X_10794_ _10794_/Q clkload21/A _10794_/D _10794_/RESET_B VPWR VGND sg13cmos5l_dfrbpq_1
XFILLER_13_954 VPWR VGND sg13cmos5l_decap_4
X_11451__1388 _11451_/RESET_B VPWR VGND sg13cmos5l_tiehi
XFILLER_40_751 VPWR VGND sg13cmos5l_fill_2
XFILLER_40_740 VPWR VGND sg13cmos5l_decap_8
XFILLER_8_435 VPWR VGND sg13cmos5l_fill_2
X_11466__1322 _11466_/RESET_B VPWR VGND sg13cmos5l_tiehi
X_11415_ _11415_/Q clkload55/A _11415_/D _11415_/RESET_B VPWR VGND sg13cmos5l_dfrbpq_1
X_11346_ _11346_/Q clkload17/A _11346_/D _11346_/RESET_B VPWR VGND sg13cmos5l_dfrbpq_1
XFILLER_98_228 VPWR VGND sg13cmos5l_fill_2
X_11622__1347 _11622_/RESET_B VPWR VGND sg13cmos5l_tiehi
XFILLER_79_442 VPWR VGND sg13cmos5l_fill_1
X_11277_ _11277_/Q clkload34/A _11277_/D _11277_/RESET_B VPWR VGND sg13cmos5l_dfrbpq_1
X_10228_ _10228_/Y _10224_/Y _10225_/Y _10226_/Y _10227_/Y _08648_/A VPWR VGND sg13cmos5l_a221oi_1
XFILLER_95_957 VPWR VGND sg13cmos5l_decap_4
XFILLER_66_136 VPWR VGND sg13cmos5l_decap_4
X_10159_ _10159_/X _11724_/Q _11740_/Q _10235_/B VPWR VGND sg13cmos5l_mux2_1
X_11343__1558 _11343_/RESET_B VPWR VGND sg13cmos5l_tiehi
XFILLER_0_880 VPWR VGND sg13cmos5l_decap_8
XFILLER_95_979 VPWR VGND sg13cmos5l_decap_4
XFILLER_94_478 VPWR VGND sg13cmos5l_decap_4
XFILLER_82_607 VPWR VGND sg13cmos5l_fill_1
XFILLER_81_128 VPWR VGND sg13cmos5l_decap_4
XFILLER_63_821 VPWR VGND sg13cmos5l_decap_4
XFILLER_47_372 VPWR VGND sg13cmos5l_decap_8
XFILLER_35_501 VPWR VGND sg13cmos5l_decap_8
XFILLER_90_673 VPWR VGND sg13cmos5l_fill_1
XFILLER_35_567 VPWR VGND sg13cmos5l_decap_4
XFILLER_90_695 VPWR VGND sg13cmos5l_fill_2
X_07370_ _07370_/Y _10242_/B _07376_/A2 _07369_/Y VPWR VGND sg13cmos5l_a21oi_1
XFILLER_16_792 VPWR VGND sg13cmos5l_fill_2
X_06321_ _06321_/Y _11512_/Q _06321_/B VPWR VGND sg13cmos5l_nand2b_1
XFILLER_31_751 VPWR VGND sg13cmos5l_decap_8
X_06252_ _10642_/A _06252_/A _06421_/B VPWR VGND sg13cmos5l_nor2_1
X_09040_ _09040_/Y _09052_/A _09036_/C _09064_/B1 VPWR VGND sg13cmos5l_o21ai_1
X_10798__935 _10798_/RESET_B VPWR VGND sg13cmos5l_tiehi
XFILLER_8_991 VPWR VGND sg13cmos5l_decap_8
X_06183_ _06183_/Y _07036_/A _06185_/B VPWR VGND sg13cmos5l_nor2_1
XFILLER_7_490 VPWR VGND sg13cmos5l_fill_2
X_09942_ _09942_/Y _09942_/A _09942_/B VPWR VGND sg13cmos5l_nor2_1
XFILLER_98_784 VPWR VGND sg13cmos5l_fill_2
X_09873_ _09873_/Y _11042_/Q _09984_/B _09987_/B1 VPWR VGND sg13cmos5l_a21oi_1
XFILLER_86_924 VPWR VGND sg13cmos5l_decap_4
XFILLER_100_745 VPWR VGND sg13cmos5l_fill_1
XFILLER_98_795 VPWR VGND sg13cmos5l_decap_4
X_08824_ _08824_/Y _08827_/B _08852_/D VPWR VGND sg13cmos5l_xnor2_1
XFILLER_85_478 VPWR VGND sg13cmos5l_decap_4
XFILLER_85_445 VPWR VGND sg13cmos5l_decap_4
X_08755_ _09102_/B _08755_/A _08755_/B VPWR VGND sg13cmos5l_nand2_1
X_11319__1582 _11319_/RESET_B VPWR VGND sg13cmos5l_tiehi
X_07706_ _07706_/Y _07706_/A _07718_/B VPWR VGND sg13cmos5l_nor2_1
X_05967_ _05967_/Y _10842_/Q VPWR VGND sg13cmos5l_inv_1
XFILLER_38_350 VPWR VGND sg13cmos5l_decap_8
XFILLER_26_512 VPWR VGND sg13cmos5l_decap_8
X_05898_ _09856_/A _09246_/A VPWR VGND sg13cmos5l_inv_1
XFILLER_54_16 VPWR VGND sg13cmos5l_fill_1
XFILLER_26_534 VPWR VGND sg13cmos5l_fill_2
XFILLER_26_545 VPWR VGND sg13cmos5l_decap_8
X_08686_ _08891_/A _08686_/A _08686_/B VPWR VGND sg13cmos5l_nand2_1
X_07637_ _07638_/B _10653_/A _07643_/D _11421_/Q VPWR VGND sg13cmos5l_a21oi_1
XFILLER_54_876 VPWR VGND sg13cmos5l_decap_4
XFILLER_13_228 VPWR VGND sg13cmos5l_fill_2
X_07568_ _08721_/B _11538_/Q _10813_/Q _07582_/S VPWR VGND sg13cmos5l_mux2_1
X_09307_ _11455_/D _09273_/Y _09305_/X _09306_/Y VPWR VGND sg13cmos5l_a21oi_1
X_06519_ _06519_/Y _05956_/Y _06512_/B _09553_/B1 _06518_/Y VPWR VGND sg13cmos5l_a22oi_1
XFILLER_16_1026 VPWR VGND sg13cmos5l_fill_2
XFILLER_10_935 VPWR VGND sg13cmos5l_fill_2
XFILLER_21_272 VPWR VGND sg13cmos5l_decap_8
X_07499_ _07499_/Y _07515_/A _07499_/B VPWR VGND sg13cmos5l_nor2_1
X_09238_ _09239_/D _09696_/A _10845_/Q _10846_/Q _09721_/A VPWR VGND sg13cmos5l_a22oi_1
XFILLER_10_957 VPWR VGND sg13cmos5l_fill_2
XFILLER_21_283 VPWR VGND sg13cmos5l_fill_1
X_09169_ _09754_/A _10305_/A _10849_/Q VPWR VGND sg13cmos5l_xnor2_1
XFILLER_5_438 VPWR VGND sg13cmos5l_fill_2
X_11200_ _11200_/Q clkload56/A _11200_/D _11200_/RESET_B VPWR VGND sg13cmos5l_dfrbpq_1
X_11131_ _11131_/Q clkload54/A _11131_/D _11131_/RESET_B VPWR VGND sg13cmos5l_dfrbpq_1
XFILLER_89_762 VPWR VGND sg13cmos5l_fill_2
XFILLER_76_401 VPWR VGND sg13cmos5l_fill_2
X_11062_ _11062_/Q clkload33/A _11062_/D _11062_/RESET_B VPWR VGND sg13cmos5l_dfrbpq_1
XFILLER_95_56 VPWR VGND sg13cmos5l_decap_8
X_10013_ _10013_/Y _10983_/Q _10007_/B _10021_/B1 VPWR VGND sg13cmos5l_a21oi_1
XFILLER_76_412 VPWR VGND sg13cmos5l_fill_1
XFILLER_1_688 VPWR VGND sg13cmos5l_fill_2
XFILLER_23_1019 VPWR VGND sg13cmos5l_decap_8
XFILLER_95_67 VPWR VGND sg13cmos5l_fill_1
XFILLER_76_456 VPWR VGND sg13cmos5l_decap_8
XFILLER_64_618 VPWR VGND sg13cmos5l_decap_8
XFILLER_48_147 VPWR VGND sg13cmos5l_decap_8
Xhold2381 _07537_/A _10904_/Q VPWR VGND sg13cmos5l_dlygate4sd3_1
Xhold2370 _10873_/D _07336_/Y VPWR VGND sg13cmos5l_dlygate4sd3_1
Xhold2392 _07716_/A _10952_/Q VPWR VGND sg13cmos5l_dlygate4sd3_1
XFILLER_57_681 VPWR VGND sg13cmos5l_fill_2
XFILLER_17_512 VPWR VGND sg13cmos5l_decap_8
XFILLER_56_180 VPWR VGND sg13cmos5l_decap_4
XFILLER_45_832 VPWR VGND sg13cmos5l_decap_8
X_10915_ _10915_/Q clkload46/A _10915_/D _10915_/RESET_B VPWR VGND sg13cmos5l_dfrbpq_1
XFILLER_44_375 VPWR VGND sg13cmos5l_decap_8
XFILLER_17_578 VPWR VGND sg13cmos5l_fill_2
XFILLER_60_846 VPWR VGND sg13cmos5l_decap_8
X_10846_ _10846_/Q clkload36/A _10846_/D _10846_/RESET_B VPWR VGND sg13cmos5l_dfrbpq_1
XFILLER_13_740 VPWR VGND sg13cmos5l_fill_2
XFILLER_32_559 VPWR VGND sg13cmos5l_fill_1
X_10777_ _10777_/Y _11687_/D _11686_/D _10777_/C VPWR VGND sg13cmos5l_nand3_1
X_11666__1298 _11666_/RESET_B VPWR VGND sg13cmos5l_tiehi
XFILLER_9_755 VPWR VGND sg13cmos5l_decap_8
XFILLER_5_21 VPWR VGND sg13cmos5l_decap_8
XFILLER_5_994 VPWR VGND sg13cmos5l_decap_8
XFILLER_5_961 VPWR VGND sg13cmos5l_decap_8
X_11329_ _11329_/Q _11361_/CLK _11329_/D _11329_/RESET_B VPWR VGND sg13cmos5l_dfrbpq_1
XFILLER_79_250 VPWR VGND sg13cmos5l_fill_2
XFILLER_68_946 VPWR VGND sg13cmos5l_fill_2
XFILLER_67_423 VPWR VGND sg13cmos5l_fill_1
X_06870_ _06874_/C _11692_/Q _11705_/Q _11693_/Q _11706_/Q VPWR VGND sg13cmos5l_nor4_1
XFILLER_95_765 VPWR VGND sg13cmos5l_fill_1
XFILLER_39_147 VPWR VGND sg13cmos5l_fill_1
X_08540_ _11354_/D fanout96/X _08553_/B _08539_/Y VPWR VGND sg13cmos5l_a21oi_1
XFILLER_91_971 VPWR VGND sg13cmos5l_fill_2
XFILLER_63_651 VPWR VGND sg13cmos5l_decap_8
X_08471_ _11320_/D _08471_/A1 _08470_/B _08470_/Y VPWR VGND sg13cmos5l_o21ai_1
X_07422_ _08767_/A _09145_/A _08651_/B VPWR VGND sg13cmos5l_nand2_1
XFILLER_23_526 VPWR VGND sg13cmos5l_decap_4
XFILLER_62_194 VPWR VGND sg13cmos5l_fill_2
XFILLER_10_209 VPWR VGND sg13cmos5l_fill_1
X_07353_ _07353_/Y _07353_/A _07365_/B VPWR VGND sg13cmos5l_nor2_1
XFILLER_31_570 VPWR VGND sg13cmos5l_fill_2
X_07284_ _07284_/Y _08834_/A _07296_/B VPWR VGND sg13cmos5l_nand2_1
X_06304_ _06709_/C _06272_/A _06645_/B _06299_/Y _06179_/A _06303_/Y VPWR VGND sg13cmos5l_a221oi_1
X_09023_ _09023_/Y _08967_/Y _09070_/A _09021_/Y VPWR VGND sg13cmos5l_o21ai_1
X_06235_ _10437_/A _06236_/A _09557_/A VPWR VGND sg13cmos5l_nor2_1
XFILLER_2_419 VPWR VGND sg13cmos5l_decap_8
X_06166_ _06166_/Y _11497_/Q _09202_/A VPWR VGND sg13cmos5l_nand2_1
XFILLER_105_848 VPWR VGND sg13cmos5l_decap_8
X_11017__965 _11017_/RESET_B VPWR VGND sg13cmos5l_tiehi
X_11711__1253 _11711_/RESET_B VPWR VGND sg13cmos5l_tiehi
X_06097_ _06098_/A _06133_/A _06122_/B _06096_/Y _06117_/A VPWR VGND sg13cmos5l_a22oi_1
XFILLER_49_16 VPWR VGND sg13cmos5l_decap_8
X_09925_ _09931_/A _09921_/Y _09922_/Y _09923_/Y _09924_/Y _10016_/C1 VPWR VGND sg13cmos5l_a221oi_1
XFILLER_77_209 VPWR VGND sg13cmos5l_fill_1
Xfanout723 _07642_/S _07651_/S VPWR VGND sg13cmos5l_buf_1
Xfanout712 _07225_/A1 _09063_/A1 VPWR VGND sg13cmos5l_buf_1
XFILLER_59_902 VPWR VGND sg13cmos5l_decap_4
Xfanout701 _06739_/A _06679_/A VPWR VGND sg13cmos5l_buf_1
XFILLER_86_710 VPWR VGND sg13cmos5l_fill_2
Xfanout745 _09246_/A _11483_/Q VPWR VGND sg13cmos5l_buf_1
X_09856_ _09857_/B _09856_/A _09968_/B VPWR VGND sg13cmos5l_nand2_1
XFILLER_59_946 VPWR VGND sg13cmos5l_decap_4
Xfanout734 _06216_/A _11507_/Q VPWR VGND sg13cmos5l_buf_1
Xfanout756 _10289_/A _11477_/Q VPWR VGND sg13cmos5l_buf_1
Xfanout767 _10298_/A _10462_/A VPWR VGND sg13cmos5l_buf_1
XFILLER_100_542 VPWR VGND sg13cmos5l_fill_2
XFILLER_100_531 VPWR VGND sg13cmos5l_fill_2
XFILLER_86_776 VPWR VGND sg13cmos5l_fill_1
Xfanout789 _10180_/B _11457_/Q VPWR VGND sg13cmos5l_buf_1
X_08807_ _08807_/Y _08819_/A _08806_/Y _08832_/A1 VPWR VGND sg13cmos5l_o21ai_1
Xfanout778 _09205_/A _09507_/A VPWR VGND sg13cmos5l_buf_1
XFILLER_105_77 VPWR VGND sg13cmos5l_decap_8
X_09787_ _09787_/Y _11071_/Q _09823_/B VPWR VGND sg13cmos5l_nand2_1
XFILLER_85_286 VPWR VGND sg13cmos5l_fill_2
XFILLER_74_938 VPWR VGND sg13cmos5l_fill_1
XFILLER_74_927 VPWR VGND sg13cmos5l_decap_8
XFILLER_67_990 VPWR VGND sg13cmos5l_fill_1
X_06999_ _06999_/Y _07006_/B _11501_/Q VPWR VGND sg13cmos5l_nand2b_1
X_08738_ _08738_/Y _08738_/A _08738_/B VPWR VGND sg13cmos5l_nand2_1
XFILLER_27_832 VPWR VGND sg13cmos5l_decap_4
XFILLER_60_109 VPWR VGND sg13cmos5l_decap_8
X_08669_ _08670_/A _10220_/A _08846_/B _08827_/B _08831_/B1 VPWR VGND sg13cmos5l_a22oi_1
XFILLER_26_353 VPWR VGND sg13cmos5l_fill_2
XFILLER_26_364 VPWR VGND sg13cmos5l_decap_4
XFILLER_92_1028 VPWR VGND sg13cmos5l_fill_1
XFILLER_81_14 VPWR VGND sg13cmos5l_decap_8
X_10700_ _10700_/Y _10700_/A _10695_/Y VPWR VGND sg13cmos5l_nor2b_1
XFILLER_27_898 VPWR VGND sg13cmos5l_fill_1
X_11680_ _11680_/Q clkload13/A _11680_/D _11680_/RESET_B VPWR VGND sg13cmos5l_dfrbpq_1
XFILLER_41_356 VPWR VGND sg13cmos5l_fill_2
X_10631_ _10631_/Y _10624_/Y _10626_/Y _10630_/Y VPWR VGND sg13cmos5l_o21ai_1
X_10562_ _10566_/B _10562_/A _10852_/Q VPWR VGND sg13cmos5l_xor2_1
X_10493_ _10493_/Y _10539_/A _10506_/B _10506_/C VPWR VGND sg13cmos5l_nand3_1
XFILLER_100_0 VPWR VGND sg13cmos5l_decap_8
X_10971__1011 _10971_/RESET_B VPWR VGND sg13cmos5l_tiehi
XFILLER_5_279 VPWR VGND sg13cmos5l_decap_8
XFILLER_2_920 VPWR VGND sg13cmos5l_decap_8
X_11114_ _11114_/Q _11646_/CLK _11114_/D _11114_/RESET_B VPWR VGND sg13cmos5l_dfrbpq_1
XFILLER_68_209 VPWR VGND sg13cmos5l_fill_2
XFILLER_77_721 VPWR VGND sg13cmos5l_decap_8
X_11045_ _11045_/Q _11355_/CLK _11045_/D _11045_/RESET_B VPWR VGND sg13cmos5l_dfrbpq_1
XFILLER_2_997 VPWR VGND sg13cmos5l_decap_8
XFILLER_103_391 VPWR VGND sg13cmos5l_decap_8
XFILLER_77_743 VPWR VGND sg13cmos5l_decap_8
XFILLER_49_445 VPWR VGND sg13cmos5l_fill_1
XFILLER_49_434 VPWR VGND sg13cmos5l_fill_2
X_11260__1641 _11260_/RESET_B VPWR VGND sg13cmos5l_tiehi
XFILLER_18_821 VPWR VGND sg13cmos5l_decap_8
XFILLER_73_960 VPWR VGND sg13cmos5l_decap_8
XFILLER_17_342 VPWR VGND sg13cmos5l_fill_1
XFILLER_44_172 VPWR VGND sg13cmos5l_fill_1
XFILLER_32_301 VPWR VGND sg13cmos5l_decap_8
XFILLER_32_312 VPWR VGND sg13cmos5l_fill_2
X_10829_ _10829_/Q clkload49/A _10829_/D _10829_/RESET_B VPWR VGND sg13cmos5l_dfrbpq_1
XFILLER_72_4 VPWR VGND sg13cmos5l_decap_4
XFILLER_9_596 VPWR VGND sg13cmos5l_fill_2
X_06020_ _06021_/C _06800_/A _10727_/A _10727_/B VPWR VGND sg13cmos5l_o21ai_1
XFILLER_69_1019 VPWR VGND sg13cmos5l_fill_1
XFILLER_5_780 VPWR VGND sg13cmos5l_decap_8
X_07971_ _11075_/D fanout62/X _07982_/B _07970_/Y VPWR VGND sg13cmos5l_o21ai_1
X_06922_ _06922_/Y _06931_/B _11688_/D _11690_/D _11689_/D VPWR VGND sg13cmos5l_nor4_1
X_09710_ _09710_/Y _10908_/Q _09708_/S _09842_/B1 VPWR VGND sg13cmos5l_a21oi_1
XFILLER_95_562 VPWR VGND sg13cmos5l_fill_2
X_06853_ _06853_/Y _06853_/A _06861_/B VPWR VGND sg13cmos5l_nand2_1
XFILLER_68_798 VPWR VGND sg13cmos5l_fill_1
X_09641_ _09722_/B _09641_/A _09668_/B VPWR VGND sg13cmos5l_nor2_1
X_06784_ _06784_/Y _10728_/B _10763_/S VPWR VGND sg13cmos5l_nand2_1
X_11392__1506 _11392_/RESET_B VPWR VGND sg13cmos5l_tiehi
XFILLER_55_437 VPWR VGND sg13cmos5l_decap_8
X_09572_ _09572_/Y _09570_/Y _09571_/Y _09572_/B1 VPWR VGND sg13cmos5l_a21oi_1
XFILLER_83_779 VPWR VGND sg13cmos5l_decap_4
XFILLER_70_418 VPWR VGND sg13cmos5l_fill_2
XFILLER_70_407 VPWR VGND sg13cmos5l_decap_8
XFILLER_36_673 VPWR VGND sg13cmos5l_fill_1
X_08523_ _08523_/Y _08523_/A _08527_/B VPWR VGND sg13cmos5l_nor2_1
XFILLER_63_481 VPWR VGND sg13cmos5l_fill_2
XFILLER_50_131 VPWR VGND sg13cmos5l_fill_1
X_08454_ _08454_/Y _08454_/A _08468_/B VPWR VGND sg13cmos5l_nand2_1
X_11514__1155 _11514_/RESET_B VPWR VGND sg13cmos5l_tiehi
X_07405_ _07405_/Y _07403_/Y _08755_/A _07429_/B1 VPWR VGND sg13cmos5l_a21oi_1
XFILLER_52_1023 VPWR VGND sg13cmos5l_decap_4
XFILLER_51_687 VPWR VGND sg13cmos5l_fill_1
XFILLER_50_164 VPWR VGND sg13cmos5l_decap_8
X_11123__1778 _11123_/RESET_B VPWR VGND sg13cmos5l_tiehi
X_08385_ _08385_/Y _08385_/A _08397_/B VPWR VGND sg13cmos5l_nor2_1
X_07336_ _07336_/Y _07425_/B _07334_/Y _07335_/Y VPWR VGND sg13cmos5l_a21oi_1
X_09006_ _09018_/B _09043_/A _09036_/A VPWR VGND sg13cmos5l_xnor2_1
X_07267_ _07267_/Y _07265_/Y _07266_/Y _06956_/B VPWR VGND sg13cmos5l_a21oi_1
X_07198_ _07200_/A _08774_/A _07198_/B _07202_/C VPWR VGND sg13cmos5l_nand3_1
X_06218_ _06732_/A _06738_/A _10270_/A VPWR VGND sg13cmos5l_nor2_1
XFILLER_4_7 VPWR VGND sg13cmos5l_decap_8
X_06149_ _06682_/A _11501_/Q _09218_/A VPWR VGND sg13cmos5l_nand2_1
XFILLER_105_656 VPWR VGND sg13cmos5l_decap_8
XFILLER_104_133 VPWR VGND sg13cmos5l_decap_8
XFILLER_105_689 VPWR VGND sg13cmos5l_decap_8
Xfanout520 _07650_/A _07652_/A1 VPWR VGND sg13cmos5l_buf_1
Xfanout542 _08762_/A _08770_/A VPWR VGND sg13cmos5l_buf_1
XFILLER_78_529 VPWR VGND sg13cmos5l_fill_2
XFILLER_59_710 VPWR VGND sg13cmos5l_decap_8
Xfanout531 _07326_/B _08651_/B VPWR VGND sg13cmos5l_buf_1
XFILLER_86_540 VPWR VGND sg13cmos5l_decap_4
X_09908_ _09915_/B _09996_/A _09908_/B _09908_/C VPWR VGND sg13cmos5l_nor3_1
Xfanout575 _06758_/B1 _06401_/D VPWR VGND sg13cmos5l_buf_1
Xfanout564 _06933_/B _07191_/A2 VPWR VGND sg13cmos5l_buf_1
Xfanout553 _07316_/A2 _07262_/A2 VPWR VGND sg13cmos5l_buf_1
Xfanout586 _06401_/B _06395_/X VPWR VGND sg13cmos5l_buf_1
XFILLER_59_787 VPWR VGND sg13cmos5l_fill_2
XFILLER_59_776 VPWR VGND sg13cmos5l_decap_8
Xfanout597 _07108_/A2 _07122_/A2 VPWR VGND sg13cmos5l_buf_1
X_09839_ _09839_/Y _10006_/A _09839_/B _09839_/C VPWR VGND sg13cmos5l_nand3_1
XFILLER_100_394 VPWR VGND sg13cmos5l_decap_8
XFILLER_92_35 VPWR VGND sg13cmos5l_decap_8
XFILLER_55_971 VPWR VGND sg13cmos5l_decap_8
XFILLER_27_662 VPWR VGND sg13cmos5l_fill_2
XFILLER_92_79 VPWR VGND sg13cmos5l_fill_2
XFILLER_27_684 VPWR VGND sg13cmos5l_decap_4
X_11732_ _11732_/Q _11766_/CLK _11732_/D _11732_/RESET_B VPWR VGND sg13cmos5l_dfrbpq_1
X_11542__1489 _11542_/RESET_B VPWR VGND sg13cmos5l_tiehi
XFILLER_42_687 VPWR VGND sg13cmos5l_decap_4
XFILLER_41_153 VPWR VGND sg13cmos5l_fill_1
XFILLER_14_378 VPWR VGND sg13cmos5l_fill_2
XFILLER_14_389 VPWR VGND sg13cmos5l_fill_2
X_11663_ _11663_/Q clkload7/A _11663_/D _11663_/RESET_B VPWR VGND sg13cmos5l_dfrbpq_1
X_10614_ _10616_/B _10614_/A1 _10656_/B _10613_/X _10614_/B2 _10614_/C1 VPWR VGND
+ sg13cmos5l_a221oi_1
X_11594_ _11594_/Q _11594_/CLK _11594_/D _11594_/RESET_B VPWR VGND sg13cmos5l_dfrbpq_1
XFILLER_6_511 VPWR VGND sg13cmos5l_decap_4
X_10545_ _10545_/Y _10545_/A _10545_/B VPWR VGND sg13cmos5l_nand2_1
XFILLER_41_72 VPWR VGND sg13cmos5l_decap_4
XFILLER_51_9 VPWR VGND sg13cmos5l_fill_1
X_10476_ _10478_/C _10474_/A _10476_/B VPWR VGND sg13cmos5l_nand2b_1
X_11278__1623 _11278_/RESET_B VPWR VGND sg13cmos5l_tiehi
XFILLER_29_1014 VPWR VGND sg13cmos5l_fill_2
XFILLER_44_8 VPWR VGND sg13cmos5l_fill_1
XFILLER_2_750 VPWR VGND sg13cmos5l_decap_8
XFILLER_29_1025 VPWR VGND sg13cmos5l_decap_4
XFILLER_96_326 VPWR VGND sg13cmos5l_fill_2
XFILLER_2_772 VPWR VGND sg13cmos5l_decap_4
XFILLER_49_253 VPWR VGND sg13cmos5l_fill_1
X_11028_ _11028_/Q _11347_/CLK _11028_/D _11028_/RESET_B VPWR VGND sg13cmos5l_dfrbpq_1
XFILLER_64_234 VPWR VGND sg13cmos5l_fill_1
XFILLER_49_286 VPWR VGND sg13cmos5l_fill_1
XFILLER_80_738 VPWR VGND sg13cmos5l_fill_2
XFILLER_52_429 VPWR VGND sg13cmos5l_fill_1
XFILLER_17_161 VPWR VGND sg13cmos5l_decap_4
XFILLER_60_440 VPWR VGND sg13cmos5l_fill_2
X_11007__975 _11007_/RESET_B VPWR VGND sg13cmos5l_tiehi
X_08170_ _11172_/D fanout60/X _08169_/B _08169_/Y VPWR VGND sg13cmos5l_a21oi_1
XFILLER_60_484 VPWR VGND sg13cmos5l_fill_2
XFILLER_20_326 VPWR VGND sg13cmos5l_decap_8
XFILLER_20_337 VPWR VGND sg13cmos5l_fill_1
XFILLER_32_186 VPWR VGND sg13cmos5l_decap_8
XANTENNA_16 _07652_/A1 VPWR VGND sg13cmos5l_antennanp
X_11725__1230 _11725_/RESET_B VPWR VGND sg13cmos5l_tiehi
X_07121_ _07121_/Y _10180_/A _07122_/A2 _06091_/A VPWR VGND sg13cmos5l_o21ai_1
XFILLER_63_0 VPWR VGND sg13cmos5l_fill_2
X_07052_ _07052_/Y _11515_/Q _10165_/B VPWR VGND sg13cmos5l_nand2_1
X_06003_ _06012_/A _10728_/B _06003_/B _06003_/C VPWR VGND sg13cmos5l_nand3_1
XFILLER_102_626 VPWR VGND sg13cmos5l_fill_1
XFILLER_99_186 VPWR VGND sg13cmos5l_fill_2
Xhold2903 _09157_/B _10859_/Q VPWR VGND sg13cmos5l_dlygate4sd3_1
Xhold2914 _11534_/D _10451_/Y VPWR VGND sg13cmos5l_dlygate4sd3_1
XFILLER_101_147 VPWR VGND sg13cmos5l_decap_8
XFILLER_87_359 VPWR VGND sg13cmos5l_fill_2
XFILLER_87_348 VPWR VGND sg13cmos5l_decap_8
Xhold2936 _05990_/B _11587_/Q VPWR VGND sg13cmos5l_dlygate4sd3_1
X_11014__968 _11014_/RESET_B VPWR VGND sg13cmos5l_tiehi
X_07954_ _07954_/Y _07954_/A _07974_/B VPWR VGND sg13cmos5l_nand2_1
Xhold2925 _09177_/B _10834_/Q VPWR VGND sg13cmos5l_dlygate4sd3_1
Xhold2947 _06175_/A _11495_/Q VPWR VGND sg13cmos5l_dlygate4sd3_1
X_06905_ _06905_/X _06905_/A _07202_/C VPWR VGND sg13cmos5l_and2_1
X_07885_ _07885_/Y _07885_/A _07893_/B VPWR VGND sg13cmos5l_nor2_1
X_06836_ _06836_/Y hold2656/X _06927_/B _06874_/A _06835_/Y VPWR VGND sg13cmos5l_a22oi_1
X_09624_ _09624_/Y _10969_/Q _09652_/S _06477_/B VPWR VGND sg13cmos5l_a21oi_1
XFILLER_70_204 VPWR VGND sg13cmos5l_fill_1
X_06767_ _06768_/B _06322_/Y _06765_/Y _06766_/Y _05893_/Y VPWR VGND sg13cmos5l_a22oi_1
XFILLER_55_289 VPWR VGND sg13cmos5l_decap_4
X_09555_ _09555_/Y _09548_/Y _09550_/Y _09554_/Y _09608_/B1 VPWR VGND sg13cmos5l_a22oi_1
XFILLER_24_610 VPWR VGND sg13cmos5l_decap_8
XFILLER_102_56 VPWR VGND sg13cmos5l_decap_8
X_08506_ _08506_/Y _11564_/Q _11563_/Q _08506_/C VPWR VGND sg13cmos5l_nor3_1
XFILLER_52_952 VPWR VGND sg13cmos5l_decap_4
X_11356__1545 _11356_/RESET_B VPWR VGND sg13cmos5l_tiehi
XFILLER_24_643 VPWR VGND sg13cmos5l_fill_1
X_06698_ _06698_/Y _06709_/B _06698_/B VPWR VGND sg13cmos5l_xnor2_1
X_09486_ _09487_/B _09199_/A _09206_/A _09208_/C VPWR VGND sg13cmos5l_o21ai_1
X_08437_ _08437_/Y _08437_/A _08439_/B VPWR VGND sg13cmos5l_nor2_1
XFILLER_51_495 VPWR VGND sg13cmos5l_decap_4
XFILLER_11_326 VPWR VGND sg13cmos5l_fill_2
X_08368_ _08368_/Y _08368_/A _08368_/B VPWR VGND sg13cmos5l_nand2_1
X_08299_ _08299_/Y _08299_/A _08299_/B VPWR VGND sg13cmos5l_nor2_1
X_07319_ _07319_/Y _11532_/Q _08689_/A VPWR VGND sg13cmos5l_nand2_1
XFILLER_106_910 VPWR VGND sg13cmos5l_decap_8
X_10330_ _10338_/B _10329_/Y _10330_/B _10330_/C VPWR VGND sg13cmos5l_nand3b_1
XFILLER_3_503 VPWR VGND sg13cmos5l_decap_4
X_10261_ _10261_/Y _10261_/A _10261_/B _10261_/C VPWR VGND sg13cmos5l_nand3_1
XFILLER_3_536 VPWR VGND sg13cmos5l_fill_2
XFILLER_106_987 VPWR VGND sg13cmos5l_decap_8
XFILLER_79_816 VPWR VGND sg13cmos5l_decap_4
XFILLER_87_35 VPWR VGND sg13cmos5l_decap_8
XFILLER_79_849 VPWR VGND sg13cmos5l_fill_1
X_10192_ _10194_/A _11395_/Q _10832_/Q VPWR VGND sg13cmos5l_xnor2_1
XFILLER_59_540 VPWR VGND sg13cmos5l_decap_8
Xfanout350 _09722_/A _10026_/A VPWR VGND sg13cmos5l_buf_1
Xfanout383 _07190_/C _06879_/B VPWR VGND sg13cmos5l_buf_1
Xfanout361 _10707_/C _10682_/A VPWR VGND sg13cmos5l_buf_1
XFILLER_59_551 VPWR VGND sg13cmos5l_fill_2
Xfanout372 _09805_/A2 _09303_/Y VPWR VGND sg13cmos5l_buf_1
Xfanout394 _06476_/A _06460_/X VPWR VGND sg13cmos5l_buf_1
XFILLER_47_757 VPWR VGND sg13cmos5l_decap_8
XFILLER_19_437 VPWR VGND sg13cmos5l_decap_8
XFILLER_74_554 VPWR VGND sg13cmos5l_decap_4
XFILLER_46_289 VPWR VGND sg13cmos5l_fill_2
XFILLER_36_61 VPWR VGND sg13cmos5l_fill_2
XFILLER_34_418 VPWR VGND sg13cmos5l_fill_2
XFILLER_14_120 VPWR VGND sg13cmos5l_decap_4
XFILLER_14_131 VPWR VGND sg13cmos5l_decap_8
X_11715_ _11715_/Q _11715_/CLK _11715_/D _11715_/RESET_B VPWR VGND sg13cmos5l_dfrbpq_1
XFILLER_43_985 VPWR VGND sg13cmos5l_fill_2
XFILLER_70_793 VPWR VGND sg13cmos5l_fill_1
XFILLER_42_484 VPWR VGND sg13cmos5l_fill_1
X_11646_ _11646_/Q _11646_/CLK _11646_/D _11646_/RESET_B VPWR VGND sg13cmos5l_dfrbpq_1
X_11577_ _11577_/Q clkload25/A _11577_/D _11577_/RESET_B VPWR VGND sg13cmos5l_dfrbpq_1
Xinput14 input14/X ui_in[6] VPWR VGND sg13cmos5l_buf_1
X_10528_ _10528_/Y hold2845/X _10548_/B fanout84/X VPWR VGND sg13cmos5l_a21oi_1
X_10841__1160 _10841_/RESET_B VPWR VGND sg13cmos5l_tiehi
XFILLER_6_352 VPWR VGND sg13cmos5l_fill_2
XFILLER_7_897 VPWR VGND sg13cmos5l_fill_1
X_10459_ _10474_/A _10460_/A _10460_/B _10460_/C VPWR VGND sg13cmos5l_a21oi_1
XFILLER_97_624 VPWR VGND sg13cmos5l_decap_4
XFILLER_35_4 VPWR VGND sg13cmos5l_fill_1
XFILLER_84_307 VPWR VGND sg13cmos5l_fill_2
XFILLER_78_860 VPWR VGND sg13cmos5l_fill_2
XFILLER_38_702 VPWR VGND sg13cmos5l_fill_1
XFILLER_65_510 VPWR VGND sg13cmos5l_fill_1
XFILLER_37_245 VPWR VGND sg13cmos5l_fill_1
X_07670_ _07670_/Y _07670_/A _07702_/B VPWR VGND sg13cmos5l_nor2_1
XFILLER_92_384 VPWR VGND sg13cmos5l_decap_8
XFILLER_80_524 VPWR VGND sg13cmos5l_fill_2
XFILLER_65_587 VPWR VGND sg13cmos5l_decap_8
XFILLER_37_267 VPWR VGND sg13cmos5l_fill_1
X_06621_ _06621_/Y _06190_/Y _06400_/B _06614_/A _06192_/B VPWR VGND sg13cmos5l_a22oi_1
X_09340_ _09340_/Y _09340_/A _09340_/B VPWR VGND sg13cmos5l_xnor2_1
X_06552_ _06554_/A _06133_/B _11656_/Q _10882_/Q _06132_/B VPWR VGND sg13cmos5l_a22oi_1
X_09271_ _09273_/B _09272_/A _10033_/A _09272_/C VPWR VGND sg13cmos5l_a21o_1
X_11751__912 _11751_/RESET_B VPWR VGND sg13cmos5l_tiehi
XFILLER_34_996 VPWR VGND sg13cmos5l_fill_1
X_08222_ _08222_/Y _08222_/A _08236_/B VPWR VGND sg13cmos5l_nand2_1
XFILLER_60_281 VPWR VGND sg13cmos5l_decap_4
XFILLER_20_112 VPWR VGND sg13cmos5l_fill_1
XFILLER_21_646 VPWR VGND sg13cmos5l_fill_2
X_06483_ _06484_/B _06483_/A _06483_/B VPWR VGND sg13cmos5l_nor2_1
X_08153_ _08153_/Y _08153_/A _08153_/B VPWR VGND sg13cmos5l_nor2_1
X_08084_ _08084_/Y _08084_/A _08104_/B VPWR VGND sg13cmos5l_nand2_1
X_07104_ _11717_/D _05889_/Y _07108_/A2 _07103_/Y VPWR VGND sg13cmos5l_a21oi_1
XFILLER_106_217 VPWR VGND sg13cmos5l_decap_8
X_07035_ _07035_/Y _07034_/B _07033_/Y _07034_/Y VPWR VGND sg13cmos5l_o21ai_1
X_11679__1285 _11679_/RESET_B VPWR VGND sg13cmos5l_tiehi
XFILLER_103_968 VPWR VGND sg13cmos5l_decap_8
Xhold2700 _10688_/A _11590_/Q VPWR VGND sg13cmos5l_dlygate4sd3_1
X_08986_ _08986_/Y _09051_/A1 _08985_/Y _09030_/A1 VPWR VGND sg13cmos5l_o21ai_1
Xhold2711 hold2711/X _11401_/Q VPWR VGND sg13cmos5l_dlygate4sd3_1
Xhold2722 _09335_/A _11463_/Q VPWR VGND sg13cmos5l_dlygate4sd3_1
XFILLER_76_819 VPWR VGND sg13cmos5l_fill_1
Xhold2744 _07206_/B _11384_/Q VPWR VGND sg13cmos5l_dlygate4sd3_1
Xhold2755 _10177_/A _11393_/Q VPWR VGND sg13cmos5l_dlygate4sd3_1
Xhold2733 hold2733/X _11709_/Q VPWR VGND sg13cmos5l_dlygate4sd3_1
X_07937_ _11058_/D _08329_/A1 _07946_/B _07936_/Y VPWR VGND sg13cmos5l_o21ai_1
Xhold2766 hold2766/X _11738_/Q VPWR VGND sg13cmos5l_dlygate4sd3_1
Xhold2799 hold2799/X _11734_/Q VPWR VGND sg13cmos5l_dlygate4sd3_1
Xheichips26_RiMaX_838 uio_oe[3] VPWR VGND sg13cmos5l_tielo
Xhold2777 hold2777/X _11400_/Q VPWR VGND sg13cmos5l_dlygate4sd3_1
Xhold2788 _06203_/A _11490_/Q VPWR VGND sg13cmos5l_dlygate4sd3_1
XFILLER_28_201 VPWR VGND sg13cmos5l_decap_8
XFILLER_84_874 VPWR VGND sg13cmos5l_decap_4
X_07868_ _11024_/D _08063_/A1 _07881_/B _07867_/Y VPWR VGND sg13cmos5l_a21oi_1
X_06819_ _06819_/Y _06798_/Y _06818_/Y _06817_/Y VPWR VGND sg13cmos5l_o21ai_1
XFILLER_83_384 VPWR VGND sg13cmos5l_fill_1
XFILLER_83_373 VPWR VGND sg13cmos5l_fill_2
XFILLER_71_502 VPWR VGND sg13cmos5l_fill_1
X_07799_ _10991_/D _08518_/A1 _07820_/B _07798_/Y VPWR VGND sg13cmos5l_o21ai_1
X_09607_ _09607_/Y _11288_/Q _09607_/A2 _09606_/Y VPWR VGND sg13cmos5l_o21ai_1
X_09538_ _09538_/Y hold2827/X _09805_/A2 _09455_/B _09537_/Y VPWR VGND sg13cmos5l_a22oi_1
XFILLER_52_793 VPWR VGND sg13cmos5l_decap_8
X_09469_ _09469_/Y _09495_/A1 _09465_/X _09468_/Y VPWR VGND sg13cmos5l_o21ai_1
X_11500_ _11500_/Q clkload16/A _11500_/D _11500_/RESET_B VPWR VGND sg13cmos5l_dfrbpq_1
XFILLER_40_966 VPWR VGND sg13cmos5l_decap_8
X_11431_ _11431_/Q _11528_/CLK _11431_/D _11431_/RESET_B VPWR VGND sg13cmos5l_dfrbpq_1
XFILLER_22_52 VPWR VGND sg13cmos5l_fill_2
X_11362_ _11362_/Q _11362_/CLK _11362_/D _11362_/RESET_B VPWR VGND sg13cmos5l_dfrbpq_1
X_10313_ _10313_/Y _10330_/B _10329_/A VPWR VGND sg13cmos5l_nand2_1
XFILLER_98_56 VPWR VGND sg13cmos5l_decap_8
X_11293_ _11293_/Q clkload42/A _11293_/D _11293_/RESET_B VPWR VGND sg13cmos5l_dfrbpq_1
XFILLER_4_856 VPWR VGND sg13cmos5l_decap_4
XFILLER_106_784 VPWR VGND sg13cmos5l_decap_8
X_10244_ _10252_/C _10479_/A _10267_/B VPWR VGND sg13cmos5l_nand2_1
XFILLER_105_294 VPWR VGND sg13cmos5l_decap_8
XFILLER_67_808 VPWR VGND sg13cmos5l_fill_1
X_10175_ _10175_/Y hold2705/X _07067_/X _10166_/X hold2819/X VPWR VGND sg13cmos5l_a22oi_1
XFILLER_26_1006 VPWR VGND sg13cmos5l_fill_1
XFILLER_26_1028 VPWR VGND sg13cmos5l_fill_1
XFILLER_102_990 VPWR VGND sg13cmos5l_decap_8
Xfanout191 _08431_/B _08435_/B VPWR VGND sg13cmos5l_buf_1
Xfanout180 _08563_/B _08555_/B VPWR VGND sg13cmos5l_buf_1
XFILLER_90_800 VPWR VGND sg13cmos5l_fill_1
XFILLER_47_554 VPWR VGND sg13cmos5l_decap_8
XFILLER_47_543 VPWR VGND sg13cmos5l_fill_2
XFILLER_19_245 VPWR VGND sg13cmos5l_decap_8
X_11742__1196 _11742_/RESET_B VPWR VGND sg13cmos5l_tiehi
X_11437__1416 _11437_/RESET_B VPWR VGND sg13cmos5l_tiehi
X_11488__1207 _11488_/RESET_B VPWR VGND sg13cmos5l_tiehi
XFILLER_15_495 VPWR VGND sg13cmos5l_fill_1
X_11629_ _11629_/Q _11713_/CLK _11629_/D _11629_/RESET_B VPWR VGND sg13cmos5l_dfrbpq_1
XFILLER_8_54 VPWR VGND sg13cmos5l_fill_1
X_11004__978 _11004_/RESET_B VPWR VGND sg13cmos5l_tiehi
XFILLER_7_683 VPWR VGND sg13cmos5l_fill_2
X_10800__937 _10800_/RESET_B VPWR VGND sg13cmos5l_tiehi
XFILLER_98_922 VPWR VGND sg13cmos5l_fill_2
XFILLER_40_2 VPWR VGND sg13cmos5l_fill_1
XFILLER_98_944 VPWR VGND sg13cmos5l_decap_4
XFILLER_97_443 VPWR VGND sg13cmos5l_fill_1
X_08840_ _08842_/B _08841_/A _08841_/B VPWR VGND sg13cmos5l_nor2_1
Xhold2007 _07834_/A _11009_/Q VPWR VGND sg13cmos5l_dlygate4sd3_1
Xhold2018 _06965_/A _11651_/Q VPWR VGND sg13cmos5l_dlygate4sd3_1
Xhold2029 _08484_/A _11327_/Q VPWR VGND sg13cmos5l_dlygate4sd3_1
XFILLER_85_616 VPWR VGND sg13cmos5l_decap_4
X_08771_ _09150_/B _08771_/A _08771_/B VPWR VGND sg13cmos5l_nand2_1
X_05983_ _05983_/Y _11333_/Q VPWR VGND sg13cmos5l_inv_1
X_07722_ _07722_/Y _07722_/A _07780_/B VPWR VGND sg13cmos5l_nor2_1
XFILLER_66_841 VPWR VGND sg13cmos5l_fill_1
XFILLER_65_340 VPWR VGND sg13cmos5l_decap_4
X_07653_ _10921_/D _07648_/B fanout49/X _07648_/Y VPWR VGND sg13cmos5l_a21oi_1
XFILLER_81_811 VPWR VGND sg13cmos5l_fill_2
XFILLER_26_716 VPWR VGND sg13cmos5l_decap_8
XFILLER_80_321 VPWR VGND sg13cmos5l_decap_8
X_06604_ _06605_/B _06604_/A _06604_/B VPWR VGND sg13cmos5l_or2_1
X_09323_ _09323_/X _09944_/A _09323_/B VPWR VGND sg13cmos5l_and2_1
X_07584_ _07584_/X _07584_/A _07584_/B VPWR VGND sg13cmos5l_and2_1
XFILLER_43_18 VPWR VGND sg13cmos5l_fill_1
XFILLER_34_760 VPWR VGND sg13cmos5l_decap_8
X_06535_ _06536_/B _06571_/A1 _11666_/Q _10860_/Q _06574_/B2 VPWR VGND sg13cmos5l_a22oi_1
XFILLER_34_782 VPWR VGND sg13cmos5l_fill_2
XFILLER_34_793 VPWR VGND sg13cmos5l_fill_2
X_09254_ _09259_/A _09862_/A _09862_/B _09254_/C _09254_/D VPWR VGND sg13cmos5l_nand4_1
X_06466_ _06476_/B _06466_/A _06467_/B VPWR VGND sg13cmos5l_nor2b_1
XFILLER_21_454 VPWR VGND sg13cmos5l_decap_8
X_09185_ _09185_/Y _10180_/B _10830_/Q VPWR VGND sg13cmos5l_nor2_1
XFILLER_21_498 VPWR VGND sg13cmos5l_fill_1
XFILLER_22_999 VPWR VGND sg13cmos5l_fill_2
X_08205_ _11189_/D _08530_/A1 _08220_/B _08204_/Y VPWR VGND sg13cmos5l_o21ai_1
X_06397_ _06397_/X _11622_/Q _11609_/Q VPWR VGND sg13cmos5l_or2_1
XFILLER_5_609 VPWR VGND sg13cmos5l_fill_1
X_08136_ _11155_/D _08331_/A1 _08135_/B _08135_/Y VPWR VGND sg13cmos5l_a21oi_1
XFILLER_104_7 VPWR VGND sg13cmos5l_decap_8
X_08067_ _11122_/D _08329_/A1 _08076_/B _08066_/Y VPWR VGND sg13cmos5l_o21ai_1
XFILLER_68_26 VPWR VGND sg13cmos5l_decap_4
X_07018_ _07018_/Y _07018_/A _07018_/B VPWR VGND sg13cmos5l_nand2_1
XFILLER_89_955 VPWR VGND sg13cmos5l_decap_8
XFILLER_89_944 VPWR VGND sg13cmos5l_fill_1
XFILLER_0_325 VPWR VGND sg13cmos5l_fill_2
XFILLER_1_859 VPWR VGND sg13cmos5l_decap_8
XFILLER_102_231 VPWR VGND sg13cmos5l_decap_8
Xhold2530 _06857_/A _11619_/Q VPWR VGND sg13cmos5l_dlygate4sd3_1
XFILLER_0_369 VPWR VGND sg13cmos5l_fill_2
XFILLER_102_297 VPWR VGND sg13cmos5l_fill_1
Xhold2563 hold2563/X _11578_/Q VPWR VGND sg13cmos5l_dlygate4sd3_1
Xhold2574 _11627_/D _06885_/X VPWR VGND sg13cmos5l_dlygate4sd3_1
X_08969_ _09022_/A _11632_/Q _08973_/A VPWR VGND sg13cmos5l_xor2_1
Xhold2552 _07359_/A _10877_/Q VPWR VGND sg13cmos5l_dlygate4sd3_1
Xhold2541 _10879_/D _07372_/Y VPWR VGND sg13cmos5l_dlygate4sd3_1
Xhold1840 _08486_/A _11328_/Q VPWR VGND sg13cmos5l_dlygate4sd3_1
Xhold1851 _06843_/A _11614_/Q VPWR VGND sg13cmos5l_dlygate4sd3_1
XFILLER_84_14 VPWR VGND sg13cmos5l_decap_8
Xhold2585 hold2585/X _11693_/Q VPWR VGND sg13cmos5l_dlygate4sd3_1
Xhold1862 _08060_/A _11119_/Q VPWR VGND sg13cmos5l_dlygate4sd3_1
XFILLER_17_705 VPWR VGND sg13cmos5l_fill_1
Xhold2596 hold2596/X _11653_/Q VPWR VGND sg13cmos5l_dlygate4sd3_1
XFILLER_29_543 VPWR VGND sg13cmos5l_decap_4
XFILLER_72_833 VPWR VGND sg13cmos5l_fill_2
Xhold1884 _08452_/A _11311_/Q VPWR VGND sg13cmos5l_dlygate4sd3_1
X_10931_ _10931_/Q clkload17/A _10931_/D _10931_/RESET_B VPWR VGND sg13cmos5l_dfrbpq_1
Xhold1895 _08474_/A _11322_/Q VPWR VGND sg13cmos5l_dlygate4sd3_1
Xhold1873 _08466_/A _11318_/Q VPWR VGND sg13cmos5l_dlygate4sd3_1
XFILLER_44_546 VPWR VGND sg13cmos5l_fill_1
XFILLER_17_96 VPWR VGND sg13cmos5l_decap_4
X_10862_ _10862_/Q clkload7/A _10862_/D _10862_/RESET_B VPWR VGND sg13cmos5l_dfrbpq_1
XFILLER_25_760 VPWR VGND sg13cmos5l_fill_2
X_10793_ _10793_/Q clkload30/A _10793_/D _10793_/RESET_B VPWR VGND sg13cmos5l_dfrbpq_1
XFILLER_24_270 VPWR VGND sg13cmos5l_decap_4
XFILLER_13_999 VPWR VGND sg13cmos5l_decap_8
X_11414_ _11414_/Q clkload55/A _11414_/D _11414_/RESET_B VPWR VGND sg13cmos5l_dfrbpq_1
XFILLER_8_469 VPWR VGND sg13cmos5l_decap_8
X_11136__1765 _11136_/RESET_B VPWR VGND sg13cmos5l_tiehi
X_11345_ _11345_/Q clkload38/A _11345_/D _11345_/RESET_B VPWR VGND sg13cmos5l_dfrbpq_1
X_11276_ _11276_/Q clkload39/A _11276_/D _11276_/RESET_B VPWR VGND sg13cmos5l_dfrbpq_1
XFILLER_106_581 VPWR VGND sg13cmos5l_decap_8
X_11594__1419 _11594_/RESET_B VPWR VGND sg13cmos5l_tiehi
XFILLER_79_421 VPWR VGND sg13cmos5l_decap_4
X_10227_ _10227_/Y hold2645/X _07067_/X _10166_/X hold2766/X VPWR VGND sg13cmos5l_a22oi_1
XFILLER_95_936 VPWR VGND sg13cmos5l_decap_8
X_10158_ _10158_/Y _05894_/Y _10158_/A2 _10157_/Y VPWR VGND sg13cmos5l_o21ai_1
XFILLER_79_487 VPWR VGND sg13cmos5l_fill_2
XFILLER_67_649 VPWR VGND sg13cmos5l_decap_8
XFILLER_67_638 VPWR VGND sg13cmos5l_fill_2
XFILLER_39_329 VPWR VGND sg13cmos5l_decap_8
XFILLER_94_446 VPWR VGND sg13cmos5l_fill_1
XFILLER_12_6 VPWR VGND sg13cmos5l_fill_1
X_11351__1550 _11351_/RESET_B VPWR VGND sg13cmos5l_tiehi
X_10089_ _10089_/Y _10356_/A1 _10840_/Q _10092_/B1 VPWR VGND sg13cmos5l_o21ai_1
XFILLER_75_660 VPWR VGND sg13cmos5l_fill_1
XFILLER_47_395 VPWR VGND sg13cmos5l_fill_1
XFILLER_35_535 VPWR VGND sg13cmos5l_decap_4
XFILLER_90_685 VPWR VGND sg13cmos5l_fill_1
XFILLER_90_663 VPWR VGND sg13cmos5l_fill_1
XFILLER_50_505 VPWR VGND sg13cmos5l_fill_1
XFILLER_35_579 VPWR VGND sg13cmos5l_decap_4
X_06320_ _06389_/C _06240_/A _06709_/C _06319_/Y VPWR VGND sg13cmos5l_o21ai_1
XFILLER_90_90 VPWR VGND sg13cmos5l_fill_2
X_06251_ _06421_/B _06251_/A _09264_/A VPWR VGND sg13cmos5l_nor2_1
XFILLER_30_262 VPWR VGND sg13cmos5l_decap_8
XFILLER_30_273 VPWR VGND sg13cmos5l_fill_2
Xclkbuf_4_4_0_clk clkbuf_4_4_0_clk/X clkbuf_0_clk/X VPWR VGND sg13cmos5l_buf_8
XFILLER_8_970 VPWR VGND sg13cmos5l_decap_8
X_06182_ _06605_/A _06610_/B _06182_/B VPWR VGND sg13cmos5l_and2_1
XFILLER_89_229 VPWR VGND sg13cmos5l_decap_4
X_09941_ _09942_/B _09998_/A _09941_/B VPWR VGND sg13cmos5l_nand2_1
X_09872_ _09872_/Y _11074_/Q _09986_/B VPWR VGND sg13cmos5l_nand2_1
XFILLER_86_914 VPWR VGND sg13cmos5l_fill_1
XFILLER_58_649 VPWR VGND sg13cmos5l_decap_4
X_08823_ _08841_/B _08852_/A _08852_/D VPWR VGND sg13cmos5l_nor2_1
XFILLER_38_29 VPWR VGND sg13cmos5l_decap_4
X_10925__1057 _10925_/RESET_B VPWR VGND sg13cmos5l_tiehi
XFILLER_100_768 VPWR VGND sg13cmos5l_decap_8
X_08754_ _08755_/B _08762_/A _08754_/B VPWR VGND sg13cmos5l_nand2_1
X_05966_ _05966_/Y _11319_/Q VPWR VGND sg13cmos5l_inv_1
X_07705_ _10946_/D fanout64/X _07704_/B _07704_/Y VPWR VGND sg13cmos5l_a21oi_1
XFILLER_39_885 VPWR VGND sg13cmos5l_fill_1
X_05897_ _09882_/A _09264_/A VPWR VGND sg13cmos5l_inv_1
XFILLER_54_855 VPWR VGND sg13cmos5l_fill_1
XFILLER_38_395 VPWR VGND sg13cmos5l_decap_8
X_08685_ _08686_/B _08689_/A _08685_/B VPWR VGND sg13cmos5l_nand2_1
X_07636_ _07636_/Y _11421_/Q _10653_/A _07643_/D VPWR VGND sg13cmos5l_nand3_1
XFILLER_53_343 VPWR VGND sg13cmos5l_decap_8
XFILLER_80_184 VPWR VGND sg13cmos5l_decap_8
X_11214__1687 _11214_/RESET_B VPWR VGND sg13cmos5l_tiehi
X_07567_ _10908_/D _07566_/B fanout80/X _07566_/Y VPWR VGND sg13cmos5l_a21oi_1
X_09306_ _09306_/Y _09944_/A _09305_/B _09270_/A VPWR VGND sg13cmos5l_a21oi_1
X_06518_ _06518_/Y _11342_/Q _09491_/S VPWR VGND sg13cmos5l_nand2_1
XFILLER_16_1005 VPWR VGND sg13cmos5l_decap_8
XFILLER_70_49 VPWR VGND sg13cmos5l_decap_8
X_09237_ _09242_/A _09649_/A _09237_/B VPWR VGND sg13cmos5l_nor2_1
X_07498_ _07499_/B _05860_/Y _11528_/Q _07497_/X VPWR VGND sg13cmos5l_a21oi_1
X_11421__1448 _11421_/RESET_B VPWR VGND sg13cmos5l_tiehi
X_06449_ _06451_/A _10161_/B _11630_/Q VPWR VGND sg13cmos5l_nor2_1
XFILLER_6_918 VPWR VGND sg13cmos5l_decap_4
X_09168_ _09244_/A _09168_/A _09168_/B VPWR VGND sg13cmos5l_nor2_1
XFILLER_5_406 VPWR VGND sg13cmos5l_fill_1
X_08119_ _08119_/Y _08119_/A _08169_/B VPWR VGND sg13cmos5l_nor2_1
X_09099_ _09099_/Y _09120_/A _09098_/Y _09104_/A VPWR VGND sg13cmos5l_o21ai_1
X_11472__1239 _11472_/RESET_B VPWR VGND sg13cmos5l_tiehi
X_11130_ _11130_/Q clkload41/A _11130_/D _11130_/RESET_B VPWR VGND sg13cmos5l_dfrbpq_1
XFILLER_1_612 VPWR VGND sg13cmos5l_fill_2
XFILLER_62_1014 VPWR VGND sg13cmos5l_decap_8
X_11061_ _11061_/Q _11349_/CLK _11061_/D _11061_/RESET_B VPWR VGND sg13cmos5l_dfrbpq_1
XFILLER_95_35 VPWR VGND sg13cmos5l_decap_8
X_10012_ _10012_/Y _11015_/Q _10012_/B VPWR VGND sg13cmos5l_nand2_1
XFILLER_76_435 VPWR VGND sg13cmos5l_fill_2
XFILLER_88_295 VPWR VGND sg13cmos5l_decap_8
XFILLER_48_137 VPWR VGND sg13cmos5l_fill_2
Xhold2360 _07305_/A _10868_/Q VPWR VGND sg13cmos5l_dlygate4sd3_1
Xhold2382 _08513_/A _11341_/Q VPWR VGND sg13cmos5l_dlygate4sd3_1
Xhold2371 _07329_/A _10872_/Q VPWR VGND sg13cmos5l_dlygate4sd3_1
Xhold2393 _08291_/A _11232_/Q VPWR VGND sg13cmos5l_dlygate4sd3_1
XFILLER_28_51 VPWR VGND sg13cmos5l_decap_4
X_10914_ _10914_/Q _11362_/CLK _10914_/D _10914_/RESET_B VPWR VGND sg13cmos5l_dfrbpq_1
XFILLER_60_814 VPWR VGND sg13cmos5l_decap_8
XFILLER_45_866 VPWR VGND sg13cmos5l_decap_4
X_10845_ _10845_/Q clkload36/A _10845_/D _10845_/RESET_B VPWR VGND sg13cmos5l_dfrbpq_1
XFILLER_32_549 VPWR VGND sg13cmos5l_fill_2
XFILLER_44_72 VPWR VGND sg13cmos5l_decap_4
X_10776_ _10776_/Y _10776_/A _10776_/B VPWR VGND sg13cmos5l_nand2_1
XFILLER_12_251 VPWR VGND sg13cmos5l_decap_8
XFILLER_13_796 VPWR VGND sg13cmos5l_decap_8
XFILLER_74_8 VPWR VGND sg13cmos5l_fill_1
X_11674__1290 _11674_/RESET_B VPWR VGND sg13cmos5l_tiehi
X_11369__1532 _11369_/RESET_B VPWR VGND sg13cmos5l_tiehi
XFILLER_60_60 VPWR VGND sg13cmos5l_fill_2
X_11328_ _11328_/Q clkload56/A _11328_/D _11328_/RESET_B VPWR VGND sg13cmos5l_dfrbpq_1
X_11551__1471 _11551_/RESET_B VPWR VGND sg13cmos5l_tiehi
XFILLER_68_903 VPWR VGND sg13cmos5l_fill_1
X_11259_ _11259_/Q clkload55/A _11259_/D _11259_/RESET_B VPWR VGND sg13cmos5l_dfrbpq_1
XFILLER_79_295 VPWR VGND sg13cmos5l_decap_8
XFILLER_95_788 VPWR VGND sg13cmos5l_decap_8
XFILLER_54_129 VPWR VGND sg13cmos5l_decap_8
XFILLER_36_833 VPWR VGND sg13cmos5l_decap_4
XFILLER_91_961 VPWR VGND sg13cmos5l_fill_1
XFILLER_51_814 VPWR VGND sg13cmos5l_decap_8
XFILLER_47_192 VPWR VGND sg13cmos5l_fill_1
XFILLER_36_888 VPWR VGND sg13cmos5l_decap_8
XFILLER_36_866 VPWR VGND sg13cmos5l_decap_4
XFILLER_35_365 VPWR VGND sg13cmos5l_fill_2
XFILLER_35_354 VPWR VGND sg13cmos5l_decap_8
XFILLER_23_505 VPWR VGND sg13cmos5l_decap_4
X_08470_ _08470_/Y _08470_/A _08470_/B VPWR VGND sg13cmos5l_nand2_1
X_07421_ _07421_/Y _11549_/Q _08762_/A VPWR VGND sg13cmos5l_nand2_1
XFILLER_36_899 VPWR VGND sg13cmos5l_fill_2
XFILLER_93_0 VPWR VGND sg13cmos5l_decap_8
X_07352_ _07352_/Y _10295_/A _07376_/A2 _07351_/Y VPWR VGND sg13cmos5l_a21oi_1
XFILLER_50_368 VPWR VGND sg13cmos5l_decap_8
X_06303_ _06303_/Y _06160_/A _06302_/Y _06300_/Y VPWR VGND sg13cmos5l_o21ai_1
XFILLER_31_560 VPWR VGND sg13cmos5l_fill_1
X_10806__943 _10806_/RESET_B VPWR VGND sg13cmos5l_tiehi
X_07283_ _07283_/Y _11526_/Q _08667_/S VPWR VGND sg13cmos5l_nand2_1
X_09022_ _09070_/A _09022_/A _09022_/B _09022_/C VPWR VGND sg13cmos5l_nand3_1
X_06234_ _06709_/A _06234_/A _06233_/X VPWR VGND sg13cmos5l_nor2b_1
X_06165_ _06168_/A _11497_/Q _09202_/A VPWR VGND sg13cmos5l_and2_1
XFILLER_105_816 VPWR VGND sg13cmos5l_decap_8
X_06096_ _06096_/Y input20/X hold2293/X VPWR VGND sg13cmos5l_nor2b_1
X_09924_ _09924_/Y _10916_/Q _09934_/B _10015_/B1 VPWR VGND sg13cmos5l_a21oi_1
Xfanout724 _07651_/S _11557_/Q VPWR VGND sg13cmos5l_buf_1
Xfanout713 _09051_/A1 _09063_/A1 VPWR VGND sg13cmos5l_buf_1
Xfanout702 _06679_/A _06441_/A1 VPWR VGND sg13cmos5l_buf_1
Xfanout746 _09968_/A _11482_/Q VPWR VGND sg13cmos5l_buf_1
X_09855_ _09855_/Y _09909_/A _09885_/B _09910_/A VPWR VGND sg13cmos5l_o21ai_1
XFILLER_58_424 VPWR VGND sg13cmos5l_fill_1
Xfanout757 _10424_/A _11477_/Q VPWR VGND sg13cmos5l_buf_1
Xfanout735 _10434_/B _11506_/Q VPWR VGND sg13cmos5l_buf_1
XFILLER_105_56 VPWR VGND sg13cmos5l_decap_8
X_08806_ _08806_/Y _08817_/C _08806_/B VPWR VGND sg13cmos5l_xnor2_1
Xfanout768 _10462_/A _11473_/Q VPWR VGND sg13cmos5l_buf_1
Xfanout779 _09507_/A hold2928/X VPWR VGND sg13cmos5l_buf_1
X_09786_ _09786_/Y _11135_/Q _09823_/B _09990_/S1 VPWR VGND sg13cmos5l_a21oi_1
XFILLER_39_660 VPWR VGND sg13cmos5l_fill_2
X_06998_ _06998_/Y _11501_/Q _07006_/A _07006_/B _10073_/A VPWR VGND sg13cmos5l_a22oi_1
X_05949_ _06139_/A _05949_/A VPWR VGND sg13cmos5l_inv_1
X_08737_ _08738_/B _08750_/A _08737_/B VPWR VGND sg13cmos5l_nand2_1
XFILLER_54_630 VPWR VGND sg13cmos5l_decap_4
Xclkbuf_leaf_65_clk clkload15/A clkbuf_4_2_0_clk/X VPWR VGND sg13cmos5l_buf_8
XFILLER_92_1007 VPWR VGND sg13cmos5l_fill_1
XFILLER_82_950 VPWR VGND sg13cmos5l_decap_8
X_08668_ _08852_/A _08827_/B VPWR VGND sg13cmos5l_inv_1
XFILLER_26_332 VPWR VGND sg13cmos5l_fill_2
XFILLER_81_482 VPWR VGND sg13cmos5l_decap_8
X_07619_ _07619_/Y _07638_/A _07619_/B VPWR VGND sg13cmos5l_nor2_1
XFILLER_26_376 VPWR VGND sg13cmos5l_fill_2
X_08599_ _08599_/X _11243_/Q _11211_/Q _11179_/Q _11147_/Q _08588_/B _08599_/S1 VPWR
+ VGND sg13cmos5l_mux4_1
X_11593__1407 _11593_/RESET_B VPWR VGND sg13cmos5l_tiehi
XFILLER_81_37 VPWR VGND sg13cmos5l_decap_4
X_10630_ _10630_/Y _10654_/A _10630_/B _10630_/C _10630_/D VPWR VGND sg13cmos5l_nand4_1
XFILLER_41_368 VPWR VGND sg13cmos5l_decap_8
XFILLER_22_560 VPWR VGND sg13cmos5l_decap_8
X_10561_ _10573_/A _11415_/Q _10852_/Q VPWR VGND sg13cmos5l_nand2_1
X_10492_ _10506_/C _10287_/A _10423_/B _10479_/B VPWR VGND sg13cmos5l_o21ai_1
X_11113_ _11113_/Q clkload50/A _11113_/D _11113_/RESET_B VPWR VGND sg13cmos5l_dfrbpq_1
XFILLER_2_976 VPWR VGND sg13cmos5l_decap_8
X_11044_ _11044_/Q _11339_/CLK _11044_/D _11044_/RESET_B VPWR VGND sg13cmos5l_dfrbpq_1
XFILLER_7_1014 VPWR VGND sg13cmos5l_decap_8
XFILLER_65_906 VPWR VGND sg13cmos5l_fill_2
XFILLER_1_497 VPWR VGND sg13cmos5l_decap_8
Xhold2190 _07764_/A _10975_/Q VPWR VGND sg13cmos5l_dlygate4sd3_1
XFILLER_91_202 VPWR VGND sg13cmos5l_decap_8
XFILLER_76_276 VPWR VGND sg13cmos5l_decap_8
XFILLER_65_917 VPWR VGND sg13cmos5l_fill_1
XFILLER_49_468 VPWR VGND sg13cmos5l_decap_4
X_11398__1494 _11398_/RESET_B VPWR VGND sg13cmos5l_tiehi
Xclkbuf_leaf_56_clk _11361_/CLK clkbuf_4_10_0_clk/X VPWR VGND sg13cmos5l_buf_8
XFILLER_45_652 VPWR VGND sg13cmos5l_decap_4
XFILLER_45_696 VPWR VGND sg13cmos5l_fill_1
XFILLER_44_151 VPWR VGND sg13cmos5l_fill_2
XFILLER_33_825 VPWR VGND sg13cmos5l_decap_8
XFILLER_60_633 VPWR VGND sg13cmos5l_decap_8
XFILLER_44_195 VPWR VGND sg13cmos5l_decap_8
X_10828_ _10828_/Q _11339_/CLK _10828_/D _10828_/RESET_B VPWR VGND sg13cmos5l_dfrbpq_1
XFILLER_60_677 VPWR VGND sg13cmos5l_decap_4
XFILLER_20_508 VPWR VGND sg13cmos5l_fill_1
XFILLER_20_519 VPWR VGND sg13cmos5l_decap_8
XFILLER_32_379 VPWR VGND sg13cmos5l_fill_2
X_10759_ _10759_/Y _06139_/A _10760_/S _10758_/Y VPWR VGND sg13cmos5l_a21oi_1
XFILLER_9_520 VPWR VGND sg13cmos5l_decap_8
XFILLER_13_582 VPWR VGND sg13cmos5l_decap_4
X_07970_ _07970_/Y _07970_/A _07982_/B VPWR VGND sg13cmos5l_nand2_1
X_06921_ _06940_/D _11690_/D _11689_/D VPWR VGND sg13cmos5l_nor2_1
X_06852_ _06852_/Y _06832_/A _06851_/Y _06850_/Y VPWR VGND sg13cmos5l_o21ai_1
X_09640_ _09647_/B _09745_/A _09640_/B VPWR VGND sg13cmos5l_nor2_1
XFILLER_83_747 VPWR VGND sg13cmos5l_decap_4
X_06783_ _06783_/Y _10739_/A _07202_/C VPWR VGND sg13cmos5l_nor2_1
XFILLER_82_235 VPWR VGND sg13cmos5l_decap_8
X_09571_ _09571_/Y _10903_/Q _09576_/B _09577_/B1 VPWR VGND sg13cmos5l_a21oi_1
XFILLER_71_909 VPWR VGND sg13cmos5l_fill_2
Xclkbuf_leaf_47_clk clkload37/A clkload3/A VPWR VGND sg13cmos5l_buf_8
X_08522_ _11345_/D _08522_/A1 _08543_/B _08521_/Y VPWR VGND sg13cmos5l_a21oi_1
X_08453_ _11311_/D _08453_/A1 _08470_/B _08452_/Y VPWR VGND sg13cmos5l_o21ai_1
XFILLER_35_162 VPWR VGND sg13cmos5l_fill_1
X_07404_ _08755_/A _09093_/A _07416_/B VPWR VGND sg13cmos5l_nand2_1
XFILLER_23_324 VPWR VGND sg13cmos5l_fill_2
XFILLER_23_346 VPWR VGND sg13cmos5l_fill_2
X_11461__1350 _11461_/RESET_B VPWR VGND sg13cmos5l_tiehi
XFILLER_35_195 VPWR VGND sg13cmos5l_decap_8
X_08384_ _11277_/D _08384_/A1 _08401_/B _08383_/Y VPWR VGND sg13cmos5l_a21oi_1
X_11095__1806 _11095_/RESET_B VPWR VGND sg13cmos5l_tiehi
XFILLER_23_368 VPWR VGND sg13cmos5l_decap_4
X_11131__1770 _11131_/RESET_B VPWR VGND sg13cmos5l_tiehi
X_07335_ _07335_/Y _07335_/A _07425_/B VPWR VGND sg13cmos5l_nor2_1
X_07266_ _07266_/Y _11427_/Q _07296_/B VPWR VGND sg13cmos5l_nand2_1
X_09005_ _09020_/B _09043_/A _09036_/A VPWR VGND sg13cmos5l_nor2_1
X_06217_ _10270_/A _10267_/B _10267_/C VPWR VGND sg13cmos5l_and2_1
X_07197_ _07197_/X _07197_/A _07202_/C VPWR VGND sg13cmos5l_and2_1
XFILLER_105_635 VPWR VGND sg13cmos5l_decap_8
XFILLER_104_112 VPWR VGND sg13cmos5l_decap_8
X_06148_ _06160_/A _06690_/A VPWR VGND sg13cmos5l_inv_1
X_06079_ _11753_/D _06093_/A _10688_/B VPWR VGND sg13cmos5l_nor2_1
XFILLER_104_189 VPWR VGND sg13cmos5l_decap_8
X_09907_ _09908_/C _09898_/Y _09900_/X _09906_/Y VPWR VGND sg13cmos5l_o21ai_1
Xfanout521 _07652_/A1 _07443_/Y VPWR VGND sg13cmos5l_buf_1
Xfanout532 _07362_/B _07416_/B VPWR VGND sg13cmos5l_buf_1
Xfanout510 _08936_/B fanout518/X VPWR VGND sg13cmos5l_buf_1
Xfanout543 _08750_/A _08770_/A VPWR VGND sg13cmos5l_buf_1
Xfanout565 _07182_/C1 _07212_/A2 VPWR VGND sg13cmos5l_buf_1
XFILLER_59_755 VPWR VGND sg13cmos5l_decap_8
Xfanout554 _07262_/A2 _06948_/Y VPWR VGND sg13cmos5l_buf_1
XFILLER_100_351 VPWR VGND sg13cmos5l_fill_1
XFILLER_100_340 VPWR VGND sg13cmos5l_fill_2
XFILLER_86_574 VPWR VGND sg13cmos5l_decap_8
Xfanout576 _06401_/D _06399_/X VPWR VGND sg13cmos5l_buf_1
Xfanout587 _06722_/B _06757_/B VPWR VGND sg13cmos5l_buf_1
XFILLER_76_59 VPWR VGND sg13cmos5l_fill_1
Xfanout598 _07120_/A2 _07122_/A2 VPWR VGND sg13cmos5l_buf_1
X_09838_ _09839_/C _09837_/B _09837_/C _09837_/A VPWR VGND sg13cmos5l_a21o_1
XFILLER_46_416 VPWR VGND sg13cmos5l_decap_4
X_09769_ _09769_/Y _11326_/Q _09986_/B VPWR VGND sg13cmos5l_nand2b_1
XFILLER_92_14 VPWR VGND sg13cmos5l_decap_8
Xclkbuf_leaf_38_clk _11362_/CLK clkload6/A VPWR VGND sg13cmos5l_buf_8
XFILLER_39_490 VPWR VGND sg13cmos5l_decap_4
XFILLER_27_641 VPWR VGND sg13cmos5l_decap_8
XFILLER_27_652 VPWR VGND sg13cmos5l_fill_2
XFILLER_82_780 VPWR VGND sg13cmos5l_decap_8
XFILLER_42_622 VPWR VGND sg13cmos5l_decap_8
XFILLER_42_600 VPWR VGND sg13cmos5l_fill_1
X_11731_ _11731_/Q _11766_/CLK _11731_/D _11731_/RESET_B VPWR VGND sg13cmos5l_dfrbpq_1
X_11662_ _11662_/Q clkload7/A _11662_/D _11662_/RESET_B VPWR VGND sg13cmos5l_dfrbpq_1
XFILLER_25_96 VPWR VGND sg13cmos5l_fill_2
X_11593_ _11593_/Q _11622_/CLK _11593_/D _11593_/RESET_B VPWR VGND sg13cmos5l_dfrbpq_1
X_10613_ _10613_/X _10613_/A _10622_/C VPWR VGND sg13cmos5l_xor2_1
X_10544_ _11540_/D _10537_/Y _10541_/Y _10543_/Y VPWR VGND sg13cmos5l_a21oi_1
XFILLER_10_530 VPWR VGND sg13cmos5l_decap_4
XFILLER_10_552 VPWR VGND sg13cmos5l_fill_2
XFILLER_10_574 VPWR VGND sg13cmos5l_fill_2
X_10920__1062 _10920_/RESET_B VPWR VGND sg13cmos5l_tiehi
X_10475_ _10476_/B _10477_/A _10845_/Q _10569_/A VPWR VGND sg13cmos5l_a21oi_1
XFILLER_96_305 VPWR VGND sg13cmos5l_decap_8
XFILLER_77_541 VPWR VGND sg13cmos5l_decap_8
X_11173__1728 _11173_/RESET_B VPWR VGND sg13cmos5l_tiehi
XFILLER_65_714 VPWR VGND sg13cmos5l_fill_1
XFILLER_65_703 VPWR VGND sg13cmos5l_decap_8
X_11027_ _11027_/Q clkload8/A _11027_/D _11027_/RESET_B VPWR VGND sg13cmos5l_dfrbpq_1
Xclkbuf_leaf_29_clk clkload45/A clkbuf_4_12_0_clk/X VPWR VGND sg13cmos5l_buf_8
XFILLER_92_588 VPWR VGND sg13cmos5l_decap_4
XFILLER_33_644 VPWR VGND sg13cmos5l_decap_8
XFILLER_61_975 VPWR VGND sg13cmos5l_fill_1
XFILLER_21_828 VPWR VGND sg13cmos5l_fill_1
XANTENNA_17 _07448_/A VPWR VGND sg13cmos5l_antennanp
XFILLER_33_699 VPWR VGND sg13cmos5l_fill_2
X_07120_ _11725_/D _05881_/Y _07120_/A2 _07119_/Y VPWR VGND sg13cmos5l_a21oi_1
XFILLER_20_349 VPWR VGND sg13cmos5l_fill_2
X_07051_ _07051_/X hold2503/X _08626_/A1 _07050_/Y VPWR VGND sg13cmos5l_a21o_1
X_06002_ _06003_/C _11603_/Q _06043_/C _06014_/C VPWR VGND sg13cmos5l_o21ai_1
X_11517__1149 _11517_/RESET_B VPWR VGND sg13cmos5l_tiehi
XFILLER_102_605 VPWR VGND sg13cmos5l_decap_8
XFILLER_99_165 VPWR VGND sg13cmos5l_decap_8
XFILLER_88_828 VPWR VGND sg13cmos5l_decap_4
Xhold2904 _11517_/D _10155_/X VPWR VGND sg13cmos5l_dlygate4sd3_1
XFILLER_101_126 VPWR VGND sg13cmos5l_decap_8
Xhold2926 _10656_/A _11485_/Q VPWR VGND sg13cmos5l_dlygate4sd3_1
Xhold2948 _10605_/B _10855_/Q VPWR VGND sg13cmos5l_dlygate4sd3_1
Xhold2937 _05903_/A _11479_/Q VPWR VGND sg13cmos5l_dlygate4sd3_1
Xhold2915 hold2915/X _11395_/Q VPWR VGND sg13cmos5l_dlygate4sd3_1
X_07953_ _11066_/D fanout97/X _07958_/B _07952_/Y VPWR VGND sg13cmos5l_o21ai_1
X_06904_ _07185_/A _11590_/Q _11638_/Q _11644_/Q VPWR VGND sg13cmos5l_or3_1
XFILLER_56_714 VPWR VGND sg13cmos5l_fill_2
X_07884_ _11032_/D _08536_/A1 _07883_/B _07883_/Y VPWR VGND sg13cmos5l_a21oi_1
X_06835_ _06835_/Y _06840_/A _06835_/B VPWR VGND sg13cmos5l_nor2_1
XFILLER_55_224 VPWR VGND sg13cmos5l_fill_2
X_11149__1752 _11149_/RESET_B VPWR VGND sg13cmos5l_tiehi
X_09623_ _09623_/Y _11001_/Q _09630_/B VPWR VGND sg13cmos5l_nand2_1
XFILLER_71_706 VPWR VGND sg13cmos5l_decap_8
XFILLER_37_950 VPWR VGND sg13cmos5l_decap_8
XFILLER_102_35 VPWR VGND sg13cmos5l_decap_8
X_06766_ _06766_/Y _06266_/Y _06385_/C _06269_/B VPWR VGND sg13cmos5l_a21oi_1
XFILLER_37_972 VPWR VGND sg13cmos5l_fill_2
X_09554_ _09554_/Y _11286_/Q _09607_/A2 _09553_/Y VPWR VGND sg13cmos5l_o21ai_1
X_08505_ _11337_/D fanout49/X _08504_/B _08504_/Y VPWR VGND sg13cmos5l_o21ai_1
XFILLER_36_493 VPWR VGND sg13cmos5l_decap_8
XFILLER_36_482 VPWR VGND sg13cmos5l_fill_2
X_06697_ _06698_/B _06709_/C _06368_/Y _06760_/S VPWR VGND sg13cmos5l_mux2_1
X_09485_ _11465_/D _09378_/A _09540_/A _09464_/Y _09484_/Y VPWR VGND sg13cmos5l_a22oi_1
X_08436_ _11303_/D fanout53/X _08435_/B _08435_/Y VPWR VGND sg13cmos5l_a21oi_1
XFILLER_52_986 VPWR VGND sg13cmos5l_fill_1
XFILLER_51_463 VPWR VGND sg13cmos5l_fill_2
XFILLER_51_441 VPWR VGND sg13cmos5l_fill_2
XFILLER_24_677 VPWR VGND sg13cmos5l_decap_4
X_08367_ _11269_/D fanout58/X _08366_/B _08366_/Y VPWR VGND sg13cmos5l_o21ai_1
XFILLER_11_349 VPWR VGND sg13cmos5l_fill_1
X_07318_ _07318_/Y _07317_/B _07316_/Y hold2445/X VPWR VGND sg13cmos5l_a21oi_1
X_08298_ _11235_/D fanout61/X _08307_/B _08297_/Y VPWR VGND sg13cmos5l_a21oi_1
X_07249_ _07249_/Y _10859_/Q _10770_/S _07249_/B1 _06831_/B VPWR VGND sg13cmos5l_a22oi_1
XFILLER_11_21 VPWR VGND sg13cmos5l_decap_8
X_11571__1397 _11571_/RESET_B VPWR VGND sg13cmos5l_tiehi
X_11553__1463 _11553_/RESET_B VPWR VGND sg13cmos5l_tiehi
X_10260_ _10277_/A _10261_/A _10261_/B _10261_/C VPWR VGND sg13cmos5l_and3_1
XFILLER_106_966 VPWR VGND sg13cmos5l_decap_8
XFILLER_105_454 VPWR VGND sg13cmos5l_decap_8
XFILLER_87_14 VPWR VGND sg13cmos5l_decap_8
XFILLER_11_87 VPWR VGND sg13cmos5l_decap_8
XFILLER_11_98 VPWR VGND sg13cmos5l_fill_2
X_10191_ _10191_/Y _10191_/A _10832_/Q VPWR VGND sg13cmos5l_nand2_1
Xfanout340 _09851_/B2 _09608_/B1 VPWR VGND sg13cmos5l_buf_1
Xfanout373 _09911_/B _10053_/A2 VPWR VGND sg13cmos5l_buf_1
Xfanout351 _10026_/A _06086_/Y VPWR VGND sg13cmos5l_buf_1
Xfanout384 _06879_/B _06780_/Y VPWR VGND sg13cmos5l_buf_1
Xfanout362 _10682_/A _10164_/Y VPWR VGND sg13cmos5l_buf_1
XFILLER_19_405 VPWR VGND sg13cmos5l_decap_4
XFILLER_98_1024 VPWR VGND sg13cmos5l_decap_4
XFILLER_59_585 VPWR VGND sg13cmos5l_decap_8
Xfanout395 _09572_/B1 _09574_/A1 VPWR VGND sg13cmos5l_buf_1
XFILLER_4_1028 VPWR VGND sg13cmos5l_fill_1
XFILLER_46_246 VPWR VGND sg13cmos5l_fill_1
XFILLER_62_728 VPWR VGND sg13cmos5l_fill_2
XFILLER_61_205 VPWR VGND sg13cmos5l_fill_2
XFILLER_14_110 VPWR VGND sg13cmos5l_decap_4
X_10938__1044 _10938_/RESET_B VPWR VGND sg13cmos5l_tiehi
X_11714_ _11714_/Q clkload29/A _11714_/D _11714_/RESET_B VPWR VGND sg13cmos5l_dfrbpq_1
XFILLER_43_975 VPWR VGND sg13cmos5l_fill_1
XFILLER_30_614 VPWR VGND sg13cmos5l_decap_8
X_11645_ _11645_/Q clkload25/A _11645_/D _11645_/RESET_B VPWR VGND sg13cmos5l_dfrbpq_1
XFILLER_52_72 VPWR VGND sg13cmos5l_fill_2
X_11576_ _11576_/Q clkload26/A _11576_/D _11576_/RESET_B VPWR VGND sg13cmos5l_dfrbpq_1
Xinput15 input15/X ui_in[7] VPWR VGND sg13cmos5l_buf_1
X_10527_ _10527_/Y hold2905/X _10547_/A2 _10614_/C1 VPWR VGND sg13cmos5l_a21oi_1
XFILLER_10_382 VPWR VGND sg13cmos5l_fill_2
XFILLER_10_393 VPWR VGND sg13cmos5l_fill_1
X_11227__1674 _11227_/RESET_B VPWR VGND sg13cmos5l_tiehi
X_10458_ _10460_/C _10477_/A _10845_/Q VPWR VGND sg13cmos5l_xnor2_1
X_10389_ _10403_/D _09641_/A _10424_/B _06719_/B VPWR VGND sg13cmos5l_a21oi_1
XFILLER_96_135 VPWR VGND sg13cmos5l_decap_8
X_11728__1224 _11728_/RESET_B VPWR VGND sg13cmos5l_tiehi
XFILLER_96_179 VPWR VGND sg13cmos5l_fill_1
XFILLER_78_883 VPWR VGND sg13cmos5l_decap_8
XFILLER_77_393 VPWR VGND sg13cmos5l_decap_8
XFILLER_38_725 VPWR VGND sg13cmos5l_decap_4
XFILLER_37_213 VPWR VGND sg13cmos5l_decap_8
XFILLER_93_853 VPWR VGND sg13cmos5l_decap_8
XFILLER_65_544 VPWR VGND sg13cmos5l_decap_4
XFILLER_37_235 VPWR VGND sg13cmos5l_fill_1
X_06620_ _06620_/Y _06620_/A _06620_/B VPWR VGND sg13cmos5l_xnor2_1
XFILLER_93_897 VPWR VGND sg13cmos5l_fill_2
XFILLER_65_599 VPWR VGND sg13cmos5l_decap_8
XFILLER_93_90 VPWR VGND sg13cmos5l_fill_2
XFILLER_92_396 VPWR VGND sg13cmos5l_decap_8
XFILLER_80_547 VPWR VGND sg13cmos5l_decap_8
X_06551_ _06551_/Y _06551_/A _06551_/B VPWR VGND sg13cmos5l_nand2_1
XFILLER_34_953 VPWR VGND sg13cmos5l_decap_8
X_09270_ _09272_/C _09270_/A _10679_/B VPWR VGND sg13cmos5l_xnor2_1
X_06482_ _06483_/B _09852_/A1 _06475_/X _06481_/Y VPWR VGND sg13cmos5l_o21ai_1
XFILLER_60_260 VPWR VGND sg13cmos5l_decap_8
X_08221_ _11197_/D fanout78/X _08220_/B _08220_/Y VPWR VGND sg13cmos5l_o21ai_1
XFILLER_21_636 VPWR VGND sg13cmos5l_fill_1
XFILLER_33_474 VPWR VGND sg13cmos5l_decap_8
XFILLER_33_485 VPWR VGND sg13cmos5l_fill_1
X_11638__1328 _11638_/RESET_B VPWR VGND sg13cmos5l_tiehi
XFILLER_20_135 VPWR VGND sg13cmos5l_fill_1
X_08152_ _11163_/D fanout83/X _08171_/B _08151_/Y VPWR VGND sg13cmos5l_a21oi_1
Xclkbuf_leaf_9_clk clkload28/A clkbuf_4_6_0_clk/X VPWR VGND sg13cmos5l_buf_8
X_07103_ _07103_/Y hold2705/X _07132_/A2 _08627_/C VPWR VGND sg13cmos5l_o21ai_1
XFILLER_9_191 VPWR VGND sg13cmos5l_decap_8
X_08083_ _11130_/D fanout97/X _08088_/B _08082_/Y VPWR VGND sg13cmos5l_o21ai_1
X_07034_ _07034_/Y _07034_/A _07034_/B VPWR VGND sg13cmos5l_nand2_1
XFILLER_0_518 VPWR VGND sg13cmos5l_decap_8
XFILLER_0_529 VPWR VGND sg13cmos5l_fill_2
XFILLER_103_947 VPWR VGND sg13cmos5l_decap_8
XFILLER_88_636 VPWR VGND sg13cmos5l_decap_8
Xhold2701 hold2701/X _11684_/Q VPWR VGND sg13cmos5l_dlygate4sd3_1
Xhold2712 _07190_/B _11380_/Q VPWR VGND sg13cmos5l_dlygate4sd3_1
X_08985_ _08985_/Y _08997_/A _08997_/C VPWR VGND sg13cmos5l_xnor2_1
Xhold2723 hold2723/X _10234_/Y VPWR VGND sg13cmos5l_dlygate4sd3_1
Xhold2745 _10839_/D _07208_/Y VPWR VGND sg13cmos5l_dlygate4sd3_1
Xhold2756 hold2756/X _11552_/Q VPWR VGND sg13cmos5l_dlygate4sd3_1
Xhold2734 _07240_/B _07239_/Y VPWR VGND sg13cmos5l_dlygate4sd3_1
X_07936_ _07936_/Y _07936_/A _07946_/B VPWR VGND sg13cmos5l_nand2_1
Xhold2767 hold2767/X _11744_/Q VPWR VGND sg13cmos5l_dlygate4sd3_1
Xhold2778 _05970_/A _10844_/Q VPWR VGND sg13cmos5l_dlygate4sd3_1
XFILLER_56_511 VPWR VGND sg13cmos5l_decap_4
Xhold2789 hold2789/X _06204_/B VPWR VGND sg13cmos5l_dlygate4sd3_1
Xheichips26_RiMaX_839 uio_out[0] VPWR VGND sg13cmos5l_tielo
XFILLER_29_714 VPWR VGND sg13cmos5l_decap_4
XFILLER_29_725 VPWR VGND sg13cmos5l_decap_4
XFILLER_56_544 VPWR VGND sg13cmos5l_fill_2
X_07867_ _07867_/Y _07867_/A _07881_/B VPWR VGND sg13cmos5l_nor2_1
XFILLER_28_235 VPWR VGND sg13cmos5l_decap_8
X_06818_ _06818_/Y _10728_/B _11644_/Q _07190_/C VPWR VGND sg13cmos5l_nand3_1
XFILLER_44_728 VPWR VGND sg13cmos5l_decap_8
X_07798_ _07798_/Y _07798_/A _07820_/B VPWR VGND sg13cmos5l_nand2_1
XFILLER_43_216 VPWR VGND sg13cmos5l_decap_4
X_09606_ _09606_/Y _11320_/Q _09606_/B VPWR VGND sg13cmos5l_nand2b_1
X_06749_ _06749_/Y _10282_/A _06757_/B VPWR VGND sg13cmos5l_nor2_1
XFILLER_25_931 VPWR VGND sg13cmos5l_fill_2
X_09537_ _09537_/Y _09537_/A _09614_/A VPWR VGND sg13cmos5l_nor2_1
X_11305__1596 _11305_/RESET_B VPWR VGND sg13cmos5l_tiehi
X_09468_ _09468_/Y _09466_/Y _09467_/Y _09572_/B1 VPWR VGND sg13cmos5l_a21oi_1
X_08419_ _08419_/Y _08419_/A _08429_/B VPWR VGND sg13cmos5l_nor2_1
XFILLER_12_658 VPWR VGND sg13cmos5l_decap_4
X_09399_ _09399_/Y _09396_/Y _09398_/Y _09579_/B2 VPWR VGND sg13cmos5l_o21ai_1
X_11430_ _11430_/Q _11528_/CLK _11430_/D _11430_/RESET_B VPWR VGND sg13cmos5l_dfrbpq_1
XFILLER_7_128 VPWR VGND sg13cmos5l_fill_2
XFILLER_22_31 VPWR VGND sg13cmos5l_fill_2
X_11361_ _11361_/Q _11361_/CLK _11361_/D _11361_/RESET_B VPWR VGND sg13cmos5l_dfrbpq_1
XFILLER_22_64 VPWR VGND sg13cmos5l_fill_2
XFILLER_98_35 VPWR VGND sg13cmos5l_decap_8
X_10312_ _10312_/Y _10422_/A VPWR VGND sg13cmos5l_inv_1
X_11292_ _11292_/Q _11356_/CLK _11292_/D _11292_/RESET_B VPWR VGND sg13cmos5l_dfrbpq_1
XFILLER_106_763 VPWR VGND sg13cmos5l_decap_8
X_10243_ _10247_/B _10250_/B _10289_/A _10267_/B _10305_/A VPWR VGND sg13cmos5l_nand4_1
XFILLER_105_273 VPWR VGND sg13cmos5l_decap_8
XFILLER_79_647 VPWR VGND sg13cmos5l_fill_2
X_10174_ _10174_/Y hold2724/X _10172_/Y _10173_/Y hold2742/X _10707_/C VPWR VGND sg13cmos5l_a221oi_1
XFILLER_26_1018 VPWR VGND sg13cmos5l_fill_1
Xfanout181 _08555_/B _08506_/Y VPWR VGND sg13cmos5l_buf_1
Xfanout192 _08435_/B _08376_/Y VPWR VGND sg13cmos5l_buf_1
X_10844__1154 _10844_/RESET_B VPWR VGND sg13cmos5l_tiehi
Xfanout170 _07311_/B _06955_/Y VPWR VGND sg13cmos5l_buf_1
XFILLER_47_522 VPWR VGND sg13cmos5l_decap_8
XFILLER_47_500 VPWR VGND sg13cmos5l_fill_2
X_11430__1430 _11430_/RESET_B VPWR VGND sg13cmos5l_tiehi
XFILLER_86_190 VPWR VGND sg13cmos5l_fill_2
XFILLER_47_83 VPWR VGND sg13cmos5l_decap_8
X_11090__1811 _11090_/RESET_B VPWR VGND sg13cmos5l_tiehi
XFILLER_75_897 VPWR VGND sg13cmos5l_fill_1
X_11481__1221 _11481_/RESET_B VPWR VGND sg13cmos5l_tiehi
XFILLER_47_94 VPWR VGND sg13cmos5l_fill_1
XFILLER_31_901 VPWR VGND sg13cmos5l_decap_4
XFILLER_31_912 VPWR VGND sg13cmos5l_fill_1
XFILLER_97_7 VPWR VGND sg13cmos5l_decap_8
XFILLER_30_411 VPWR VGND sg13cmos5l_fill_1
XFILLER_42_293 VPWR VGND sg13cmos5l_decap_8
XFILLER_8_22 VPWR VGND sg13cmos5l_fill_2
XFILLER_8_11 VPWR VGND sg13cmos5l_decap_8
X_11628_ _11628_/Q clkload29/A _11628_/D _11628_/RESET_B VPWR VGND sg13cmos5l_dfrbpq_1
XFILLER_8_66 VPWR VGND sg13cmos5l_fill_1
XFILLER_8_44 VPWR VGND sg13cmos5l_fill_2
XFILLER_8_88 VPWR VGND sg13cmos5l_decap_8
XFILLER_11_680 VPWR VGND sg13cmos5l_fill_2
XFILLER_11_691 VPWR VGND sg13cmos5l_fill_2
X_11559_ _11559_/Q clkload27/A _11559_/D _11559_/RESET_B VPWR VGND sg13cmos5l_dfrbpq_1
XFILLER_98_901 VPWR VGND sg13cmos5l_fill_2
Xhold2008 _08356_/A _11264_/Q VPWR VGND sg13cmos5l_dlygate4sd3_1
Xhold2019 _11651_/D _06966_/Y VPWR VGND sg13cmos5l_dlygate4sd3_1
X_05982_ _05982_/Y _11332_/Q VPWR VGND sg13cmos5l_inv_1
XFILLER_84_127 VPWR VGND sg13cmos5l_fill_2
X_08770_ _08771_/B _08770_/A _08770_/B VPWR VGND sg13cmos5l_nand2_1
XFILLER_78_680 VPWR VGND sg13cmos5l_fill_1
X_07721_ _07721_/Y _07721_/A _08506_/C VPWR VGND sg13cmos5l_nor2_1
XFILLER_81_823 VPWR VGND sg13cmos5l_fill_2
X_07652_ _07652_/Y _07652_/A1 _08770_/B _07650_/Y VPWR VGND sg13cmos5l_o21ai_1
XFILLER_80_300 VPWR VGND sg13cmos5l_decap_4
XFILLER_25_205 VPWR VGND sg13cmos5l_decap_4
XFILLER_26_739 VPWR VGND sg13cmos5l_fill_2
XFILLER_65_396 VPWR VGND sg13cmos5l_fill_1
XFILLER_65_385 VPWR VGND sg13cmos5l_decap_8
X_07583_ _07597_/C _07584_/A _07584_/B VPWR VGND sg13cmos5l_nor2_1
X_06603_ _06604_/B _06662_/A _06603_/B _06603_/C VPWR VGND sg13cmos5l_nor3_1
XFILLER_25_216 VPWR VGND sg13cmos5l_decap_8
XFILLER_80_366 VPWR VGND sg13cmos5l_decap_8
X_09322_ _09323_/B _10177_/A _10053_/A2 _09321_/Y _09303_/D _09320_/Y VPWR VGND sg13cmos5l_a221oi_1
XFILLER_53_569 VPWR VGND sg13cmos5l_decap_8
XFILLER_41_709 VPWR VGND sg13cmos5l_decap_8
X_06534_ _06536_/A _10876_/Q _06571_/B2 _06531_/A _11650_/Q VPWR VGND sg13cmos5l_a22oi_1
XFILLER_22_901 VPWR VGND sg13cmos5l_fill_1
XFILLER_33_271 VPWR VGND sg13cmos5l_fill_2
X_09253_ _09254_/D _09253_/A _09862_/C VPWR VGND sg13cmos5l_nor2b_1
X_06465_ _06467_/B _11636_/Q _10140_/A VPWR VGND sg13cmos5l_nand2b_1
X_06396_ _06396_/Y _11622_/Q _11609_/Q VPWR VGND sg13cmos5l_nor2_1
X_09184_ _09184_/Y _10180_/B _10830_/Q VPWR VGND sg13cmos5l_nand2_1
X_08204_ _08204_/Y _08204_/A _08228_/B VPWR VGND sg13cmos5l_nand2_1
X_08135_ _08135_/Y _08135_/A _08135_/B VPWR VGND sg13cmos5l_nor2_1
XFILLER_49_1018 VPWR VGND sg13cmos5l_fill_2
X_08066_ _08066_/Y _08066_/A _08076_/B VPWR VGND sg13cmos5l_nand2_1
X_07017_ _07017_/Y _11505_/Q _07024_/B _07016_/Y VPWR VGND sg13cmos5l_a21oi_1
XFILLER_102_210 VPWR VGND sg13cmos5l_decap_8
XFILLER_1_838 VPWR VGND sg13cmos5l_decap_8
XFILLER_103_777 VPWR VGND sg13cmos5l_decap_8
Xhold2531 _11619_/D _06858_/Y VPWR VGND sg13cmos5l_dlygate4sd3_1
Xhold2520 _11676_/D _07054_/X VPWR VGND sg13cmos5l_dlygate4sd3_1
Xhold2542 _06944_/A _11645_/Q VPWR VGND sg13cmos5l_dlygate4sd3_1
XFILLER_75_116 VPWR VGND sg13cmos5l_decap_8
X_08968_ _08983_/A _11632_/Q _08973_/A VPWR VGND sg13cmos5l_nand2_1
Xhold2564 _09333_/A _11458_/Q VPWR VGND sg13cmos5l_dlygate4sd3_1
Xhold2553 _07413_/A _10886_/Q VPWR VGND sg13cmos5l_dlygate4sd3_1
Xhold1841 _07972_/A _11076_/Q VPWR VGND sg13cmos5l_dlygate4sd3_1
Xhold1863 _07964_/A _11072_/Q VPWR VGND sg13cmos5l_dlygate4sd3_1
Xhold2575 hold2575/X _11579_/Q VPWR VGND sg13cmos5l_dlygate4sd3_1
X_07919_ _07919_/Y _08441_/B _08049_/B VPWR VGND sg13cmos5l_nand2_1
Xhold1852 _11614_/D _06846_/Y VPWR VGND sg13cmos5l_dlygate4sd3_1
X_11758__919 _11758_/RESET_B VPWR VGND sg13cmos5l_tiehi
Xhold2586 _11693_/D _06886_/X VPWR VGND sg13cmos5l_dlygate4sd3_1
XFILLER_57_853 VPWR VGND sg13cmos5l_fill_1
X_08899_ _08918_/B _08930_/A _08930_/D VPWR VGND sg13cmos5l_nor2_1
Xhold2597 _11653_/D _06969_/X VPWR VGND sg13cmos5l_dlygate4sd3_1
Xhold1885 _07962_/A _11071_/Q VPWR VGND sg13cmos5l_dlygate4sd3_1
XFILLER_90_119 VPWR VGND sg13cmos5l_decap_4
XFILLER_1_1009 VPWR VGND sg13cmos5l_decap_8
X_10930_ _10930_/Q clkload17/A _10930_/D _10930_/RESET_B VPWR VGND sg13cmos5l_dfrbpq_1
Xhold1896 _08450_/A _11310_/Q VPWR VGND sg13cmos5l_dlygate4sd3_1
Xhold1874 _07820_/A _11002_/Q VPWR VGND sg13cmos5l_dlygate4sd3_1
XFILLER_29_566 VPWR VGND sg13cmos5l_decap_8
XFILLER_29_588 VPWR VGND sg13cmos5l_fill_2
XFILLER_84_694 VPWR VGND sg13cmos5l_fill_2
XFILLER_72_856 VPWR VGND sg13cmos5l_fill_2
XFILLER_72_845 VPWR VGND sg13cmos5l_decap_8
XFILLER_16_238 VPWR VGND sg13cmos5l_fill_2
XFILLER_71_355 VPWR VGND sg13cmos5l_fill_2
X_10861_ _10861_/Q clkload7/A _10861_/D _10861_/RESET_B VPWR VGND sg13cmos5l_dfrbpq_1
X_10792_ _10792_/Y _06825_/Y _10783_/Y _10791_/Y VPWR VGND sg13cmos5l_o21ai_1
XFILLER_71_399 VPWR VGND sg13cmos5l_fill_2
XFILLER_12_422 VPWR VGND sg13cmos5l_decap_8
XFILLER_8_437 VPWR VGND sg13cmos5l_fill_1
X_11413_ _11413_/Q clkload55/A _11413_/D _11413_/RESET_B VPWR VGND sg13cmos5l_dfrbpq_1
XFILLER_4_643 VPWR VGND sg13cmos5l_fill_2
X_11344_ _11344_/Q _11671_/CLK _11344_/D _11344_/RESET_B VPWR VGND sg13cmos5l_dfrbpq_1
X_10888__1094 _10888_/RESET_B VPWR VGND sg13cmos5l_tiehi
XFILLER_106_560 VPWR VGND sg13cmos5l_decap_8
X_11275_ _11275_/Q _11594_/CLK _11275_/D _11275_/RESET_B VPWR VGND sg13cmos5l_dfrbpq_1
XFILLER_4_654 VPWR VGND sg13cmos5l_decap_4
X_10226_ _10226_/Y _11730_/Q _10172_/Y _10173_/Y _11746_/Q _10226_/C1 VPWR VGND sg13cmos5l_a221oi_1
X_10157_ _10157_/Y _10157_/A1 _10679_/B _10156_/Y VPWR VGND sg13cmos5l_o21ai_1
XFILLER_66_116 VPWR VGND sg13cmos5l_fill_2
XFILLER_48_853 VPWR VGND sg13cmos5l_decap_8
X_10088_ _10088_/X hold2862/X _10088_/A2 _10087_/Y VPWR VGND sg13cmos5l_a21o_1
X_11010__972 _11010_/RESET_B VPWR VGND sg13cmos5l_tiehi
XFILLER_75_683 VPWR VGND sg13cmos5l_decap_8
XFILLER_63_856 VPWR VGND sg13cmos5l_decap_4
XFILLER_35_547 VPWR VGND sg13cmos5l_fill_1
XFILLER_90_697 VPWR VGND sg13cmos5l_fill_1
X_06250_ _06429_/B _11515_/Q _09264_/A VPWR VGND sg13cmos5l_nand2_1
X_11555__1455 _11555_/RESET_B VPWR VGND sg13cmos5l_tiehi
X_06181_ _06182_/B _06181_/A _09354_/A VPWR VGND sg13cmos5l_or2_1
X_09940_ _09941_/B _09940_/A _09968_/B VPWR VGND sg13cmos5l_nand2_1
X_09871_ _09871_/Y _11138_/Q _09986_/B _09990_/S1 VPWR VGND sg13cmos5l_a21oi_1
XFILLER_100_736 VPWR VGND sg13cmos5l_decap_8
XFILLER_98_786 VPWR VGND sg13cmos5l_fill_1
X_08822_ _11428_/D _08820_/Y _08821_/Y _08811_/Y VPWR VGND sg13cmos5l_o21ai_1
XFILLER_97_296 VPWR VGND sg13cmos5l_fill_2
XFILLER_85_458 VPWR VGND sg13cmos5l_fill_2
XFILLER_73_609 VPWR VGND sg13cmos5l_decap_8
X_08753_ _11418_/D _08753_/A VPWR VGND sg13cmos5l_inv_1
X_05965_ _05965_/Y _05965_/A VPWR VGND sg13cmos5l_inv_1
X_07704_ _07704_/Y _07704_/A _07704_/B VPWR VGND sg13cmos5l_nor2_1
XFILLER_66_661 VPWR VGND sg13cmos5l_fill_2
XFILLER_54_801 VPWR VGND sg13cmos5l_fill_2
X_05896_ _09912_/A _09262_/A VPWR VGND sg13cmos5l_inv_1
XFILLER_66_683 VPWR VGND sg13cmos5l_decap_8
XFILLER_53_322 VPWR VGND sg13cmos5l_decap_8
XFILLER_53_300 VPWR VGND sg13cmos5l_fill_2
X_08684_ _11402_/D _08684_/A VPWR VGND sg13cmos5l_inv_1
XFILLER_0_1020 VPWR VGND sg13cmos5l_decap_8
XFILLER_26_536 VPWR VGND sg13cmos5l_fill_1
X_07635_ _08762_/B _11548_/Q _10823_/Q _07642_/S VPWR VGND sg13cmos5l_mux2_1
XFILLER_54_889 VPWR VGND sg13cmos5l_fill_1
XFILLER_81_697 VPWR VGND sg13cmos5l_fill_2
X_07566_ _07566_/Y _07566_/A _07566_/B VPWR VGND sg13cmos5l_nor2_1
X_11186__1715 _11186_/RESET_B VPWR VGND sg13cmos5l_tiehi
X_09305_ _09305_/X _09944_/A _09305_/B _09305_/C _09305_/D VPWR VGND sg13cmos5l_and4_1
X_06517_ _06517_/X _11246_/Q _11214_/Q _11182_/Q _11150_/Q _09551_/S0 _09551_/S1 VPWR
+ VGND sg13cmos5l_mux4_1
X_09236_ _09237_/B _09729_/A _09704_/A _09236_/C _09649_/B VPWR VGND sg13cmos5l_or4_1
X_07497_ _07497_/X _07497_/A _10803_/Q VPWR VGND sg13cmos5l_and2_1
XFILLER_16_1028 VPWR VGND sg13cmos5l_fill_1
X_06448_ _10825_/D _06759_/A1 _06443_/Y _06447_/Y VPWR VGND sg13cmos5l_o21ai_1
XFILLER_6_908 VPWR VGND sg13cmos5l_decap_4
XFILLER_10_959 VPWR VGND sg13cmos5l_fill_1
X_11715__1249 _11715_/RESET_B VPWR VGND sg13cmos5l_tiehi
X_09167_ _09168_/B _09158_/Y _09837_/B _09159_/Y VPWR VGND sg13cmos5l_a21oi_1
X_06379_ _06379_/Y _06370_/Y _06376_/Y _06378_/Y VPWR VGND sg13cmos5l_a21oi_1
X_08118_ _11146_/D _08313_/A1 _08169_/B _08117_/Y VPWR VGND sg13cmos5l_a21oi_1
XFILLER_79_15 VPWR VGND sg13cmos5l_fill_2
X_09098_ _09098_/Y _09075_/X _09121_/A _09123_/A VPWR VGND sg13cmos5l_o21ai_1
X_08049_ _08049_/Y _08311_/A _08049_/B VPWR VGND sg13cmos5l_nand2_1
X_11060_ _11060_/Q _11347_/CLK _11060_/D _11060_/RESET_B VPWR VGND sg13cmos5l_dfrbpq_1
X_10011_ _10017_/B _10007_/Y _10008_/Y _10009_/Y _10010_/Y _06476_/A VPWR VGND sg13cmos5l_a221oi_1
XFILLER_95_14 VPWR VGND sg13cmos5l_decap_8
XFILLER_89_775 VPWR VGND sg13cmos5l_decap_8
XFILLER_88_230 VPWR VGND sg13cmos5l_fill_2
XFILLER_77_915 VPWR VGND sg13cmos5l_fill_1
XFILLER_1_657 VPWR VGND sg13cmos5l_decap_8
XFILLER_103_574 VPWR VGND sg13cmos5l_fill_1
XFILLER_49_639 VPWR VGND sg13cmos5l_decap_8
XFILLER_49_628 VPWR VGND sg13cmos5l_fill_2
XFILLER_49_617 VPWR VGND sg13cmos5l_decap_8
Xhold2361 _10868_/D _07306_/Y VPWR VGND sg13cmos5l_dlygate4sd3_1
Xhold2350 _07893_/A _11037_/Q VPWR VGND sg13cmos5l_dlygate4sd3_1
Xhold2372 _10872_/D _07330_/Y VPWR VGND sg13cmos5l_dlygate4sd3_1
Xhold2383 _07690_/A _10939_/Q VPWR VGND sg13cmos5l_dlygate4sd3_1
Xhold2394 _07863_/A _11022_/Q VPWR VGND sg13cmos5l_dlygate4sd3_1
X_11633__1333 _11633_/RESET_B VPWR VGND sg13cmos5l_tiehi
XFILLER_45_856 VPWR VGND sg13cmos5l_fill_1
XFILLER_45_845 VPWR VGND sg13cmos5l_fill_2
X_10913_ _10913_/Q _11361_/CLK _10913_/D _10913_/RESET_B VPWR VGND sg13cmos5l_dfrbpq_1
X_10844_ _10844_/Q clkload36/A _10844_/D _10844_/RESET_B VPWR VGND sg13cmos5l_dfrbpq_1
XFILLER_32_539 VPWR VGND sg13cmos5l_decap_4
XFILLER_13_742 VPWR VGND sg13cmos5l_fill_1
X_10775_ _10775_/Y _06940_/Y _10779_/D _10774_/Y VPWR VGND sg13cmos5l_o21ai_1
X_10975__1007 _10975_/RESET_B VPWR VGND sg13cmos5l_tiehi
XFILLER_40_583 VPWR VGND sg13cmos5l_decap_8
XFILLER_67_8 VPWR VGND sg13cmos5l_fill_2
XFILLER_99_506 VPWR VGND sg13cmos5l_fill_1
X_11327_ _11327_/Q clkload49/A _11327_/D _11327_/RESET_B VPWR VGND sg13cmos5l_dfrbpq_1
XFILLER_69_81 VPWR VGND sg13cmos5l_decap_8
X_11258_ _11258_/Q _11361_/CLK _11258_/D _11258_/RESET_B VPWR VGND sg13cmos5l_dfrbpq_1
XFILLER_95_712 VPWR VGND sg13cmos5l_fill_2
X_11264__1637 _11264_/RESET_B VPWR VGND sg13cmos5l_tiehi
XFILLER_67_403 VPWR VGND sg13cmos5l_fill_1
X_10209_ _10212_/A _10202_/A _10202_/B _10199_/X VPWR VGND sg13cmos5l_a21oi_1
XFILLER_39_105 VPWR VGND sg13cmos5l_decap_8
X_11189_ _11189_/Q _11352_/CLK _11189_/D _11189_/RESET_B VPWR VGND sg13cmos5l_dfrbpq_1
XFILLER_83_918 VPWR VGND sg13cmos5l_decap_4
XFILLER_76_970 VPWR VGND sg13cmos5l_fill_2
XFILLER_54_108 VPWR VGND sg13cmos5l_decap_4
XFILLER_48_650 VPWR VGND sg13cmos5l_fill_2
XFILLER_10_4 VPWR VGND sg13cmos5l_decap_8
XFILLER_75_480 VPWR VGND sg13cmos5l_fill_1
XFILLER_63_631 VPWR VGND sg13cmos5l_fill_2
XFILLER_63_620 VPWR VGND sg13cmos5l_decap_4
XFILLER_48_694 VPWR VGND sg13cmos5l_decap_4
XFILLER_39_1028 VPWR VGND sg13cmos5l_fill_1
X_11599__1384 _11599_/RESET_B VPWR VGND sg13cmos5l_tiehi
XFILLER_63_686 VPWR VGND sg13cmos5l_decap_8
XFILLER_62_163 VPWR VGND sg13cmos5l_decap_8
XFILLER_35_399 VPWR VGND sg13cmos5l_fill_1
X_07420_ _10887_/D _07425_/B _07418_/Y _07419_/Y VPWR VGND sg13cmos5l_a21oi_1
XFILLER_90_494 VPWR VGND sg13cmos5l_fill_2
XFILLER_51_859 VPWR VGND sg13cmos5l_decap_8
XFILLER_50_325 VPWR VGND sg13cmos5l_fill_1
X_07351_ _07351_/Y _07349_/Y _08717_/A _07376_/A2 VPWR VGND sg13cmos5l_a21oi_1
XFILLER_16_580 VPWR VGND sg13cmos5l_decap_8
XFILLER_86_0 VPWR VGND sg13cmos5l_decap_8
X_06302_ _06302_/Y _06681_/A _06292_/X _06686_/A VPWR VGND sg13cmos5l_a21oi_1
X_07282_ _07282_/Y _07347_/B _07280_/Y _07281_/Y VPWR VGND sg13cmos5l_a21oi_1
XFILLER_31_583 VPWR VGND sg13cmos5l_decap_8
X_09021_ _09021_/Y _09043_/A _09036_/A _09022_/C _09019_/Y _09020_/Y VPWR VGND sg13cmos5l_a221oi_1
X_06233_ _06233_/X _10424_/B _10298_/A VPWR VGND sg13cmos5l_or2_1
X_06164_ _06657_/A _06164_/A _06658_/A VPWR VGND sg13cmos5l_nor2_1
X_06095_ _06114_/A _08627_/C input18/X VPWR VGND sg13cmos5l_nand2_1
X_09923_ _09923_/Y _10948_/Q _10012_/B VPWR VGND sg13cmos5l_nand2_1
Xfanout703 _06772_/S _06441_/A1 VPWR VGND sg13cmos5l_buf_1
Xfanout714 _09104_/A _09137_/A VPWR VGND sg13cmos5l_buf_1
XFILLER_86_712 VPWR VGND sg13cmos5l_fill_1
XFILLER_85_200 VPWR VGND sg13cmos5l_decap_4
Xfanout725 _08621_/B _11552_/Q VPWR VGND sg13cmos5l_buf_1
Xfanout747 _10614_/A1 hold2939/X VPWR VGND sg13cmos5l_buf_1
X_09854_ _09942_/A _10250_/A _09970_/B VPWR VGND sg13cmos5l_nor2_1
Xfanout758 _10267_/C _10434_/A VPWR VGND sg13cmos5l_buf_1
Xfanout736 _10479_/B _11506_/Q VPWR VGND sg13cmos5l_buf_1
XFILLER_105_35 VPWR VGND sg13cmos5l_decap_8
XFILLER_100_544 VPWR VGND sg13cmos5l_fill_1
XFILLER_100_533 VPWR VGND sg13cmos5l_fill_1
XFILLER_86_767 VPWR VGND sg13cmos5l_decap_8
XFILLER_58_436 VPWR VGND sg13cmos5l_decap_8
X_08805_ _08805_/X _08805_/A _08805_/B VPWR VGND sg13cmos5l_xor2_1
Xfanout769 _09696_/A _09557_/A VPWR VGND sg13cmos5l_buf_1
X_09785_ _09785_/Y _11103_/Q _09814_/S VPWR VGND sg13cmos5l_nand2_1
XFILLER_67_981 VPWR VGND sg13cmos5l_decap_8
X_06997_ _06997_/X hold2507/X _07030_/B _06996_/Y VPWR VGND sg13cmos5l_a21o_1
XFILLER_100_588 VPWR VGND sg13cmos5l_fill_2
X_05948_ _05948_/Y _05948_/A VPWR VGND sg13cmos5l_inv_1
XFILLER_66_491 VPWR VGND sg13cmos5l_decap_8
X_08736_ _11414_/D _08736_/A VPWR VGND sg13cmos5l_inv_1
XFILLER_39_683 VPWR VGND sg13cmos5l_decap_4
XFILLER_26_300 VPWR VGND sg13cmos5l_decap_4
XFILLER_27_823 VPWR VGND sg13cmos5l_fill_2
X_05879_ _05879_/Y _05879_/A VPWR VGND sg13cmos5l_inv_1
XFILLER_54_653 VPWR VGND sg13cmos5l_decap_4
X_08667_ _08827_/B hold2642/X _07477_/X _08667_/S VPWR VGND sg13cmos5l_mux2_1
XFILLER_26_355 VPWR VGND sg13cmos5l_fill_1
XFILLER_92_1019 VPWR VGND sg13cmos5l_decap_8
X_07618_ _07619_/B _10591_/A _07617_/C _11418_/Q VPWR VGND sg13cmos5l_a21oi_1
XFILLER_53_152 VPWR VGND sg13cmos5l_fill_1
XFILLER_42_848 VPWR VGND sg13cmos5l_fill_1
XFILLER_42_815 VPWR VGND sg13cmos5l_fill_2
XFILLER_27_889 VPWR VGND sg13cmos5l_decap_8
X_11526__1131 _11526_/RESET_B VPWR VGND sg13cmos5l_tiehi
X_08598_ _08605_/A _10017_/A _08598_/B _08598_/C VPWR VGND sg13cmos5l_nor3_1
XFILLER_41_358 VPWR VGND sg13cmos5l_fill_1
X_07549_ _07550_/B _05860_/Y _11535_/Q _07548_/X VPWR VGND sg13cmos5l_a21oi_1
X_10560_ _10560_/X _10560_/A _10560_/B _10560_/C VPWR VGND sg13cmos5l_or3_1
XFILLER_22_583 VPWR VGND sg13cmos5l_decap_8
X_10491_ _10506_/B _10491_/A _10491_/B VPWR VGND sg13cmos5l_xnor2_1
XFILLER_10_778 VPWR VGND sg13cmos5l_decap_4
X_11342__1559 _11342_/RESET_B VPWR VGND sg13cmos5l_tiehi
X_09219_ _09590_/A _11470_/Q _10843_/Q VPWR VGND sg13cmos5l_xor2_1
XFILLER_6_749 VPWR VGND sg13cmos5l_decap_4
XFILLER_5_237 VPWR VGND sg13cmos5l_fill_2
X_11000__982 _11000_/RESET_B VPWR VGND sg13cmos5l_tiehi
X_11112_ _11112_/Q clkload57/A _11112_/D _11112_/RESET_B VPWR VGND sg13cmos5l_dfrbpq_1
XFILLER_2_955 VPWR VGND sg13cmos5l_decap_8
XFILLER_104_894 VPWR VGND sg13cmos5l_decap_8
X_11043_ _11043_/Q clkload46/A _11043_/D _11043_/RESET_B VPWR VGND sg13cmos5l_dfrbpq_1
XFILLER_49_414 VPWR VGND sg13cmos5l_fill_1
XFILLER_49_403 VPWR VGND sg13cmos5l_decap_8
XFILLER_1_454 VPWR VGND sg13cmos5l_fill_2
XFILLER_49_436 VPWR VGND sg13cmos5l_fill_1
Xhold2191 _08433_/A _11302_/Q VPWR VGND sg13cmos5l_dlygate4sd3_1
XFILLER_65_929 VPWR VGND sg13cmos5l_decap_8
Xclkbuf_4_3_0_clk clkload0/A clkbuf_0_clk/X VPWR VGND sg13cmos5l_buf_8
Xhold2180 _07674_/A _10931_/Q VPWR VGND sg13cmos5l_dlygate4sd3_1
XFILLER_92_759 VPWR VGND sg13cmos5l_fill_1
XFILLER_64_439 VPWR VGND sg13cmos5l_fill_2
XFILLER_64_428 VPWR VGND sg13cmos5l_fill_1
XFILLER_58_992 VPWR VGND sg13cmos5l_decap_8
XFILLER_45_631 VPWR VGND sg13cmos5l_fill_1
XFILLER_45_620 VPWR VGND sg13cmos5l_decap_8
XFILLER_33_804 VPWR VGND sg13cmos5l_decap_8
XFILLER_60_612 VPWR VGND sg13cmos5l_decap_8
XFILLER_17_377 VPWR VGND sg13cmos5l_decap_4
XFILLER_33_815 VPWR VGND sg13cmos5l_fill_1
X_10827_ _10827_/Q _11594_/CLK _10827_/D _10827_/RESET_B VPWR VGND sg13cmos5l_dfrbpq_1
XFILLER_13_561 VPWR VGND sg13cmos5l_decap_8
X_10758_ _10758_/Y _11689_/Q _10760_/S VPWR VGND sg13cmos5l_nor2_1
XFILLER_41_881 VPWR VGND sg13cmos5l_fill_2
X_10689_ _10690_/B _10698_/A _10688_/B _10688_/Y VPWR VGND sg13cmos5l_a21oi_1
X_11318__1583 _11318_/RESET_B VPWR VGND sg13cmos5l_tiehi
XFILLER_58_4 VPWR VGND sg13cmos5l_decap_8
XFILLER_99_303 VPWR VGND sg13cmos5l_fill_1
XFILLER_102_809 VPWR VGND sg13cmos5l_decap_8
X_06920_ _11689_/D hold2759/X hold2790/X _08615_/A VPWR VGND sg13cmos5l_mux2_1
X_06851_ _06851_/Y _10691_/C _06944_/A _07202_/C _06874_/A VPWR VGND sg13cmos5l_nand4_1
XFILLER_83_726 VPWR VGND sg13cmos5l_decap_8
X_06782_ _06782_/Y _10710_/B _06782_/B _06927_/B VPWR VGND sg13cmos5l_nor3_1
X_09570_ _09570_/Y _10935_/Q _09570_/B VPWR VGND sg13cmos5l_nand2_1
XFILLER_36_664 VPWR VGND sg13cmos5l_fill_1
X_08521_ _08521_/Y _08521_/A _08543_/B VPWR VGND sg13cmos5l_nor2_1
XFILLER_64_984 VPWR VGND sg13cmos5l_decap_8
X_08452_ _08452_/Y _08452_/A _08470_/B VPWR VGND sg13cmos5l_nand2_1
XFILLER_23_303 VPWR VGND sg13cmos5l_decap_8
X_07403_ _07403_/Y _11546_/Q _08762_/A VPWR VGND sg13cmos5l_nand2_1
XFILLER_51_678 VPWR VGND sg13cmos5l_decap_8
X_08383_ _08383_/Y _08383_/A _08401_/B VPWR VGND sg13cmos5l_nor2_1
XFILLER_50_177 VPWR VGND sg13cmos5l_fill_1
X_07334_ _07334_/Y _10440_/A1 _07340_/A2 _07333_/Y VPWR VGND sg13cmos5l_a21oi_1
X_07265_ _07265_/Y _11523_/Q _08667_/S VPWR VGND sg13cmos5l_nand2_1
X_09004_ _09004_/Y _09004_/A _09004_/B VPWR VGND sg13cmos5l_nand2_1
X_06216_ _06738_/A _06216_/A _10267_/C VPWR VGND sg13cmos5l_nor2_1
X_07196_ _07196_/Y _07196_/A _07196_/B VPWR VGND sg13cmos5l_nand2_1
XFILLER_105_614 VPWR VGND sg13cmos5l_decap_8
X_06147_ _06690_/A _11502_/Q _09217_/A VPWR VGND sg13cmos5l_xnor2_1
X_06078_ _10688_/B _06078_/A _06084_/A VPWR VGND sg13cmos5l_nand2_1
X_11371__1411 _11371_/RESET_B VPWR VGND sg13cmos5l_tiehi
XFILLER_104_168 VPWR VGND sg13cmos5l_decap_8
XFILLER_99_881 VPWR VGND sg13cmos5l_fill_2
X_09906_ _09906_/Y _09903_/Y _09905_/Y _09994_/A1 VPWR VGND sg13cmos5l_o21ai_1
Xfanout500 _09319_/C _09277_/X VPWR VGND sg13cmos5l_buf_1
Xfanout533 _07380_/B _07416_/B VPWR VGND sg13cmos5l_buf_1
Xfanout511 _09004_/B _08739_/A2 VPWR VGND sg13cmos5l_buf_1
Xfanout522 _07493_/A _07530_/A VPWR VGND sg13cmos5l_buf_1
Xfanout544 _08770_/A _07251_/X VPWR VGND sg13cmos5l_buf_1
Xfanout566 _07237_/A2 _07239_/A2 VPWR VGND sg13cmos5l_buf_1
XFILLER_59_734 VPWR VGND sg13cmos5l_fill_1
Xfanout555 _07340_/A2 _07375_/B1 VPWR VGND sg13cmos5l_buf_1
XFILLER_100_330 VPWR VGND sg13cmos5l_fill_2
Xfanout599 _07122_/A2 _06124_/X VPWR VGND sg13cmos5l_buf_1
Xfanout588 _07148_/A2 _07142_/A2 VPWR VGND sg13cmos5l_buf_1
X_09837_ _09839_/B _09837_/A _09837_/B _09837_/C VPWR VGND sg13cmos5l_nand3_1
Xfanout577 _06614_/A _06401_/C VPWR VGND sg13cmos5l_buf_1
X_11665__1299 _11665_/RESET_B VPWR VGND sg13cmos5l_tiehi
XFILLER_19_609 VPWR VGND sg13cmos5l_fill_2
X_09768_ _09768_/Y _11294_/Q _09903_/B VPWR VGND sg13cmos5l_nor2_1
X_08719_ _08720_/A hold2858/X _09004_/B _08981_/B _09013_/B1 VPWR VGND sg13cmos5l_a22oi_1
X_11730_ _11730_/Q clkload22/A _11730_/D _11730_/RESET_B VPWR VGND sg13cmos5l_dfrbpq_1
XFILLER_15_826 VPWR VGND sg13cmos5l_decap_8
XFILLER_26_141 VPWR VGND sg13cmos5l_fill_2
XFILLER_27_664 VPWR VGND sg13cmos5l_fill_1
X_09699_ _09700_/C _09611_/Y _09695_/Y _09698_/Y VPWR VGND sg13cmos5l_o21ai_1
XFILLER_14_336 VPWR VGND sg13cmos5l_fill_2
XFILLER_14_347 VPWR VGND sg13cmos5l_fill_2
XFILLER_41_144 VPWR VGND sg13cmos5l_decap_8
X_11661_ _11661_/Q clkload12/A _11661_/D _11661_/RESET_B VPWR VGND sg13cmos5l_dfrbpq_1
X_11592_ _11592_/Q clkload29/A _11592_/D _11592_/RESET_B VPWR VGND sg13cmos5l_dfrbpq_1
X_10612_ _10623_/A _10613_/A _10622_/C VPWR VGND sg13cmos5l_nor2_1
XFILLER_23_892 VPWR VGND sg13cmos5l_decap_4
X_10543_ _10543_/Y fanout84/X _10542_/X _10488_/A VPWR VGND sg13cmos5l_o21ai_1
XFILLER_41_30 VPWR VGND sg13cmos5l_fill_1
X_10474_ _10478_/B _10474_/A _10569_/A VPWR VGND sg13cmos5l_nand2_1
XFILLER_49_233 VPWR VGND sg13cmos5l_decap_8
XFILLER_2_35 VPWR VGND sg13cmos5l_decap_8
X_11026_ _11026_/Q clkload8/A _11026_/D _11026_/RESET_B VPWR VGND sg13cmos5l_dfrbpq_1
X_11181__1720 _11181_/RESET_B VPWR VGND sg13cmos5l_tiehi
XFILLER_92_523 VPWR VGND sg13cmos5l_decap_8
XFILLER_46_984 VPWR VGND sg13cmos5l_fill_2
XFILLER_45_450 VPWR VGND sg13cmos5l_fill_2
XFILLER_72_280 VPWR VGND sg13cmos5l_fill_2
XFILLER_82_81 VPWR VGND sg13cmos5l_fill_2
X_11710__1254 _11710_/RESET_B VPWR VGND sg13cmos5l_tiehi
XFILLER_61_987 VPWR VGND sg13cmos5l_fill_1
XANTENNA_18 _06775_/B1 VPWR VGND sg13cmos5l_antennanp
XFILLER_60_486 VPWR VGND sg13cmos5l_fill_1
X_07050_ _07050_/Y _06986_/Y _07049_/Y _07050_/B1 VPWR VGND sg13cmos5l_a21oi_1
X_11510__1163 _11510_/RESET_B VPWR VGND sg13cmos5l_tiehi
X_06001_ _06043_/C _11604_/Q _11602_/Q VPWR VGND sg13cmos5l_or2_1
X_11464__1344 _11464_/RESET_B VPWR VGND sg13cmos5l_tiehi
XFILLER_99_144 VPWR VGND sg13cmos5l_decap_8
XFILLER_82_1018 VPWR VGND sg13cmos5l_fill_2
XFILLER_101_105 VPWR VGND sg13cmos5l_decap_8
Xhold2905 hold2905/X _11476_/Q VPWR VGND sg13cmos5l_dlygate4sd3_1
XFILLER_99_199 VPWR VGND sg13cmos5l_fill_2
Xhold2927 hold2927/X _11390_/Q VPWR VGND sg13cmos5l_dlygate4sd3_1
Xhold2938 _09263_/B _10857_/Q VPWR VGND sg13cmos5l_dlygate4sd3_1
Xhold2916 hold2916/X _11399_/Q VPWR VGND sg13cmos5l_dlygate4sd3_1
X_07952_ _07952_/Y _07952_/A _07958_/B VPWR VGND sg13cmos5l_nand2_1
X_06903_ _11636_/D _11707_/D hold2776/X _08640_/A VPWR VGND sg13cmos5l_mux2_1
Xhold2949 _09536_/A _11466_/Q VPWR VGND sg13cmos5l_dlygate4sd3_1
X_07883_ _07883_/Y _07883_/A _07883_/B VPWR VGND sg13cmos5l_nor2_1
X_06834_ _11611_/D _06834_/A VPWR VGND sg13cmos5l_inv_1
X_09622_ _09622_/Y _09220_/A _09620_/Y _09621_/Y VPWR VGND sg13cmos5l_o21ai_1
X_09553_ _09553_/Y _05964_/Y _06512_/B _09553_/B1 _09552_/Y VPWR VGND sg13cmos5l_a22oi_1
XFILLER_102_14 VPWR VGND sg13cmos5l_decap_8
X_08504_ _08504_/Y _08504_/A _08504_/B VPWR VGND sg13cmos5l_nand2_1
X_06765_ _06765_/Y _10581_/B _06389_/C _05893_/Y VPWR VGND sg13cmos5l_a21oi_1
XFILLER_36_461 VPWR VGND sg13cmos5l_fill_1
XFILLER_62_18 VPWR VGND sg13cmos5l_decap_8
XFILLER_51_420 VPWR VGND sg13cmos5l_decap_8
X_10970__1012 _10970_/RESET_B VPWR VGND sg13cmos5l_tiehi
XFILLER_23_100 VPWR VGND sg13cmos5l_decap_4
X_06696_ _06696_/Y _10329_/A _06665_/B _06732_/B _06709_/B _06695_/Y VPWR VGND sg13cmos5l_a221oi_1
X_09484_ _09484_/Y _09540_/A _09484_/B _09484_/C VPWR VGND sg13cmos5l_nor3_1
X_08435_ _08435_/Y _10019_/A _08435_/B VPWR VGND sg13cmos5l_nor2_1
XFILLER_12_807 VPWR VGND sg13cmos5l_decap_8
X_08366_ _08366_/Y _08366_/A _08366_/B VPWR VGND sg13cmos5l_nand2_1
XFILLER_51_475 VPWR VGND sg13cmos5l_fill_1
X_07317_ _07317_/Y _07317_/A _07317_/B VPWR VGND sg13cmos5l_nor2_1
X_08297_ _08297_/Y _08297_/A _08307_/B VPWR VGND sg13cmos5l_nor2_1
X_07248_ _10858_/D _07250_/A _07248_/B VPWR VGND sg13cmos5l_nand2_1
X_07179_ _07179_/Y _08889_/A _11636_/Q _07185_/A _11707_/Q _07182_/C1 VPWR VGND sg13cmos5l_a221oi_1
XFILLER_11_55 VPWR VGND sg13cmos5l_decap_8
XFILLER_106_945 VPWR VGND sg13cmos5l_decap_8
XFILLER_105_433 VPWR VGND sg13cmos5l_decap_8
X_10190_ _10190_/Y _10182_/Y _10183_/Y _10189_/Y _10226_/C1 _06953_/A VPWR VGND sg13cmos5l_a221oi_1
XFILLER_3_538 VPWR VGND sg13cmos5l_fill_1
XFILLER_105_488 VPWR VGND sg13cmos5l_decap_8
XFILLER_78_306 VPWR VGND sg13cmos5l_decap_4
XFILLER_78_339 VPWR VGND sg13cmos5l_decap_4
Xfanout330 _07044_/B1 _06958_/Y VPWR VGND sg13cmos5l_buf_1
Xfanout341 _09608_/B1 _06476_/Y VPWR VGND sg13cmos5l_buf_1
XFILLER_87_873 VPWR VGND sg13cmos5l_decap_4
XFILLER_87_851 VPWR VGND sg13cmos5l_decap_8
Xfanout352 _09644_/A _09910_/A VPWR VGND sg13cmos5l_buf_1
Xfanout374 _10053_/A2 _09303_/Y VPWR VGND sg13cmos5l_buf_1
Xfanout363 _10508_/B1 _10614_/C1 VPWR VGND sg13cmos5l_buf_1
XFILLER_4_1007 VPWR VGND sg13cmos5l_decap_8
XFILLER_98_1003 VPWR VGND sg13cmos5l_decap_8
Xfanout385 _07202_/C _10783_/C VPWR VGND sg13cmos5l_buf_1
XFILLER_59_575 VPWR VGND sg13cmos5l_fill_1
Xfanout396 _09574_/A1 _06459_/Y VPWR VGND sg13cmos5l_buf_1
XFILLER_100_182 VPWR VGND sg13cmos5l_decap_8
XFILLER_46_225 VPWR VGND sg13cmos5l_decap_8
XFILLER_28_973 VPWR VGND sg13cmos5l_decap_8
XFILLER_28_984 VPWR VGND sg13cmos5l_fill_2
XFILLER_61_228 VPWR VGND sg13cmos5l_decap_8
XFILLER_42_420 VPWR VGND sg13cmos5l_decap_4
X_11713_ _11713_/Q _11713_/CLK _11713_/D _11713_/RESET_B VPWR VGND sg13cmos5l_dfrbpq_1
XFILLER_70_762 VPWR VGND sg13cmos5l_decap_4
XFILLER_54_291 VPWR VGND sg13cmos5l_fill_1
X_11644_ _11644_/Q clkload25/A _11644_/D _11644_/RESET_B VPWR VGND sg13cmos5l_dfrbpq_1
XFILLER_52_40 VPWR VGND sg13cmos5l_fill_1
XFILLER_35_1020 VPWR VGND sg13cmos5l_decap_8
XFILLER_11_840 VPWR VGND sg13cmos5l_fill_1
X_11575_ _11575_/Q clkload26/A _11575_/D _11575_/RESET_B VPWR VGND sg13cmos5l_dfrbpq_1
Xinput16 input16/X ui_in[8] VPWR VGND sg13cmos5l_buf_1
X_11199__1702 _11199_/RESET_B VPWR VGND sg13cmos5l_tiehi
X_10526_ _10526_/Y _10526_/A _10526_/B _10526_/C VPWR VGND sg13cmos5l_nand3_1
X_11391__1507 _11391_/RESET_B VPWR VGND sg13cmos5l_tiehi
X_10457_ _10460_/B _11407_/Q _10844_/Q _10452_/Y _10455_/Y _10456_/Y VPWR VGND sg13cmos5l_a221oi_1
XFILLER_6_354 VPWR VGND sg13cmos5l_fill_1
X_10388_ _10403_/C _10434_/A _06236_/A _09696_/A _11507_/Q VPWR VGND sg13cmos5l_a22oi_1
XFILLER_2_593 VPWR VGND sg13cmos5l_fill_1
XFILLER_78_862 VPWR VGND sg13cmos5l_fill_1
X_11122__1779 _11122_/RESET_B VPWR VGND sg13cmos5l_tiehi
XFILLER_77_92 VPWR VGND sg13cmos5l_decap_8
XFILLER_38_737 VPWR VGND sg13cmos5l_fill_2
X_11009_ _11009_/Q clkload42/A _11009_/D _11009_/RESET_B VPWR VGND sg13cmos5l_dfrbpq_1
XFILLER_80_526 VPWR VGND sg13cmos5l_fill_1
XFILLER_19_962 VPWR VGND sg13cmos5l_fill_2
X_06550_ _06551_/B _06573_/A1 _11671_/Q _10865_/Q _06564_/B2 VPWR VGND sg13cmos5l_a22oi_1
XFILLER_61_751 VPWR VGND sg13cmos5l_decap_8
XFILLER_21_604 VPWR VGND sg13cmos5l_fill_2
X_06481_ _06481_/Y _06478_/Y _06480_/Y _09851_/B2 VPWR VGND sg13cmos5l_o21ai_1
XFILLER_33_453 VPWR VGND sg13cmos5l_decap_8
XFILLER_34_965 VPWR VGND sg13cmos5l_fill_2
X_08220_ _08220_/Y _08220_/A _08220_/B VPWR VGND sg13cmos5l_nand2_1
X_08151_ _08151_/Y _08151_/A _08171_/B VPWR VGND sg13cmos5l_nor2_1
X_07102_ _11716_/D _05890_/Y _07132_/A2 _07101_/Y VPWR VGND sg13cmos5l_a21oi_1
X_08082_ _08082_/Y _08082_/A _08088_/B VPWR VGND sg13cmos5l_nand2_1
X_07033_ _07033_/Y _11509_/Q _07036_/B _07032_/Y VPWR VGND sg13cmos5l_a21oi_1
XFILLER_103_926 VPWR VGND sg13cmos5l_decap_8
Xhold2702 _11684_/D _06910_/X VPWR VGND sg13cmos5l_dlygate4sd3_1
Xhold2713 _07192_/A _07190_/Y VPWR VGND sg13cmos5l_dlygate4sd3_1
X_08984_ _08984_/Y _09022_/B _08984_/B VPWR VGND sg13cmos5l_xnor2_1
Xhold2735 _06780_/B _11555_/Q VPWR VGND sg13cmos5l_dlygate4sd3_1
Xhold2724 hold2724/X _11725_/Q VPWR VGND sg13cmos5l_dlygate4sd3_1
Xhold2746 hold2746/X _11736_/Q VPWR VGND sg13cmos5l_dlygate4sd3_1
X_07935_ _11057_/D _08522_/A1 _07966_/B _07934_/Y VPWR VGND sg13cmos5l_o21ai_1
XFILLER_84_821 VPWR VGND sg13cmos5l_decap_4
Xhold2768 hold2768/X _11416_/Q VPWR VGND sg13cmos5l_dlygate4sd3_1
Xhold2757 _05972_/A _10845_/Q VPWR VGND sg13cmos5l_dlygate4sd3_1
Xhold2779 _10844_/D _07220_/Y VPWR VGND sg13cmos5l_dlygate4sd3_1
XFILLER_28_214 VPWR VGND sg13cmos5l_decap_8
X_07866_ _11023_/D _08518_/A1 _07877_/B _07865_/Y VPWR VGND sg13cmos5l_a21oi_1
XFILLER_28_247 VPWR VGND sg13cmos5l_decap_8
X_09605_ _09605_/Y _11352_/Q _09593_/B _09605_/B1 VPWR VGND sg13cmos5l_a21oi_1
X_06817_ _06817_/Y _06946_/D _06861_/B VPWR VGND sg13cmos5l_nand2_1
XFILLER_56_589 VPWR VGND sg13cmos5l_fill_1
X_07797_ _10990_/D _08451_/A1 _07814_/B _07796_/Y VPWR VGND sg13cmos5l_o21ai_1
XFILLER_28_269 VPWR VGND sg13cmos5l_fill_2
XFILLER_71_526 VPWR VGND sg13cmos5l_decap_8
X_11277__1624 _11277_/RESET_B VPWR VGND sg13cmos5l_tiehi
X_09536_ _09614_/A _09536_/A _09536_/B VPWR VGND sg13cmos5l_nor2_1
X_06748_ _06748_/Y _06748_/A _06748_/B VPWR VGND sg13cmos5l_xnor2_1
X_09467_ _09467_/Y _10899_/Q _09576_/B _09577_/B1 VPWR VGND sg13cmos5l_a21oi_1
XFILLER_19_1026 VPWR VGND sg13cmos5l_fill_2
X_08418_ _11294_/D fanout76/X _08439_/B _08417_/Y VPWR VGND sg13cmos5l_a21oi_1
XFILLER_51_261 VPWR VGND sg13cmos5l_decap_8
XFILLER_51_250 VPWR VGND sg13cmos5l_fill_1
XFILLER_12_615 VPWR VGND sg13cmos5l_fill_1
X_06679_ _06679_/X _06679_/A _06685_/B VPWR VGND sg13cmos5l_and2_1
XFILLER_24_497 VPWR VGND sg13cmos5l_fill_2
XFILLER_51_294 VPWR VGND sg13cmos5l_decap_8
XFILLER_11_147 VPWR VGND sg13cmos5l_decap_4
X_09398_ _09398_/Y _11280_/Q _09578_/A2 _09397_/Y VPWR VGND sg13cmos5l_o21ai_1
X_08349_ _11260_/D fanout81/X _08348_/B _08348_/Y VPWR VGND sg13cmos5l_o21ai_1
X_11360_ _11360_/Q clkload56/A _11360_/D _11360_/RESET_B VPWR VGND sg13cmos5l_dfrbpq_1
XFILLER_22_54 VPWR VGND sg13cmos5l_fill_1
XFILLER_98_14 VPWR VGND sg13cmos5l_decap_8
X_10311_ _10311_/Y _10545_/A _10545_/B VPWR VGND sg13cmos5l_nor2_1
XFILLER_106_742 VPWR VGND sg13cmos5l_decap_8
X_11291_ _11291_/Q _11355_/CLK _11291_/D _11291_/RESET_B VPWR VGND sg13cmos5l_dfrbpq_1
XFILLER_105_252 VPWR VGND sg13cmos5l_decap_8
X_10242_ _10265_/A _10267_/A _10242_/B _10267_/B _10267_/C VPWR VGND sg13cmos5l_and4_1
XFILLER_3_357 VPWR VGND sg13cmos5l_fill_2
X_10173_ _10173_/Y _10173_/A _10173_/B VPWR VGND sg13cmos5l_nor2_1
XFILLER_78_169 VPWR VGND sg13cmos5l_decap_4
XFILLER_94_629 VPWR VGND sg13cmos5l_fill_2
Xfanout182 _08403_/B _08401_/B VPWR VGND sg13cmos5l_buf_1
Xfanout171 _08527_/B _08533_/B VPWR VGND sg13cmos5l_buf_1
Xfanout160 _07365_/B _07371_/B VPWR VGND sg13cmos5l_buf_1
XFILLER_47_545 VPWR VGND sg13cmos5l_fill_1
XFILLER_47_51 VPWR VGND sg13cmos5l_fill_1
Xfanout193 _08263_/B _08273_/B VPWR VGND sg13cmos5l_buf_1
XFILLER_90_835 VPWR VGND sg13cmos5l_fill_2
XFILLER_34_217 VPWR VGND sg13cmos5l_fill_2
XFILLER_34_228 VPWR VGND sg13cmos5l_decap_8
XFILLER_34_239 VPWR VGND sg13cmos5l_fill_2
XFILLER_43_740 VPWR VGND sg13cmos5l_decap_8
XFILLER_16_954 VPWR VGND sg13cmos5l_fill_2
XFILLER_16_965 VPWR VGND sg13cmos5l_fill_1
XFILLER_27_291 VPWR VGND sg13cmos5l_fill_2
XFILLER_63_83 VPWR VGND sg13cmos5l_fill_1
XFILLER_42_272 VPWR VGND sg13cmos5l_decap_8
XFILLER_16_998 VPWR VGND sg13cmos5l_decap_8
XFILLER_31_946 VPWR VGND sg13cmos5l_decap_4
XFILLER_30_423 VPWR VGND sg13cmos5l_decap_4
X_11627_ _11627_/Q clkload29/A _11627_/D _11627_/RESET_B VPWR VGND sg13cmos5l_dfrbpq_1
XFILLER_30_478 VPWR VGND sg13cmos5l_decap_4
X_11558_ _11558_/Q clkload29/A _11558_/D _11558_/RESET_B VPWR VGND sg13cmos5l_dfrbpq_1
X_10509_ _10509_/Y _11735_/Q _10548_/B fanout84/X VPWR VGND sg13cmos5l_a21oi_1
XFILLER_7_663 VPWR VGND sg13cmos5l_decap_8
X_11489_ _11489_/Q clkload13/A _11489_/D _11489_/RESET_B VPWR VGND sg13cmos5l_dfrbpq_1
Xhold2009 _07832_/A _11008_/Q VPWR VGND sg13cmos5l_dlygate4sd3_1
X_11355__1546 _11355_/RESET_B VPWR VGND sg13cmos5l_tiehi
XFILLER_98_979 VPWR VGND sg13cmos5l_decap_8
XFILLER_2_390 VPWR VGND sg13cmos5l_fill_1
XFILLER_100_929 VPWR VGND sg13cmos5l_fill_2
X_05981_ _05981_/Y _11330_/Q VPWR VGND sg13cmos5l_inv_1
X_07720_ _08506_/C _11562_/Q _11561_/Q _07720_/C VPWR VGND sg13cmos5l_nand3b_1
XFILLER_66_810 VPWR VGND sg13cmos5l_decap_8
XFILLER_38_501 VPWR VGND sg13cmos5l_fill_2
XFILLER_93_640 VPWR VGND sg13cmos5l_decap_4
XFILLER_81_813 VPWR VGND sg13cmos5l_fill_1
XFILLER_81_802 VPWR VGND sg13cmos5l_fill_2
X_07651_ _08770_/B _11550_/Q _10825_/Q _07651_/S VPWR VGND sg13cmos5l_mux2_1
XFILLER_66_876 VPWR VGND sg13cmos5l_decap_4
XFILLER_93_695 VPWR VGND sg13cmos5l_fill_1
X_07582_ _08730_/B _11540_/Q _10815_/Q _07582_/S VPWR VGND sg13cmos5l_mux2_1
X_06602_ _06604_/A _06631_/S _06602_/B _06602_/C VPWR VGND sg13cmos5l_nor3_1
X_09321_ _09321_/Y _09321_/A _09321_/B VPWR VGND sg13cmos5l_xnor2_1
X_06533_ _06533_/Y _06533_/A _06533_/B VPWR VGND sg13cmos5l_nand2_1
XFILLER_40_209 VPWR VGND sg13cmos5l_decap_8
XFILLER_21_412 VPWR VGND sg13cmos5l_fill_2
XFILLER_22_913 VPWR VGND sg13cmos5l_decap_8
XFILLER_34_784 VPWR VGND sg13cmos5l_fill_1
X_09252_ _09862_/C _09909_/A _10853_/Q VPWR VGND sg13cmos5l_xor2_1
X_06464_ _06466_/A _10140_/A _11388_/Q VPWR VGND sg13cmos5l_nor2_1
XFILLER_22_968 VPWR VGND sg13cmos5l_decap_4
X_06395_ _06395_/X _11623_/Q _11610_/Q VPWR VGND sg13cmos5l_or2_1
X_09183_ _09183_/Y _09183_/A VPWR VGND sg13cmos5l_inv_1
X_08203_ _11188_/D _08333_/A1 _08202_/B _08202_/Y VPWR VGND sg13cmos5l_o21ai_1
XFILLER_21_467 VPWR VGND sg13cmos5l_decap_8
X_08134_ _11154_/D _08329_/A1 _08141_/B _08133_/Y VPWR VGND sg13cmos5l_a21oi_1
X_08065_ _11121_/D _08457_/A1 _08096_/B _08064_/Y VPWR VGND sg13cmos5l_o21ai_1
XFILLER_1_817 VPWR VGND sg13cmos5l_decap_8
X_07016_ _07016_/Y _07016_/A _07024_/B VPWR VGND sg13cmos5l_nor2_1
XFILLER_103_712 VPWR VGND sg13cmos5l_fill_2
XFILLER_88_456 VPWR VGND sg13cmos5l_decap_8
XFILLER_88_445 VPWR VGND sg13cmos5l_fill_2
Xhold2521 hold2521/X _11657_/Q VPWR VGND sg13cmos5l_dlygate4sd3_1
Xhold2510 _11677_/D _07057_/X VPWR VGND sg13cmos5l_dlygate4sd3_1
XFILLER_102_266 VPWR VGND sg13cmos5l_decap_8
Xhold2532 hold2532/X _11715_/Q VPWR VGND sg13cmos5l_dlygate4sd3_1
Xhold2565 _08620_/A _11375_/Q VPWR VGND sg13cmos5l_dlygate4sd3_1
X_08967_ _08967_/Y _08967_/A _08967_/B VPWR VGND sg13cmos5l_nor2_1
Xhold2543 _07407_/A _10885_/Q VPWR VGND sg13cmos5l_dlygate4sd3_1
Xhold2554 _07347_/A _10875_/Q VPWR VGND sg13cmos5l_dlygate4sd3_1
XFILLER_29_501 VPWR VGND sg13cmos5l_decap_8
X_07918_ _11049_/D fanout50/X _07917_/B _07917_/Y VPWR VGND sg13cmos5l_a21oi_1
Xhold2576 _11579_/D _10763_/X VPWR VGND sg13cmos5l_dlygate4sd3_1
Xhold1831 _06141_/B _11572_/Q VPWR VGND sg13cmos5l_dlygate4sd3_1
XFILLER_57_832 VPWR VGND sg13cmos5l_decap_8
X_08898_ _08898_/Y _08906_/B _08898_/B VPWR VGND sg13cmos5l_xnor2_1
Xhold2598 _07070_/A _11681_/Q VPWR VGND sg13cmos5l_dlygate4sd3_1
Xhold1853 _07818_/A _11001_/Q VPWR VGND sg13cmos5l_dlygate4sd3_1
Xhold2587 hold2587/X _11679_/Q VPWR VGND sg13cmos5l_dlygate4sd3_1
Xhold1842 _08204_/A _11189_/Q VPWR VGND sg13cmos5l_dlygate4sd3_1
X_07849_ _11016_/D fanout51/X _07850_/B _07848_/Y VPWR VGND sg13cmos5l_o21ai_1
Xhold1875 _08504_/A _11337_/Q VPWR VGND sg13cmos5l_dlygate4sd3_1
XFILLER_72_824 VPWR VGND sg13cmos5l_decap_4
XFILLER_72_802 VPWR VGND sg13cmos5l_decap_4
Xhold1886 _08468_/A _11319_/Q VPWR VGND sg13cmos5l_dlygate4sd3_1
Xhold1864 _08344_/A _11258_/Q VPWR VGND sg13cmos5l_dlygate4sd3_1
XFILLER_16_206 VPWR VGND sg13cmos5l_decap_8
XFILLER_95_1028 VPWR VGND sg13cmos5l_fill_1
XFILLER_95_1017 VPWR VGND sg13cmos5l_decap_8
Xhold1897 _08098_/A _11138_/Q VPWR VGND sg13cmos5l_dlygate4sd3_1
XFILLER_16_217 VPWR VGND sg13cmos5l_fill_1
X_10860_ _10860_/Q clkload7/A _10860_/D _10860_/RESET_B VPWR VGND sg13cmos5l_dfrbpq_1
XFILLER_71_367 VPWR VGND sg13cmos5l_fill_1
X_09519_ _09519_/Y _10901_/Q _09652_/S _09842_/B1 VPWR VGND sg13cmos5l_a21oi_1
X_10791_ _10791_/Y _10791_/A _10791_/B VPWR VGND sg13cmos5l_nand2_1
X_10847__1148 _10847_/RESET_B VPWR VGND sg13cmos5l_tiehi
XFILLER_24_261 VPWR VGND sg13cmos5l_fill_1
XFILLER_31_209 VPWR VGND sg13cmos5l_decap_8
X_11433__1424 _11433_/RESET_B VPWR VGND sg13cmos5l_tiehi
XFILLER_9_906 VPWR VGND sg13cmos5l_decap_4
XFILLER_33_53 VPWR VGND sg13cmos5l_fill_1
X_11484__1215 _11484_/RESET_B VPWR VGND sg13cmos5l_tiehi
X_11412_ _11412_/Q clkload43/A _11412_/D _11412_/RESET_B VPWR VGND sg13cmos5l_dfrbpq_1
XFILLER_40_798 VPWR VGND sg13cmos5l_decap_8
X_11343_ _11343_/Q clkload44/A _11343_/D _11343_/RESET_B VPWR VGND sg13cmos5l_dfrbpq_1
X_11274_ _11274_/Q _11622_/CLK _11274_/D _11274_/RESET_B VPWR VGND sg13cmos5l_dfrbpq_1
XFILLER_79_434 VPWR VGND sg13cmos5l_fill_2
X_10225_ _10225_/Y hold2837/X _09335_/B _10168_/B VPWR VGND sg13cmos5l_a21oi_1
XFILLER_3_187 VPWR VGND sg13cmos5l_fill_2
XFILLER_95_916 VPWR VGND sg13cmos5l_decap_4
XFILLER_79_467 VPWR VGND sg13cmos5l_decap_8
X_10156_ _10156_/Y _10681_/B2 _09297_/Y _10149_/B VPWR VGND sg13cmos5l_a21oi_1
XFILLER_58_83 VPWR VGND sg13cmos5l_decap_8
XFILLER_48_832 VPWR VGND sg13cmos5l_fill_2
XFILLER_47_331 VPWR VGND sg13cmos5l_decap_8
XFILLER_0_894 VPWR VGND sg13cmos5l_decap_8
X_10087_ _10087_/Y _10356_/A1 _09504_/B _10086_/Y VPWR VGND sg13cmos5l_a21oi_1
XFILLER_47_342 VPWR VGND sg13cmos5l_fill_1
XFILLER_90_610 VPWR VGND sg13cmos5l_fill_2
XFILLER_74_172 VPWR VGND sg13cmos5l_fill_2
XFILLER_47_386 VPWR VGND sg13cmos5l_fill_1
XFILLER_62_356 VPWR VGND sg13cmos5l_fill_2
XFILLER_62_345 VPWR VGND sg13cmos5l_decap_8
XFILLER_50_518 VPWR VGND sg13cmos5l_decap_8
X_10989_ _10989_/Q clkload34/A _10989_/D _10989_/RESET_B VPWR VGND sg13cmos5l_dfrbpq_1
XFILLER_15_261 VPWR VGND sg13cmos5l_fill_2
XFILLER_22_209 VPWR VGND sg13cmos5l_decap_8
X_11678__1286 _11678_/RESET_B VPWR VGND sg13cmos5l_tiehi
XFILLER_31_721 VPWR VGND sg13cmos5l_fill_1
XFILLER_43_581 VPWR VGND sg13cmos5l_fill_1
XFILLER_31_765 VPWR VGND sg13cmos5l_decap_4
XFILLER_8_950 VPWR VGND sg13cmos5l_fill_1
X_06180_ _06610_/B _06181_/A _09354_/A VPWR VGND sg13cmos5l_nand2_1
XFILLER_7_471 VPWR VGND sg13cmos5l_fill_2
X_09870_ _09870_/Y _11106_/Q _09870_/B VPWR VGND sg13cmos5l_nand2_1
X_08821_ _08821_/Y _08832_/A1 _08817_/D _08831_/B1 VPWR VGND sg13cmos5l_o21ai_1
XFILLER_58_618 VPWR VGND sg13cmos5l_decap_8
X_08752_ _08753_/A _10604_/A _09093_/B _09102_/A _09106_/B1 VPWR VGND sg13cmos5l_a22oi_1
XFILLER_57_128 VPWR VGND sg13cmos5l_decap_8
XFILLER_38_331 VPWR VGND sg13cmos5l_fill_2
X_05964_ _05964_/Y _11318_/Q VPWR VGND sg13cmos5l_inv_1
XFILLER_94_971 VPWR VGND sg13cmos5l_fill_1
XFILLER_65_150 VPWR VGND sg13cmos5l_decap_8
X_08683_ _08684_/A hold2786/X _08895_/B _08890_/B _08922_/A VPWR VGND sg13cmos5l_a22oi_1
XFILLER_39_876 VPWR VGND sg13cmos5l_decap_8
XFILLER_38_364 VPWR VGND sg13cmos5l_decap_8
X_07703_ _10945_/D fanout67/X _07702_/B _07702_/Y VPWR VGND sg13cmos5l_a21oi_1
XFILLER_93_470 VPWR VGND sg13cmos5l_fill_1
X_05895_ _09940_/A _09268_/A VPWR VGND sg13cmos5l_inv_1
X_07634_ _10918_/D _07629_/B fanout55/X _07629_/Y VPWR VGND sg13cmos5l_a21oi_1
XFILLER_65_172 VPWR VGND sg13cmos5l_fill_1
XFILLER_65_161 VPWR VGND sg13cmos5l_decap_8
XFILLER_55_1012 VPWR VGND sg13cmos5l_decap_8
X_07565_ _07565_/Y _07577_/A _08716_/B _07564_/Y VPWR VGND sg13cmos5l_a21oi_1
X_09304_ _09305_/D _10679_/A _09911_/B _09302_/Y VPWR VGND sg13cmos5l_a21oi_1
X_07496_ _10898_/D _07526_/B _08329_/A1 _07495_/Y VPWR VGND sg13cmos5l_a21oi_1
X_06516_ _06516_/Y _09574_/A1 _06510_/X _09574_/B1 VPWR VGND sg13cmos5l_a21oi_1
XFILLER_34_592 VPWR VGND sg13cmos5l_decap_8
X_06447_ _06447_/Y _06242_/A _06758_/B1 _06446_/Y VPWR VGND sg13cmos5l_a21oi_1
X_09235_ _09649_/B _09696_/A _10845_/Q VPWR VGND sg13cmos5l_xnor2_1
X_09166_ _09168_/A _09837_/A _09171_/B _09166_/C _09166_/D VPWR VGND sg13cmos5l_nor4_1
XFILLER_5_419 VPWR VGND sg13cmos5l_fill_2
X_06378_ _06378_/Y _10427_/A _06378_/B VPWR VGND sg13cmos5l_nand2_1
X_08117_ _08117_/Y _08117_/A _08169_/B VPWR VGND sg13cmos5l_nor2_1
X_09097_ _09121_/A _09097_/A _09097_/B VPWR VGND sg13cmos5l_or2_1
X_08048_ _11113_/D fanout50/X _08047_/B _08047_/Y VPWR VGND sg13cmos5l_a21oi_1
X_10010_ _10010_/Y _11047_/Q _10007_/B _10015_/B1 VPWR VGND sg13cmos5l_a21oi_1
Xhold2340 _07615_/A _10916_/Q VPWR VGND sg13cmos5l_dlygate4sd3_1
XFILLER_77_927 VPWR VGND sg13cmos5l_decap_8
XFILLER_76_426 VPWR VGND sg13cmos5l_decap_4
X_09999_ _09999_/Y _09856_/A _09885_/B _10026_/A VPWR VGND sg13cmos5l_a21oi_1
XFILLER_0_157 VPWR VGND sg13cmos5l_decap_8
Xhold2351 _07784_/A _10985_/Q VPWR VGND sg13cmos5l_dlygate4sd3_1
Xhold2373 _07762_/A _10974_/Q VPWR VGND sg13cmos5l_dlygate4sd3_1
X_11590__1427 _11590_/RESET_B VPWR VGND sg13cmos5l_tiehi
XFILLER_48_139 VPWR VGND sg13cmos5l_fill_1
Xhold2362 _07676_/A _10932_/Q VPWR VGND sg13cmos5l_dlygate4sd3_1
XFILLER_29_320 VPWR VGND sg13cmos5l_fill_1
Xhold2395 _07857_/A _11019_/Q VPWR VGND sg13cmos5l_dlygate4sd3_1
Xhold2384 _07595_/A _10913_/Q VPWR VGND sg13cmos5l_dlygate4sd3_1
X_10912_ _10912_/Q clkload56/A _10912_/D _10912_/RESET_B VPWR VGND sg13cmos5l_dfrbpq_1
XFILLER_72_610 VPWR VGND sg13cmos5l_decap_8
XFILLER_17_526 VPWR VGND sg13cmos5l_fill_2
XFILLER_28_86 VPWR VGND sg13cmos5l_decap_4
XFILLER_29_397 VPWR VGND sg13cmos5l_decap_8
XFILLER_72_643 VPWR VGND sg13cmos5l_decap_8
X_10843_ _10843_/Q _11535_/CLK _10843_/D _10843_/RESET_B VPWR VGND sg13cmos5l_dfrbpq_1
XFILLER_32_507 VPWR VGND sg13cmos5l_decap_8
X_10774_ _10774_/Y _10774_/A _10776_/B VPWR VGND sg13cmos5l_nand2_1
XFILLER_25_592 VPWR VGND sg13cmos5l_decap_4
XFILLER_100_91 VPWR VGND sg13cmos5l_decap_8
XFILLER_60_84 VPWR VGND sg13cmos5l_decap_8
X_11326_ _11326_/Q clkload56/A _11326_/D _11326_/RESET_B VPWR VGND sg13cmos5l_dfrbpq_1
XFILLER_5_35 VPWR VGND sg13cmos5l_decap_8
X_11257_ _11257_/Q _11265_/CLK _11257_/D _11257_/RESET_B VPWR VGND sg13cmos5l_dfrbpq_1
XFILLER_79_264 VPWR VGND sg13cmos5l_decap_4
X_10208_ _10208_/Y _10226_/C1 _10205_/Y _10206_/Y _10207_/Y _06953_/A VPWR VGND sg13cmos5l_a221oi_1
X_11188_ _11188_/Q clkload9/A _11188_/D _11188_/RESET_B VPWR VGND sg13cmos5l_dfrbpq_1
XFILLER_95_757 VPWR VGND sg13cmos5l_decap_4
XFILLER_95_746 VPWR VGND sg13cmos5l_decap_4
XFILLER_94_223 VPWR VGND sg13cmos5l_fill_2
XFILLER_79_286 VPWR VGND sg13cmos5l_fill_2
X_10139_ _10139_/Y _11513_/Q _10149_/B VPWR VGND sg13cmos5l_nand2_1
XFILLER_39_128 VPWR VGND sg13cmos5l_fill_2
XFILLER_76_993 VPWR VGND sg13cmos5l_fill_1
XFILLER_76_982 VPWR VGND sg13cmos5l_decap_8
XFILLER_63_665 VPWR VGND sg13cmos5l_fill_1
XFILLER_62_120 VPWR VGND sg13cmos5l_decap_8
XFILLER_47_183 VPWR VGND sg13cmos5l_decap_8
XFILLER_39_1007 VPWR VGND sg13cmos5l_decap_8
XFILLER_50_315 VPWR VGND sg13cmos5l_decap_4
XFILLER_51_849 VPWR VGND sg13cmos5l_fill_2
X_07350_ _08717_/A _08979_/A _07362_/B VPWR VGND sg13cmos5l_nand2_1
X_06301_ _06686_/A _11501_/Q _09643_/A VPWR VGND sg13cmos5l_nor2_1
X_09020_ _09020_/Y _09020_/A _09020_/B VPWR VGND sg13cmos5l_nor2_1
X_07281_ _07281_/Y _07281_/A _07347_/B VPWR VGND sg13cmos5l_nor2_1
X_06232_ _06234_/A _10424_/B _10298_/A VPWR VGND sg13cmos5l_and2_1
XFILLER_8_780 VPWR VGND sg13cmos5l_fill_1
X_06163_ _06658_/A _11498_/Q _09559_/A VPWR VGND sg13cmos5l_nor2_1
X_06094_ _06122_/B _06117_/A input18/X VPWR VGND sg13cmos5l_and2_1
XFILLER_104_339 VPWR VGND sg13cmos5l_fill_1
X_09922_ _09922_/Y _10980_/Q _09934_/B _09932_/S1 VPWR VGND sg13cmos5l_a21oi_1
Xfanout704 _06441_/A1 _11615_/Q VPWR VGND sg13cmos5l_buf_1
Xfanout715 _09137_/A _09063_/A1 VPWR VGND sg13cmos5l_buf_1
XFILLER_105_14 VPWR VGND sg13cmos5l_decap_8
XFILLER_86_724 VPWR VGND sg13cmos5l_fill_2
Xfanout748 _09938_/A hold2892/X VPWR VGND sg13cmos5l_buf_1
Xfanout726 _10268_/A _11509_/Q VPWR VGND sg13cmos5l_buf_1
X_09853_ _09860_/B _09996_/A _09853_/B VPWR VGND sg13cmos5l_nor2_1
Xfanout737 _10479_/C _11505_/Q VPWR VGND sg13cmos5l_buf_1
X_08804_ _08805_/B _08793_/B _08795_/B _08791_/Y VPWR VGND sg13cmos5l_a21oi_1
X_09784_ _09784_/Y _09171_/D _09782_/Y _09783_/Y VPWR VGND sg13cmos5l_o21ai_1
Xfanout759 _10434_/A _10305_/A VPWR VGND sg13cmos5l_buf_1
XFILLER_85_256 VPWR VGND sg13cmos5l_fill_2
X_08735_ _08736_/A hold2825/X _08739_/A2 _09036_/C _08739_/B2 VPWR VGND sg13cmos5l_a22oi_1
X_06996_ _06996_/Y _06994_/Y _06995_/Y _07062_/S VPWR VGND sg13cmos5l_a21oi_1
X_05947_ _06868_/A _11687_/Q VPWR VGND sg13cmos5l_inv_1
XFILLER_81_440 VPWR VGND sg13cmos5l_fill_1
X_05878_ _05878_/Y input4/X VPWR VGND sg13cmos5l_inv_1
X_08666_ _11397_/D _08666_/A VPWR VGND sg13cmos5l_inv_1
XFILLER_38_183 VPWR VGND sg13cmos5l_decap_4
XFILLER_26_334 VPWR VGND sg13cmos5l_fill_1
X_11135__1766 _11135_/RESET_B VPWR VGND sg13cmos5l_tiehi
X_08597_ _08598_/C _08593_/Y _08594_/Y _08595_/Y _08596_/Y _10016_/C1 VPWR VGND sg13cmos5l_a221oi_1
X_07617_ _07623_/B _11418_/Q _10591_/A _07617_/C VPWR VGND sg13cmos5l_nand3_1
X_11621__1349 _11621_/RESET_B VPWR VGND sg13cmos5l_tiehi
XFILLER_81_28 VPWR VGND sg13cmos5l_decap_4
X_07548_ _07548_/X _07582_/S _10810_/Q VPWR VGND sg13cmos5l_and2_1
XFILLER_14_44 VPWR VGND sg13cmos5l_fill_2
XFILLER_22_595 VPWR VGND sg13cmos5l_decap_4
X_07479_ _07500_/D _07479_/A _07479_/B VPWR VGND sg13cmos5l_nor2_1
X_10490_ _10490_/Y _11734_/Q _10548_/B fanout84/X VPWR VGND sg13cmos5l_a21oi_1
XFILLER_6_706 VPWR VGND sg13cmos5l_decap_8
X_11350__1551 _11350_/RESET_B VPWR VGND sg13cmos5l_tiehi
X_09218_ _09620_/A _09218_/A _09218_/B VPWR VGND sg13cmos5l_nand2_1
X_09149_ _09151_/A _09150_/A _09138_/B _09124_/Y _09148_/Y _09126_/Y VPWR VGND sg13cmos5l_a221oi_1
XFILLER_5_216 VPWR VGND sg13cmos5l_fill_2
X_11111_ _11111_/Q _11364_/CLK _11111_/D _11111_/RESET_B VPWR VGND sg13cmos5l_dfrbpq_1
XFILLER_2_934 VPWR VGND sg13cmos5l_decap_8
XFILLER_104_873 VPWR VGND sg13cmos5l_decap_8
X_11042_ _11042_/Q _11362_/CLK _11042_/D _11042_/RESET_B VPWR VGND sg13cmos5l_dfrbpq_1
XFILLER_89_584 VPWR VGND sg13cmos5l_decap_8
XFILLER_39_41 VPWR VGND sg13cmos5l_decap_4
XFILLER_103_372 VPWR VGND sg13cmos5l_decap_8
XFILLER_92_716 VPWR VGND sg13cmos5l_fill_2
XFILLER_92_705 VPWR VGND sg13cmos5l_fill_1
Xhold2181 _07889_/A _11035_/Q VPWR VGND sg13cmos5l_dlygate4sd3_1
Xhold2170 _07999_/A _11089_/Q VPWR VGND sg13cmos5l_dlygate4sd3_1
Xhold2192 _08169_/A _11172_/Q VPWR VGND sg13cmos5l_dlygate4sd3_1
XFILLER_17_312 VPWR VGND sg13cmos5l_fill_1
XFILLER_18_835 VPWR VGND sg13cmos5l_fill_2
XFILLER_55_40 VPWR VGND sg13cmos5l_decap_4
XFILLER_29_194 VPWR VGND sg13cmos5l_decap_8
XFILLER_73_974 VPWR VGND sg13cmos5l_fill_2
X_10826_ _10826_/Q clkload30/A _10826_/D _10826_/RESET_B VPWR VGND sg13cmos5l_dfrbpq_1
XFILLER_72_484 VPWR VGND sg13cmos5l_decap_8
XFILLER_60_668 VPWR VGND sg13cmos5l_decap_4
XFILLER_41_860 VPWR VGND sg13cmos5l_fill_2
X_10757_ _10757_/X _11688_/Q hold2614/X _10760_/S VPWR VGND sg13cmos5l_mux2_1
XFILLER_9_544 VPWR VGND sg13cmos5l_fill_2
X_10688_ _10688_/Y _10688_/A _10688_/B VPWR VGND sg13cmos5l_nor2_1
X_10924__1058 _10924_/RESET_B VPWR VGND sg13cmos5l_tiehi
XFILLER_99_348 VPWR VGND sg13cmos5l_fill_2
X_11309_ _11309_/Q clkload34/A _11309_/D _11309_/RESET_B VPWR VGND sg13cmos5l_dfrbpq_1
XFILLER_68_724 VPWR VGND sg13cmos5l_decap_8
XFILLER_68_702 VPWR VGND sg13cmos5l_decap_8
X_11213__1688 _11213_/RESET_B VPWR VGND sg13cmos5l_tiehi
X_06850_ _06850_/Y _06850_/A _06861_/B VPWR VGND sg13cmos5l_nand2_1
XFILLER_68_757 VPWR VGND sg13cmos5l_fill_1
XFILLER_82_204 VPWR VGND sg13cmos5l_fill_1
X_06781_ _06781_/Y _11555_/Q _08774_/B VPWR VGND sg13cmos5l_nand2b_1
XFILLER_48_470 VPWR VGND sg13cmos5l_fill_2
X_08520_ _11344_/D _08520_/A1 _08527_/B _08519_/Y VPWR VGND sg13cmos5l_a21oi_1
X_08451_ _11310_/D _08451_/A1 _08462_/B _08450_/Y VPWR VGND sg13cmos5l_o21ai_1
XFILLER_35_153 VPWR VGND sg13cmos5l_decap_8
XFILLER_51_646 VPWR VGND sg13cmos5l_decap_8
XFILLER_51_624 VPWR VGND sg13cmos5l_fill_2
X_07402_ _10884_/D _07401_/B _07400_/Y _07401_/Y VPWR VGND sg13cmos5l_a21oi_1
XFILLER_23_326 VPWR VGND sg13cmos5l_fill_1
XFILLER_23_348 VPWR VGND sg13cmos5l_fill_1
X_08382_ _11276_/D _08512_/A1 _08423_/B _08381_/Y VPWR VGND sg13cmos5l_a21oi_1
XFILLER_32_871 VPWR VGND sg13cmos5l_fill_2
X_07333_ _07333_/Y _07331_/Y _07332_/Y _07340_/A2 VPWR VGND sg13cmos5l_a21oi_1
X_07264_ _07264_/Y _07359_/B _07262_/Y _07263_/Y VPWR VGND sg13cmos5l_a21oi_1
XFILLER_31_381 VPWR VGND sg13cmos5l_decap_8
X_09003_ _11442_/D _09001_/Y _09002_/Y _08990_/Y VPWR VGND sg13cmos5l_o21ai_1
X_06215_ _06224_/C _06756_/A _06748_/A VPWR VGND sg13cmos5l_nor2_1
X_11529__1125 _11529_/RESET_B VPWR VGND sg13cmos5l_tiehi
X_07195_ _07196_/B _10836_/Q _07205_/B _07185_/X _07193_/X VPWR VGND sg13cmos5l_a22oi_1
X_06146_ _06146_/Y _06146_/A _09217_/A VPWR VGND sg13cmos5l_nor2_1
XFILLER_104_147 VPWR VGND sg13cmos5l_decap_8
X_06077_ _06084_/A _08819_/A _10719_/C VPWR VGND sg13cmos5l_nor2_1
X_09905_ _09905_/Y _11363_/Q _09894_/B _10046_/B1 _09904_/Y VPWR VGND sg13cmos5l_a22oi_1
Xfanout512 _09055_/B _08739_/A2 VPWR VGND sg13cmos5l_buf_1
Xfanout523 _07452_/B _07530_/A VPWR VGND sg13cmos5l_buf_1
Xfanout501 _09668_/B _09480_/B VPWR VGND sg13cmos5l_buf_1
XFILLER_101_821 VPWR VGND sg13cmos5l_decap_4
XFILLER_101_810 VPWR VGND sg13cmos5l_fill_2
XFILLER_76_39 VPWR VGND sg13cmos5l_decap_8
Xfanout534 _07416_/B _08651_/B VPWR VGND sg13cmos5l_buf_1
Xfanout556 _07376_/A2 _07375_/B1 VPWR VGND sg13cmos5l_buf_1
Xfanout545 _07024_/B _07055_/B VPWR VGND sg13cmos5l_buf_1
Xfanout578 _06401_/C _06775_/B1 VPWR VGND sg13cmos5l_buf_1
Xfanout567 _07239_/A2 _07212_/A2 VPWR VGND sg13cmos5l_buf_1
Xfanout589 _07142_/A2 _07150_/A2 VPWR VGND sg13cmos5l_buf_1
X_09836_ _11478_/D _10287_/A _09915_/A _09813_/Y _09835_/Y VPWR VGND sg13cmos5l_a22oi_1
X_11673__1291 _11673_/RESET_B VPWR VGND sg13cmos5l_tiehi
X_09767_ _09767_/X _11262_/Q _11230_/Q _11198_/Q _11166_/Q _09814_/S _10035_/B1 VPWR
+ VGND sg13cmos5l_mux4_1
XFILLER_74_738 VPWR VGND sg13cmos5l_decap_8
X_06979_ _06979_/Y _06982_/B1 _11496_/Q VPWR VGND sg13cmos5l_nand2b_1
X_11368__1533 _11368_/RESET_B VPWR VGND sg13cmos5l_tiehi
X_08718_ _08997_/A _08981_/B VPWR VGND sg13cmos5l_inv_1
XFILLER_26_120 VPWR VGND sg13cmos5l_decap_8
X_09698_ _09698_/Y _11409_/Q _09725_/B _09613_/Y _09697_/Y VPWR VGND sg13cmos5l_a22oi_1
XFILLER_92_49 VPWR VGND sg13cmos5l_decap_8
X_08649_ _08649_/Y _10707_/A _10739_/A VPWR VGND sg13cmos5l_nor2_1
XFILLER_55_985 VPWR VGND sg13cmos5l_decap_8
XFILLER_82_793 VPWR VGND sg13cmos5l_decap_8
XFILLER_14_326 VPWR VGND sg13cmos5l_decap_4
XFILLER_26_175 VPWR VGND sg13cmos5l_fill_2
XFILLER_25_76 VPWR VGND sg13cmos5l_fill_2
X_11660_ _11660_/Q clkload11/A _11660_/D _11660_/RESET_B VPWR VGND sg13cmos5l_dfrbpq_1
XFILLER_30_808 VPWR VGND sg13cmos5l_fill_2
X_11591_ _11591_/Q _11622_/CLK _11591_/D _11591_/RESET_B VPWR VGND sg13cmos5l_dfrbpq_1
X_10611_ _10622_/C _10611_/A _10611_/B VPWR VGND sg13cmos5l_xnor2_1
XFILLER_41_189 VPWR VGND sg13cmos5l_decap_8
XFILLER_10_510 VPWR VGND sg13cmos5l_decap_8
X_10542_ _10542_/X _11737_/Q _10548_/B VPWR VGND sg13cmos5l_and2_1
X_10473_ _10569_/A _11409_/Q _10846_/Q VPWR VGND sg13cmos5l_xor2_1
XFILLER_6_547 VPWR VGND sg13cmos5l_fill_2
XFILLER_2_764 VPWR VGND sg13cmos5l_decap_4
XFILLER_2_797 VPWR VGND sg13cmos5l_decap_8
XFILLER_2_14 VPWR VGND sg13cmos5l_decap_8
X_11025_ _11025_/Q _11265_/CLK _11025_/D _11025_/RESET_B VPWR VGND sg13cmos5l_dfrbpq_1
XFILLER_1_296 VPWR VGND sg13cmos5l_fill_2
XFILLER_92_502 VPWR VGND sg13cmos5l_fill_2
XFILLER_65_749 VPWR VGND sg13cmos5l_decap_8
XFILLER_66_83 VPWR VGND sg13cmos5l_fill_2
XFILLER_18_621 VPWR VGND sg13cmos5l_decap_4
XFILLER_18_654 VPWR VGND sg13cmos5l_decap_4
XFILLER_18_687 VPWR VGND sg13cmos5l_fill_2
XFILLER_33_602 VPWR VGND sg13cmos5l_decap_8
XFILLER_73_793 VPWR VGND sg13cmos5l_fill_2
XFILLER_17_175 VPWR VGND sg13cmos5l_decap_4
XFILLER_32_134 VPWR VGND sg13cmos5l_decap_8
XANTENNA_19 _06401_/B VPWR VGND sg13cmos5l_antennanp
XFILLER_14_871 VPWR VGND sg13cmos5l_fill_1
XFILLER_14_893 VPWR VGND sg13cmos5l_decap_4
X_10809_ _10809_/Q clkload35/A _10809_/D _10809_/RESET_B VPWR VGND sg13cmos5l_dfrbpq_1
XFILLER_70_4 VPWR VGND sg13cmos5l_fill_2
X_06000_ _06014_/C _11551_/Q _06066_/C _11554_/Q VPWR VGND sg13cmos5l_a21oi_1
XFILLER_99_123 VPWR VGND sg13cmos5l_decap_8
XFILLER_5_580 VPWR VGND sg13cmos5l_decap_8
X_07951_ _11065_/D fanout99/X _07958_/B _07950_/Y VPWR VGND sg13cmos5l_o21ai_1
XFILLER_96_841 VPWR VGND sg13cmos5l_decap_8
XFILLER_96_830 VPWR VGND sg13cmos5l_decap_4
Xhold2906 hold2906/X _11514_/Q VPWR VGND sg13cmos5l_dlygate4sd3_1
Xhold2939 hold2939/X _11482_/Q VPWR VGND sg13cmos5l_dlygate4sd3_1
X_06902_ _11707_/D hold2752/X hold2667/X _07091_/S VPWR VGND sg13cmos5l_mux2_1
Xhold2917 hold2917/X _11503_/Q VPWR VGND sg13cmos5l_dlygate4sd3_1
Xhold2928 hold2928/X _11465_/Q VPWR VGND sg13cmos5l_dlygate4sd3_1
XFILLER_96_874 VPWR VGND sg13cmos5l_fill_2
XFILLER_96_863 VPWR VGND sg13cmos5l_fill_1
X_07882_ _11031_/D _08534_/A1 _07881_/B _07881_/Y VPWR VGND sg13cmos5l_a21oi_1
XFILLER_96_885 VPWR VGND sg13cmos5l_decap_8
XFILLER_95_384 VPWR VGND sg13cmos5l_fill_2
X_06833_ _06833_/Y _06035_/D _06927_/B _06874_/A _06832_/Y VPWR VGND sg13cmos5l_a22oi_1
X_09621_ _09621_/Y _09220_/A _09620_/Y _09755_/A VPWR VGND sg13cmos5l_a21oi_1
XFILLER_95_395 VPWR VGND sg13cmos5l_fill_2
X_06764_ _10818_/D _06269_/B _06762_/Y _06763_/Y VPWR VGND sg13cmos5l_o21ai_1
XFILLER_55_237 VPWR VGND sg13cmos5l_decap_4
X_09552_ _09552_/Y _11350_/Q _09552_/B VPWR VGND sg13cmos5l_nand2_1
X_08503_ _11336_/D fanout51/X _08504_/B _08502_/Y VPWR VGND sg13cmos5l_o21ai_1
XFILLER_83_579 VPWR VGND sg13cmos5l_fill_2
XFILLER_37_996 VPWR VGND sg13cmos5l_decap_8
XFILLER_36_440 VPWR VGND sg13cmos5l_fill_2
XFILLER_36_484 VPWR VGND sg13cmos5l_fill_1
XFILLER_36_473 VPWR VGND sg13cmos5l_fill_1
XFILLER_24_624 VPWR VGND sg13cmos5l_decap_8
X_06695_ _06695_/Y _10437_/A _06733_/B VPWR VGND sg13cmos5l_nor2_1
X_09483_ _09484_/C _09534_/A _09477_/Y _09482_/Y VPWR VGND sg13cmos5l_o21ai_1
X_08434_ _11302_/D fanout55/X _08433_/B _08433_/Y VPWR VGND sg13cmos5l_a21oi_1
XFILLER_52_966 VPWR VGND sg13cmos5l_decap_4
XFILLER_51_465 VPWR VGND sg13cmos5l_fill_1
XFILLER_51_443 VPWR VGND sg13cmos5l_fill_1
X_08365_ _11268_/D fanout60/X _08364_/B _08364_/Y VPWR VGND sg13cmos5l_o21ai_1
XFILLER_51_487 VPWR VGND sg13cmos5l_fill_1
XFILLER_20_841 VPWR VGND sg13cmos5l_decap_8
XFILLER_20_852 VPWR VGND sg13cmos5l_fill_2
X_07316_ _07316_/Y _09583_/A _07316_/A2 _07315_/Y VPWR VGND sg13cmos5l_a21oi_1
X_08296_ _11234_/D fanout63/X _08301_/B _08295_/Y VPWR VGND sg13cmos5l_a21oi_1
X_07247_ _07247_/Y _10858_/Q _10770_/S _07249_/B1 _07201_/A VPWR VGND sg13cmos5l_a22oi_1
Xclkbuf_4_2_0_clk clkbuf_4_2_0_clk/X clkbuf_0_clk/X VPWR VGND sg13cmos5l_buf_8
XFILLER_106_924 VPWR VGND sg13cmos5l_decap_8
X_07178_ _07178_/Y _07178_/A _07185_/B VPWR VGND sg13cmos5l_nand2_1
XFILLER_105_412 VPWR VGND sg13cmos5l_decap_8
X_06129_ _11760_/D _06953_/A _06129_/B VPWR VGND sg13cmos5l_nor2_1
XFILLER_2_7 VPWR VGND sg13cmos5l_decap_8
Xfanout331 _06861_/B _10791_/B VPWR VGND sg13cmos5l_buf_1
Xfanout320 _07026_/B _07030_/B VPWR VGND sg13cmos5l_buf_1
Xfanout342 _09994_/A1 _10049_/A1 VPWR VGND sg13cmos5l_buf_1
Xfanout364 _10614_/C1 _10168_/B VPWR VGND sg13cmos5l_buf_1
Xfanout375 _09534_/A _09996_/A VPWR VGND sg13cmos5l_buf_1
Xfanout353 _09506_/A fanout357/X VPWR VGND sg13cmos5l_buf_1
X_09819_ _09819_/X _11136_/Q _11104_/Q _11072_/Q _11040_/Q _09814_/S _10035_/B1 VPWR
+ VGND sg13cmos5l_mux4_1
XFILLER_101_684 VPWR VGND sg13cmos5l_decap_8
XFILLER_100_161 VPWR VGND sg13cmos5l_decap_8
XFILLER_86_373 VPWR VGND sg13cmos5l_fill_2
XFILLER_74_524 VPWR VGND sg13cmos5l_decap_8
Xfanout386 _10783_/C _06780_/Y VPWR VGND sg13cmos5l_buf_1
XFILLER_47_738 VPWR VGND sg13cmos5l_fill_1
XFILLER_47_727 VPWR VGND sg13cmos5l_decap_8
XFILLER_46_215 VPWR VGND sg13cmos5l_fill_1
Xfanout397 _09846_/A1 _09602_/C1 VPWR VGND sg13cmos5l_buf_1
XFILLER_36_53 VPWR VGND sg13cmos5l_fill_2
XFILLER_36_42 VPWR VGND sg13cmos5l_decap_8
XFILLER_28_963 VPWR VGND sg13cmos5l_decap_4
XFILLER_61_218 VPWR VGND sg13cmos5l_decap_4
XFILLER_54_281 VPWR VGND sg13cmos5l_fill_2
XFILLER_43_944 VPWR VGND sg13cmos5l_fill_2
XFILLER_15_624 VPWR VGND sg13cmos5l_fill_2
X_11712_ _11712_/Q clkload30/A _11712_/D _11712_/RESET_B VPWR VGND sg13cmos5l_dfrbpq_1
X_11643_ _11643_/Q clkload24/A _11643_/D _11643_/RESET_B VPWR VGND sg13cmos5l_dfrbpq_1
XFILLER_30_638 VPWR VGND sg13cmos5l_decap_4
X_11574_ _11574_/Q clkload26/A _11574_/D _11574_/RESET_B VPWR VGND sg13cmos5l_dfrbpq_1
Xinput17 input17/X ui_in[9] VPWR VGND sg13cmos5l_buf_1
XFILLER_10_362 VPWR VGND sg13cmos5l_decap_8
X_10525_ _10526_/C _10525_/A _10525_/B _10525_/C VPWR VGND sg13cmos5l_nand3_1
X_10456_ _10456_/Y _10456_/A _10456_/B _10456_/C VPWR VGND sg13cmos5l_nor3_1
X_10856__1130 _10856_/RESET_B VPWR VGND sg13cmos5l_tiehi
X_10387_ _10403_/B _10434_/B _10462_/A VPWR VGND sg13cmos5l_nand2_1
X_11094__1807 _11094_/RESET_B VPWR VGND sg13cmos5l_tiehi
XFILLER_2_572 VPWR VGND sg13cmos5l_fill_2
X_11513__1157 _11513_/RESET_B VPWR VGND sg13cmos5l_tiehi
XFILLER_42_1014 VPWR VGND sg13cmos5l_decap_4
X_11130__1771 _11130_/RESET_B VPWR VGND sg13cmos5l_tiehi
X_11008_ _11008_/Q clkload57/A _11008_/D _11008_/RESET_B VPWR VGND sg13cmos5l_dfrbpq_1
XFILLER_93_899 VPWR VGND sg13cmos5l_fill_1
XFILLER_93_877 VPWR VGND sg13cmos5l_decap_8
XFILLER_93_92 VPWR VGND sg13cmos5l_fill_1
XFILLER_93_70 VPWR VGND sg13cmos5l_decap_8
XFILLER_73_590 VPWR VGND sg13cmos5l_fill_2
XFILLER_33_421 VPWR VGND sg13cmos5l_decap_8
XFILLER_60_240 VPWR VGND sg13cmos5l_fill_1
X_06480_ _06480_/Y _11276_/Q _09850_/A2 _06479_/Y VPWR VGND sg13cmos5l_o21ai_1
XFILLER_33_432 VPWR VGND sg13cmos5l_fill_1
XFILLER_34_988 VPWR VGND sg13cmos5l_fill_2
X_08150_ _11162_/D fanout96/X _08163_/B _08149_/Y VPWR VGND sg13cmos5l_a21oi_1
XFILLER_20_126 VPWR VGND sg13cmos5l_decap_8
X_07101_ _07101_/Y hold2795/X _07132_/A2 _08627_/C VPWR VGND sg13cmos5l_o21ai_1
X_08081_ _11129_/D fanout99/X _08088_/B _08080_/Y VPWR VGND sg13cmos5l_o21ai_1
X_07032_ _07032_/Y _07032_/A _07036_/B VPWR VGND sg13cmos5l_nor2_1
XFILLER_103_916 VPWR VGND sg13cmos5l_fill_1
Xhold2714 _10835_/D _07192_/Y VPWR VGND sg13cmos5l_dlygate4sd3_1
Xhold2703 hold2703/X _11703_/Q VPWR VGND sg13cmos5l_dlygate4sd3_1
X_08983_ _08984_/B _08983_/A _08983_/B VPWR VGND sg13cmos5l_and2_1
Xhold2736 _07202_/B _11383_/Q VPWR VGND sg13cmos5l_dlygate4sd3_1
Xhold2725 _06908_/A _11719_/Q VPWR VGND sg13cmos5l_dlygate4sd3_1
Xhold2747 _07093_/A _11710_/Q VPWR VGND sg13cmos5l_dlygate4sd3_1
X_07934_ _07934_/Y _07934_/A _07966_/B VPWR VGND sg13cmos5l_nand2_1
XFILLER_69_896 VPWR VGND sg13cmos5l_fill_2
XFILLER_69_874 VPWR VGND sg13cmos5l_fill_2
Xhold2758 _10845_/D _07222_/Y VPWR VGND sg13cmos5l_dlygate4sd3_1
X_07865_ _07865_/Y _07865_/A _07877_/B VPWR VGND sg13cmos5l_nor2_1
Xhold2769 hold2769/X _11406_/Q VPWR VGND sg13cmos5l_dlygate4sd3_1
XFILLER_29_738 VPWR VGND sg13cmos5l_decap_8
X_09604_ _09604_/X _11256_/Q _11224_/Q _11192_/Q _11160_/Q _09593_/B _09605_/B1 VPWR
+ VGND sg13cmos5l_mux4_1
X_06816_ _06816_/Y _06814_/Y _06835_/B _06813_/Y VPWR VGND sg13cmos5l_o21ai_1
X_07796_ _07796_/Y _07796_/A _07814_/B VPWR VGND sg13cmos5l_nand2_1
X_09535_ _09535_/Y _10440_/A1 _09480_/B _09506_/A VPWR VGND sg13cmos5l_o21ai_1
X_06747_ _06748_/B _06745_/Y _06752_/B _06760_/S VPWR VGND sg13cmos5l_mux2_1
XFILLER_52_763 VPWR VGND sg13cmos5l_decap_8
XFILLER_40_903 VPWR VGND sg13cmos5l_decap_8
X_09466_ _09466_/Y _10931_/Q _09492_/B VPWR VGND sg13cmos5l_nand2_1
XFILLER_19_1016 VPWR VGND sg13cmos5l_fill_1
X_06678_ _06685_/B _06159_/Y _06669_/Y _06292_/A VPWR VGND sg13cmos5l_a21oi_1
XFILLER_106_1008 VPWR VGND sg13cmos5l_decap_8
X_08417_ _08417_/Y _08417_/A _08439_/B VPWR VGND sg13cmos5l_nor2_1
XFILLER_52_774 VPWR VGND sg13cmos5l_decap_8
XFILLER_24_476 VPWR VGND sg13cmos5l_decap_8
XFILLER_24_487 VPWR VGND sg13cmos5l_fill_1
X_09397_ _09397_/Y _11312_/Q _09492_/B VPWR VGND sg13cmos5l_nand2b_1
X_11172__1729 _11172_/RESET_B VPWR VGND sg13cmos5l_tiehi
X_08348_ _08348_/Y _08348_/A _08348_/B VPWR VGND sg13cmos5l_nand2_1
XFILLER_22_33 VPWR VGND sg13cmos5l_fill_1
X_08279_ _08279_/Y _08279_/A _08285_/B VPWR VGND sg13cmos5l_nor2_1
XFILLER_20_682 VPWR VGND sg13cmos5l_fill_1
X_10310_ _10545_/B _10538_/A _10538_/B _10287_/Y VPWR VGND sg13cmos5l_a21o_1
X_11290_ _11290_/Q clkload39/A _11290_/D _11290_/RESET_B VPWR VGND sg13cmos5l_dfrbpq_1
XFILLER_106_721 VPWR VGND sg13cmos5l_decap_8
X_10241_ _11526_/D _10707_/C hold2723/X _10240_/Y VPWR VGND sg13cmos5l_a21oi_1
XFILLER_3_303 VPWR VGND sg13cmos5l_decap_8
XFILLER_105_231 VPWR VGND sg13cmos5l_decap_8
XFILLER_79_616 VPWR VGND sg13cmos5l_fill_1
XFILLER_65_1014 VPWR VGND sg13cmos5l_decap_4
XFILLER_106_798 VPWR VGND sg13cmos5l_decap_8
XFILLER_79_649 VPWR VGND sg13cmos5l_fill_1
X_10172_ _10172_/Y _10180_/B _10173_/B VPWR VGND sg13cmos5l_nor2_1
XFILLER_94_608 VPWR VGND sg13cmos5l_fill_1
XFILLER_75_822 VPWR VGND sg13cmos5l_decap_8
XFILLER_47_502 VPWR VGND sg13cmos5l_fill_1
Xfanout150 _08071_/A1 _08528_/A1 VPWR VGND sg13cmos5l_buf_1
Xfanout183 _08397_/B _08401_/B VPWR VGND sg13cmos5l_buf_1
Xfanout172 _08533_/B _08506_/Y VPWR VGND sg13cmos5l_buf_1
Xfanout161 _07425_/B _07371_/B VPWR VGND sg13cmos5l_buf_1
XFILLER_86_192 VPWR VGND sg13cmos5l_fill_1
XFILLER_75_833 VPWR VGND sg13cmos5l_fill_2
X_11724__1232 _11724_/RESET_B VPWR VGND sg13cmos5l_tiehi
Xfanout194 _08267_/B _08273_/B VPWR VGND sg13cmos5l_buf_1
XFILLER_75_877 VPWR VGND sg13cmos5l_decap_4
XFILLER_47_568 VPWR VGND sg13cmos5l_decap_8
XFILLER_16_933 VPWR VGND sg13cmos5l_decap_8
XFILLER_103_91 VPWR VGND sg13cmos5l_decap_8
XFILLER_15_421 VPWR VGND sg13cmos5l_decap_8
XFILLER_16_977 VPWR VGND sg13cmos5l_decap_8
XFILLER_63_73 VPWR VGND sg13cmos5l_fill_2
X_11626_ _11626_/Q clkload30/A _11626_/D _11626_/RESET_B VPWR VGND sg13cmos5l_dfrbpq_1
XFILLER_8_46 VPWR VGND sg13cmos5l_fill_1
XFILLER_8_35 VPWR VGND sg13cmos5l_decap_4
X_11557_ _11557_/Q _11713_/CLK _11557_/D _11557_/RESET_B VPWR VGND sg13cmos5l_dfrbpq_1
XFILLER_7_620 VPWR VGND sg13cmos5l_fill_1
XFILLER_11_682 VPWR VGND sg13cmos5l_fill_1
X_11148__1753 _11148_/RESET_B VPWR VGND sg13cmos5l_tiehi
X_10508_ _10508_/Y _06310_/B _10547_/A2 _10508_/B1 VPWR VGND sg13cmos5l_a21oi_1
X_11488_ _11488_/Q clkload13/A _11488_/D _11488_/RESET_B VPWR VGND sg13cmos5l_dfrbpq_1
XFILLER_98_903 VPWR VGND sg13cmos5l_fill_1
X_10439_ _10439_/Y _10539_/A _10427_/Y _10438_/Y VPWR VGND sg13cmos5l_o21ai_1
XFILLER_98_958 VPWR VGND sg13cmos5l_fill_2
XFILLER_97_402 VPWR VGND sg13cmos5l_fill_1
XFILLER_100_908 VPWR VGND sg13cmos5l_decap_8
X_05980_ _05980_/Y _11329_/Q VPWR VGND sg13cmos5l_inv_1
XFILLER_33_4 VPWR VGND sg13cmos5l_fill_1
XFILLER_97_479 VPWR VGND sg13cmos5l_decap_8
X_07650_ _07650_/Y _07650_/A _07650_/B VPWR VGND sg13cmos5l_nand2_1
XFILLER_38_579 VPWR VGND sg13cmos5l_decap_8
X_07581_ _07581_/Y _07581_/A _07607_/B VPWR VGND sg13cmos5l_nor2_1
X_06601_ _10797_/D hold2789/X _06599_/Y _06600_/Y VPWR VGND sg13cmos5l_o21ai_1
X_09320_ _09320_/Y _09301_/S _09318_/Y _09319_/Y _09537_/A VPWR VGND sg13cmos5l_a22oi_1
X_06532_ _06533_/B _06571_/A1 _11665_/Q _10875_/Q _06571_/B2 VPWR VGND sg13cmos5l_a22oi_1
X_09251_ _09253_/A _09938_/A _10854_/Q VPWR VGND sg13cmos5l_xnor2_1
XFILLER_33_251 VPWR VGND sg13cmos5l_decap_4
XFILLER_61_593 VPWR VGND sg13cmos5l_decap_4
X_08202_ _08202_/Y _08202_/A _08202_/B VPWR VGND sg13cmos5l_nand2_1
XFILLER_21_424 VPWR VGND sg13cmos5l_decap_8
XFILLER_22_947 VPWR VGND sg13cmos5l_decap_4
X_06463_ _06473_/A _06456_/Y _06457_/Y _06461_/Y _06462_/Y _09602_/C1 VPWR VGND sg13cmos5l_a221oi_1
XFILLER_33_284 VPWR VGND sg13cmos5l_decap_8
XFILLER_33_295 VPWR VGND sg13cmos5l_fill_2
X_06394_ _06757_/B _11623_/Q _06394_/B VPWR VGND sg13cmos5l_nor2_1
X_09182_ _09183_/A _09189_/A _10831_/Q VPWR VGND sg13cmos5l_nand2_1
X_08133_ _08133_/Y _08133_/A _08141_/B VPWR VGND sg13cmos5l_nor2_1
X_08064_ _08064_/Y _08064_/A _08096_/B VPWR VGND sg13cmos5l_nand2_1
X_07015_ _07015_/Y _07034_/B _07013_/Y _07014_/Y VPWR VGND sg13cmos5l_o21ai_1
XFILLER_103_724 VPWR VGND sg13cmos5l_fill_1
XFILLER_88_424 VPWR VGND sg13cmos5l_decap_8
XFILLER_88_402 VPWR VGND sg13cmos5l_decap_4
X_10937__1045 _10937_/RESET_B VPWR VGND sg13cmos5l_tiehi
XFILLER_102_245 VPWR VGND sg13cmos5l_decap_8
Xhold2522 _11657_/D _06981_/X VPWR VGND sg13cmos5l_dlygate4sd3_1
Xhold2511 hold2511/X _11659_/Q VPWR VGND sg13cmos5l_dlygate4sd3_1
Xhold2500 hold2500/X _11678_/Q VPWR VGND sg13cmos5l_dlygate4sd3_1
Xhold2533 _11586_/D _10770_/X VPWR VGND sg13cmos5l_dlygate4sd3_1
Xhold2555 _06790_/A _11638_/Q VPWR VGND sg13cmos5l_dlygate4sd3_1
XFILLER_75_107 VPWR VGND sg13cmos5l_fill_1
XFILLER_57_822 VPWR VGND sg13cmos5l_fill_1
X_08966_ _08967_/B _08949_/Y _08965_/Y _08964_/Y VPWR VGND sg13cmos5l_o21ai_1
Xhold2544 _07377_/A _10880_/Q VPWR VGND sg13cmos5l_dlygate4sd3_1
XFILLER_29_513 VPWR VGND sg13cmos5l_fill_2
X_07917_ _07917_/Y _07917_/A _07917_/B VPWR VGND sg13cmos5l_nor2_1
Xhold1843 _07828_/A _11006_/Q VPWR VGND sg13cmos5l_dlygate4sd3_1
Xhold1832 _11768_/D _06141_/Y VPWR VGND sg13cmos5l_dlygate4sd3_1
Xhold2577 hold2577/X _11576_/Q VPWR VGND sg13cmos5l_dlygate4sd3_1
XFILLER_84_28 VPWR VGND sg13cmos5l_decap_8
XFILLER_69_682 VPWR VGND sg13cmos5l_decap_8
Xhold2566 hold2566/X _08620_/Y VPWR VGND sg13cmos5l_dlygate4sd3_1
Xhold1854 _08346_/A _11259_/Q VPWR VGND sg13cmos5l_dlygate4sd3_1
X_08897_ _08898_/B _08897_/A _08897_/B VPWR VGND sg13cmos5l_nand2_1
Xhold2588 _11679_/D _07062_/X VPWR VGND sg13cmos5l_dlygate4sd3_1
XFILLER_29_524 VPWR VGND sg13cmos5l_decap_8
X_07848_ _07848_/Y _07848_/A _07850_/B VPWR VGND sg13cmos5l_nand2_1
XFILLER_57_877 VPWR VGND sg13cmos5l_decap_8
Xhold2599 _11681_/D _07075_/Y VPWR VGND sg13cmos5l_dlygate4sd3_1
Xhold1887 _08488_/A _11329_/Q VPWR VGND sg13cmos5l_dlygate4sd3_1
Xhold1876 _08072_/A _11125_/Q VPWR VGND sg13cmos5l_dlygate4sd3_1
Xhold1865 _07924_/A _11052_/Q VPWR VGND sg13cmos5l_dlygate4sd3_1
XFILLER_84_696 VPWR VGND sg13cmos5l_fill_1
XFILLER_84_685 VPWR VGND sg13cmos5l_fill_1
XFILLER_56_387 VPWR VGND sg13cmos5l_fill_2
X_10840__1162 _10840_/RESET_B VPWR VGND sg13cmos5l_tiehi
X_11226__1675 _11226_/RESET_B VPWR VGND sg13cmos5l_tiehi
Xhold1898 _08472_/A _11321_/Q VPWR VGND sg13cmos5l_dlygate4sd3_1
XFILLER_72_869 VPWR VGND sg13cmos5l_decap_4
X_07779_ _10982_/D fanout56/X _07778_/B _07778_/Y VPWR VGND sg13cmos5l_a21oi_1
X_09518_ _09518_/Y _10933_/Q _09630_/B VPWR VGND sg13cmos5l_nand2_1
X_10790_ _10790_/Y _06840_/A _10783_/Y _10789_/Y VPWR VGND sg13cmos5l_o21ai_1
XFILLER_12_402 VPWR VGND sg13cmos5l_fill_2
XFILLER_24_240 VPWR VGND sg13cmos5l_decap_4
X_09449_ _09449_/Y _11314_/Q _09492_/B VPWR VGND sg13cmos5l_nand2b_1
XFILLER_13_947 VPWR VGND sg13cmos5l_decap_8
XFILLER_13_958 VPWR VGND sg13cmos5l_fill_1
XFILLER_40_788 VPWR VGND sg13cmos5l_decap_4
XFILLER_8_428 VPWR VGND sg13cmos5l_fill_2
X_11411_ _11411_/Q clkload37/A _11411_/D _11411_/RESET_B VPWR VGND sg13cmos5l_dfrbpq_1
XFILLER_4_601 VPWR VGND sg13cmos5l_decap_8
X_11342_ _11342_/Q clkload16/A _11342_/D _11342_/RESET_B VPWR VGND sg13cmos5l_dfrbpq_1
X_11273_ _11273_/Q clkload50/A _11273_/D _11273_/RESET_B VPWR VGND sg13cmos5l_dfrbpq_1
XFILLER_4_645 VPWR VGND sg13cmos5l_fill_1
X_10224_ _10224_/Y _10232_/B _10224_/B _10353_/A VPWR VGND sg13cmos5l_nand3b_1
XFILLER_4_689 VPWR VGND sg13cmos5l_fill_2
XFILLER_106_595 VPWR VGND sg13cmos5l_decap_8
X_10155_ _10155_/X _11517_/Q _10135_/B _10154_/Y VPWR VGND sg13cmos5l_a21o_1
XFILLER_94_405 VPWR VGND sg13cmos5l_fill_2
XFILLER_58_62 VPWR VGND sg13cmos5l_fill_1
XFILLER_0_873 VPWR VGND sg13cmos5l_decap_8
X_11645__1320 _11645_/RESET_B VPWR VGND sg13cmos5l_tiehi
X_11637__1329 _11637_/RESET_B VPWR VGND sg13cmos5l_tiehi
XFILLER_66_129 VPWR VGND sg13cmos5l_decap_8
XFILLER_59_181 VPWR VGND sg13cmos5l_decap_8
X_10086_ _10086_/Y _10356_/A1 _10839_/Q _10092_/B1 VPWR VGND sg13cmos5l_o21ai_1
XFILLER_63_814 VPWR VGND sg13cmos5l_decap_8
XFILLER_59_192 VPWR VGND sg13cmos5l_fill_1
XFILLER_47_365 VPWR VGND sg13cmos5l_decap_8
XFILLER_74_162 VPWR VGND sg13cmos5l_fill_1
XFILLER_63_825 VPWR VGND sg13cmos5l_fill_2
XFILLER_48_899 VPWR VGND sg13cmos5l_decap_8
XFILLER_74_72 VPWR VGND sg13cmos5l_decap_8
XFILLER_62_368 VPWR VGND sg13cmos5l_fill_2
XFILLER_43_571 VPWR VGND sg13cmos5l_decap_4
X_10988_ _10988_/Q _11352_/CLK _10988_/D _10988_/RESET_B VPWR VGND sg13cmos5l_dfrbpq_1
X_11609_ _11609_/Q _11622_/CLK _11609_/D _11609_/RESET_B VPWR VGND sg13cmos5l_dfrbpq_1
Xclkbuf_leaf_10_clk clkload21/A clkbuf_4_4_0_clk/X VPWR VGND sg13cmos5l_buf_8
XFILLER_8_984 VPWR VGND sg13cmos5l_decap_8
X_11304__1597 _11304_/RESET_B VPWR VGND sg13cmos5l_tiehi
X_08820_ _08820_/Y _08819_/A _08816_/Y _08852_/D _08819_/Y _10719_/C VPWR VGND sg13cmos5l_a221oi_1
XFILLER_86_928 VPWR VGND sg13cmos5l_fill_2
XFILLER_57_107 VPWR VGND sg13cmos5l_fill_1
XFILLER_97_298 VPWR VGND sg13cmos5l_fill_1
XFILLER_85_449 VPWR VGND sg13cmos5l_fill_1
XFILLER_85_438 VPWR VGND sg13cmos5l_decap_8
X_08751_ _09102_/A _08751_/A _08751_/B VPWR VGND sg13cmos5l_nand2_1
X_05963_ _05963_/Y _05963_/A VPWR VGND sg13cmos5l_inv_1
X_05894_ _05894_/Y _11518_/Q VPWR VGND sg13cmos5l_inv_1
X_08682_ _08890_/B _07326_/B _07508_/B _07302_/Y VPWR VGND sg13cmos5l_o21ai_1
X_07702_ _07702_/Y _07702_/A _07702_/B VPWR VGND sg13cmos5l_nor2_1
XFILLER_26_505 VPWR VGND sg13cmos5l_decap_8
X_07633_ _07633_/Y _07638_/A _08758_/B _07632_/Y VPWR VGND sg13cmos5l_a21oi_1
XFILLER_39_899 VPWR VGND sg13cmos5l_decap_8
XFILLER_26_527 VPWR VGND sg13cmos5l_decap_8
XFILLER_54_869 VPWR VGND sg13cmos5l_decap_8
XFILLER_53_357 VPWR VGND sg13cmos5l_decap_4
XFILLER_81_699 VPWR VGND sg13cmos5l_fill_1
XFILLER_62_880 VPWR VGND sg13cmos5l_fill_2
X_07564_ _07564_/Y _07577_/A _07575_/C _07564_/C VPWR VGND sg13cmos5l_nor3_1
XFILLER_34_571 VPWR VGND sg13cmos5l_decap_8
X_09303_ _09303_/Y _09303_/A _11587_/Q _09303_/C _09303_/D VPWR VGND sg13cmos5l_nor4_1
X_07495_ _07495_/Y _07495_/A _07526_/B VPWR VGND sg13cmos5l_nor2_1
X_06515_ _06515_/Y _09495_/A1 _06511_/X _06514_/Y VPWR VGND sg13cmos5l_o21ai_1
X_06446_ _06446_/Y _06446_/A _06446_/B VPWR VGND sg13cmos5l_nand2_1
X_09234_ _09236_/C _09721_/A _09234_/B VPWR VGND sg13cmos5l_xnor2_1
XFILLER_16_1019 VPWR VGND sg13cmos5l_decap_8
XFILLER_22_755 VPWR VGND sg13cmos5l_decap_4
XFILLER_22_777 VPWR VGND sg13cmos5l_decap_4
X_09165_ _09166_/D _10305_/A _10849_/Q _10850_/Q _10424_/A VPWR VGND sg13cmos5l_a22oi_1
X_08116_ _08116_/Y _08376_/C _08246_/B VPWR VGND sg13cmos5l_nor2_1
X_06377_ _06378_/B _06377_/A _06719_/B VPWR VGND sg13cmos5l_nand2_1
X_09096_ _09123_/A _09077_/B _09102_/A _09109_/A VPWR VGND sg13cmos5l_o21ai_1
X_08047_ _08047_/Y _08047_/A _08047_/B VPWR VGND sg13cmos5l_nor2_1
XFILLER_102_7 VPWR VGND sg13cmos5l_decap_8
XFILLER_79_28 VPWR VGND sg13cmos5l_fill_1
X_11741__1198 _11741_/RESET_B VPWR VGND sg13cmos5l_tiehi
X_11764__925 _11764_/RESET_B VPWR VGND sg13cmos5l_tiehi
XFILLER_89_733 VPWR VGND sg13cmos5l_fill_2
X_11436__1418 _11436_/RESET_B VPWR VGND sg13cmos5l_tiehi
XFILLER_0_103 VPWR VGND sg13cmos5l_fill_2
X_11487__1209 _11487_/RESET_B VPWR VGND sg13cmos5l_tiehi
XFILLER_88_254 VPWR VGND sg13cmos5l_fill_2
X_09998_ _09998_/Y _09998_/A _09998_/B _09998_/C VPWR VGND sg13cmos5l_nand3_1
XFILLER_62_1028 VPWR VGND sg13cmos5l_fill_1
Xhold2330 _07293_/A _10866_/Q VPWR VGND sg13cmos5l_dlygate4sd3_1
XFILLER_95_49 VPWR VGND sg13cmos5l_decap_8
XFILLER_76_449 VPWR VGND sg13cmos5l_fill_2
X_08949_ _08949_/Y _11631_/Q _08950_/B VPWR VGND sg13cmos5l_nor2_1
Xhold2363 _07468_/A _10894_/Q VPWR VGND sg13cmos5l_dlygate4sd3_1
Xhold2352 _07257_/A _10860_/Q VPWR VGND sg13cmos5l_dlygate4sd3_1
Xhold2341 _07275_/A _10863_/Q VPWR VGND sg13cmos5l_dlygate4sd3_1
Xhold2374 _07907_/A _11044_/Q VPWR VGND sg13cmos5l_dlygate4sd3_1
XFILLER_56_140 VPWR VGND sg13cmos5l_decap_4
Xhold2385 _07732_/A _10959_/Q VPWR VGND sg13cmos5l_dlygate4sd3_1
Xclkbuf_leaf_68_clk clkload17/A clkbuf_4_2_0_clk/X VPWR VGND sg13cmos5l_buf_8
Xhold2396 _08273_/A _11223_/Q VPWR VGND sg13cmos5l_dlygate4sd3_1
XFILLER_29_332 VPWR VGND sg13cmos5l_decap_8
X_10911_ _10911_/Q clkload58/A _10911_/D _10911_/RESET_B VPWR VGND sg13cmos5l_dfrbpq_1
XFILLER_57_674 VPWR VGND sg13cmos5l_decap_8
XFILLER_56_151 VPWR VGND sg13cmos5l_decap_4
XFILLER_45_847 VPWR VGND sg13cmos5l_fill_1
XFILLER_45_825 VPWR VGND sg13cmos5l_decap_8
XFILLER_17_505 VPWR VGND sg13cmos5l_decap_8
XFILLER_71_121 VPWR VGND sg13cmos5l_fill_2
XFILLER_60_828 VPWR VGND sg13cmos5l_fill_1
X_10842_ _10842_/Q clkload19/A _10842_/D _10842_/RESET_B VPWR VGND sg13cmos5l_dfrbpq_1
X_10773_ _10773_/Y _06943_/Y _10779_/D _10771_/Y VPWR VGND sg13cmos5l_o21ai_1
XFILLER_40_552 VPWR VGND sg13cmos5l_fill_2
XFILLER_40_541 VPWR VGND sg13cmos5l_decap_8
XFILLER_100_70 VPWR VGND sg13cmos5l_decap_8
XFILLER_5_954 VPWR VGND sg13cmos5l_fill_2
XFILLER_5_14 VPWR VGND sg13cmos5l_decap_8
X_11325_ _11325_/Q clkload41/A _11325_/D _11325_/RESET_B VPWR VGND sg13cmos5l_dfrbpq_1
X_11256_ _11256_/Q _11352_/CLK _11256_/D _11256_/RESET_B VPWR VGND sg13cmos5l_dfrbpq_1
XFILLER_5_987 VPWR VGND sg13cmos5l_decap_8
XFILLER_106_392 VPWR VGND sg13cmos5l_decap_8
XFILLER_79_243 VPWR VGND sg13cmos5l_decap_8
X_10207_ _10207_/Y hold2749/X _07067_/X _10166_/X hold2746/X VPWR VGND sg13cmos5l_a22oi_1
X_11187_ _11187_/Q clkload10/A _11187_/D _11187_/RESET_B VPWR VGND sg13cmos5l_dfrbpq_1
X_10138_ _10138_/Y _10135_/B _10137_/Y _10135_/Y VPWR VGND sg13cmos5l_o21ai_1
XFILLER_0_692 VPWR VGND sg13cmos5l_decap_4
XFILLER_76_972 VPWR VGND sg13cmos5l_fill_1
Xclkbuf_leaf_59_clk clkload33/A clkbuf_4_8_0_clk/X VPWR VGND sg13cmos5l_buf_8
X_10069_ _10069_/Y _10069_/A _10073_/B VPWR VGND sg13cmos5l_nand2_1
XFILLER_91_920 VPWR VGND sg13cmos5l_fill_1
XFILLER_75_460 VPWR VGND sg13cmos5l_fill_1
XFILLER_35_302 VPWR VGND sg13cmos5l_decap_8
X_11609__1370 _11609_/RESET_B VPWR VGND sg13cmos5l_tiehi
XFILLER_63_644 VPWR VGND sg13cmos5l_decap_8
XFILLER_51_828 VPWR VGND sg13cmos5l_decap_8
XFILLER_16_560 VPWR VGND sg13cmos5l_fill_1
XFILLER_23_519 VPWR VGND sg13cmos5l_decap_8
XFILLER_50_338 VPWR VGND sg13cmos5l_decap_8
X_06300_ _06300_/Y _11502_/Q _09217_/A VPWR VGND sg13cmos5l_nand2b_1
X_07280_ _07280_/Y _11462_/Q _06956_/B _07279_/Y VPWR VGND sg13cmos5l_a21oi_1
X_06231_ _06726_/B _06721_/A _06713_/A VPWR VGND sg13cmos5l_nor2_1
XFILLER_102_1011 VPWR VGND sg13cmos5l_decap_8
X_11748__909 _11748_/RESET_B VPWR VGND sg13cmos5l_tiehi
XFILLER_8_792 VPWR VGND sg13cmos5l_fill_1
X_06162_ _06162_/Y _11498_/Q _09559_/A VPWR VGND sg13cmos5l_nand2_1
X_06093_ _11751_/D _06093_/A _11391_/D _06093_/C VPWR VGND sg13cmos5l_or3_1
X_09921_ _09921_/Y _11012_/Q _10012_/B VPWR VGND sg13cmos5l_nand2_1
Xfanout705 _08819_/A _10776_/A VPWR VGND sg13cmos5l_buf_1
XFILLER_98_563 VPWR VGND sg13cmos5l_fill_1
Xfanout716 _09063_/A1 _11589_/Q VPWR VGND sg13cmos5l_buf_1
Xfanout749 _06321_/B hold2892/X VPWR VGND sg13cmos5l_buf_1
XFILLER_59_928 VPWR VGND sg13cmos5l_decap_4
Xfanout727 _10285_/A _11509_/Q VPWR VGND sg13cmos5l_buf_1
X_09852_ _09853_/B _09852_/A1 _09847_/X _09851_/Y VPWR VGND sg13cmos5l_o21ai_1
Xfanout738 _10424_/B _10433_/B VPWR VGND sg13cmos5l_buf_1
XFILLER_98_585 VPWR VGND sg13cmos5l_fill_2
X_08803_ _08805_/A _11378_/Q _08817_/C VPWR VGND sg13cmos5l_xnor2_1
X_09783_ _09783_/Y _09171_/D _09782_/Y _09755_/A VPWR VGND sg13cmos5l_a21oi_1
XFILLER_74_909 VPWR VGND sg13cmos5l_fill_1
X_08734_ _09036_/C _07380_/B _07591_/B _07374_/Y VPWR VGND sg13cmos5l_o21ai_1
XFILLER_22_1001 VPWR VGND sg13cmos5l_fill_1
X_06995_ _06995_/Y _07006_/B _11500_/Q VPWR VGND sg13cmos5l_nand2b_1
X_05946_ _08914_/A _05946_/A VPWR VGND sg13cmos5l_inv_1
XFILLER_38_173 VPWR VGND sg13cmos5l_decap_4
XFILLER_27_836 VPWR VGND sg13cmos5l_fill_1
XFILLER_82_964 VPWR VGND sg13cmos5l_fill_1
XFILLER_81_430 VPWR VGND sg13cmos5l_fill_1
X_05877_ _05877_/Y input5/X VPWR VGND sg13cmos5l_inv_1
XFILLER_53_132 VPWR VGND sg13cmos5l_decap_8
XFILLER_53_121 VPWR VGND sg13cmos5l_fill_1
X_08665_ _08666_/A hold2775/X _08811_/B _08817_/D _08831_/B1 VPWR VGND sg13cmos5l_a22oi_1
X_08596_ _08596_/Y _10891_/Q _08588_/B _10015_/B1 VPWR VGND sg13cmos5l_a21oi_1
X_07616_ _08750_/B _11545_/Q _10820_/Q _07642_/S VPWR VGND sg13cmos5l_mux2_1
XFILLER_54_666 VPWR VGND sg13cmos5l_decap_4
XFILLER_26_368 VPWR VGND sg13cmos5l_fill_1
X_10887__1095 _10887_/RESET_B VPWR VGND sg13cmos5l_tiehi
XFILLER_81_496 VPWR VGND sg13cmos5l_decap_8
XFILLER_53_198 VPWR VGND sg13cmos5l_decap_8
X_07547_ _07547_/Y _07547_/A _07595_/B VPWR VGND sg13cmos5l_nor2_1
X_07478_ _07478_/Y _07479_/A _07479_/B VPWR VGND sg13cmos5l_nand2_1
X_06429_ _06429_/Y _06429_/A _06429_/B VPWR VGND sg13cmos5l_nor2_1
X_09217_ _09220_/A _09217_/A _10844_/Q VPWR VGND sg13cmos5l_xor2_1
X_09148_ _09148_/Y _09148_/A _09148_/B VPWR VGND sg13cmos5l_nor2_1
X_09079_ _09079_/Y _09075_/X _09097_/A _09078_/Y VPWR VGND sg13cmos5l_a21oi_1
X_11110_ _11110_/Q _11362_/CLK _11110_/D _11110_/RESET_B VPWR VGND sg13cmos5l_dfrbpq_1
XFILLER_104_852 VPWR VGND sg13cmos5l_decap_8
XFILLER_77_714 VPWR VGND sg13cmos5l_decap_8
XFILLER_39_20 VPWR VGND sg13cmos5l_decap_8
X_11041_ _11041_/Q _11361_/CLK _11041_/D _11041_/RESET_B VPWR VGND sg13cmos5l_dfrbpq_1
XFILLER_49_427 VPWR VGND sg13cmos5l_decap_8
XFILLER_7_1028 VPWR VGND sg13cmos5l_fill_1
Xhold2160 _07656_/A _10922_/Q VPWR VGND sg13cmos5l_dlygate4sd3_1
Xhold2171 _08541_/A _11355_/Q VPWR VGND sg13cmos5l_dlygate4sd3_1
Xhold2182 _08147_/A _11161_/Q VPWR VGND sg13cmos5l_dlygate4sd3_1
XFILLER_45_600 VPWR VGND sg13cmos5l_fill_2
Xhold2193 _08293_/A _11233_/Q VPWR VGND sg13cmos5l_dlygate4sd3_1
XFILLER_18_814 VPWR VGND sg13cmos5l_decap_8
XFILLER_73_942 VPWR VGND sg13cmos5l_fill_2
XFILLER_44_110 VPWR VGND sg13cmos5l_fill_2
XFILLER_18_847 VPWR VGND sg13cmos5l_fill_2
XFILLER_73_997 VPWR VGND sg13cmos5l_decap_8
X_11569__1401 _11569_/RESET_B VPWR VGND sg13cmos5l_tiehi
X_10825_ _10825_/Q clkload46/A _10825_/D _10825_/RESET_B VPWR VGND sg13cmos5l_dfrbpq_1
XFILLER_33_839 VPWR VGND sg13cmos5l_fill_2
XFILLER_9_501 VPWR VGND sg13cmos5l_fill_1
X_10756_ _10756_/Y _06868_/A _10760_/S _10755_/Y VPWR VGND sg13cmos5l_o21ai_1
XFILLER_9_534 VPWR VGND sg13cmos5l_decap_4
X_10687_ _10690_/A _10687_/A _10687_/B VPWR VGND sg13cmos5l_nand2_1
XFILLER_40_382 VPWR VGND sg13cmos5l_fill_2
X_10932__1050 _10932_/RESET_B VPWR VGND sg13cmos5l_tiehi
XFILLER_5_751 VPWR VGND sg13cmos5l_decap_8
X_11308_ _11308_/Q clkload39/A _11308_/D _11308_/RESET_B VPWR VGND sg13cmos5l_dfrbpq_1
X_11239_ _11239_/Q _11364_/CLK _11239_/D _11239_/RESET_B VPWR VGND sg13cmos5l_dfrbpq_1
XFILLER_45_1012 VPWR VGND sg13cmos5l_decap_8
X_11185__1716 _11185_/RESET_B VPWR VGND sg13cmos5l_tiehi
XFILLER_96_70 VPWR VGND sg13cmos5l_decap_8
XFILLER_95_522 VPWR VGND sg13cmos5l_fill_2
XFILLER_68_747 VPWR VGND sg13cmos5l_fill_1
X_11221__1680 _11221_/RESET_B VPWR VGND sg13cmos5l_tiehi
XFILLER_95_555 VPWR VGND sg13cmos5l_decap_8
XFILLER_49_961 VPWR VGND sg13cmos5l_decap_4
X_06780_ _06780_/Y _10719_/C _06780_/B VPWR VGND sg13cmos5l_nor2_1
XFILLER_36_600 VPWR VGND sg13cmos5l_decap_8
XFILLER_76_791 VPWR VGND sg13cmos5l_fill_2
XFILLER_91_750 VPWR VGND sg13cmos5l_decap_4
X_08450_ _08450_/Y _08450_/A _08462_/B VPWR VGND sg13cmos5l_nand2_1
XFILLER_50_113 VPWR VGND sg13cmos5l_decap_4
X_07401_ _07401_/Y _07401_/A _07401_/B VPWR VGND sg13cmos5l_nor2_1
XFILLER_36_699 VPWR VGND sg13cmos5l_decap_8
X_08381_ _08381_/Y _08381_/A _08423_/B VPWR VGND sg13cmos5l_nor2_1
XFILLER_91_0 VPWR VGND sg13cmos5l_decap_8
XFILLER_51_669 VPWR VGND sg13cmos5l_fill_2
X_07332_ _07332_/Y _11438_/Q _07362_/B VPWR VGND sg13cmos5l_nand2_1
XFILLER_16_390 VPWR VGND sg13cmos5l_decap_8
XFILLER_52_1027 VPWR VGND sg13cmos5l_fill_2
XFILLER_31_360 VPWR VGND sg13cmos5l_decap_8
X_07263_ _07263_/Y _07263_/A _07359_/B VPWR VGND sg13cmos5l_nor2_1
X_07194_ _07194_/Y _08774_/A _07194_/B _10783_/C VPWR VGND sg13cmos5l_nand3_1
X_09002_ _09002_/Y _09030_/A1 _08992_/B _09013_/B1 VPWR VGND sg13cmos5l_o21ai_1
X_06214_ _06748_/A _06752_/A _10282_/A VPWR VGND sg13cmos5l_and2_1
X_06145_ _06692_/A _06146_/A _09217_/A VPWR VGND sg13cmos5l_nand2_1
X_11632__1334 _11632_/RESET_B VPWR VGND sg13cmos5l_tiehi
XFILLER_105_649 VPWR VGND sg13cmos5l_decap_8
XFILLER_104_126 VPWR VGND sg13cmos5l_decap_8
X_06076_ _11754_/D _06092_/B _06076_/B VPWR VGND sg13cmos5l_nor2_1
X_09904_ _09904_/Y _11331_/Q _10039_/B VPWR VGND sg13cmos5l_nand2b_1
Xfanout513 _08739_/A2 _08948_/B VPWR VGND sg13cmos5l_buf_1
Xfanout502 _09480_/B _09828_/B VPWR VGND sg13cmos5l_buf_1
Xfanout524 _07530_/A _07448_/A VPWR VGND sg13cmos5l_buf_1
XFILLER_99_894 VPWR VGND sg13cmos5l_decap_4
XFILLER_98_393 VPWR VGND sg13cmos5l_decap_4
Xfanout535 _08651_/B _07252_/Y VPWR VGND sg13cmos5l_buf_1
X_09835_ _09835_/Y _09316_/B _09827_/Y _09834_/Y VPWR VGND sg13cmos5l_a21oi_1
Xfanout557 _07375_/B1 _06948_/Y VPWR VGND sg13cmos5l_buf_1
Xfanout546 _07036_/B _07055_/B VPWR VGND sg13cmos5l_buf_1
XFILLER_86_544 VPWR VGND sg13cmos5l_fill_2
Xfanout579 _06758_/A2 _06775_/B1 VPWR VGND sg13cmos5l_buf_1
Xfanout568 _07212_/A2 _07191_/A2 VPWR VGND sg13cmos5l_buf_1
XFILLER_59_769 VPWR VGND sg13cmos5l_decap_8
XFILLER_100_387 VPWR VGND sg13cmos5l_decap_8
XFILLER_100_376 VPWR VGND sg13cmos5l_decap_8
X_10974__1008 _10974_/RESET_B VPWR VGND sg13cmos5l_tiehi
X_09766_ _09773_/A _10044_/A _09766_/B _09766_/C VPWR VGND sg13cmos5l_nor3_1
XFILLER_86_588 VPWR VGND sg13cmos5l_fill_2
XFILLER_73_205 VPWR VGND sg13cmos5l_fill_2
X_06978_ _06978_/Y _11496_/Q _07006_/A _06982_/B1 _11488_/Q VPWR VGND sg13cmos5l_a22oi_1
XFILLER_39_460 VPWR VGND sg13cmos5l_decap_8
X_05929_ _07012_/A _11488_/Q VPWR VGND sg13cmos5l_inv_1
X_08717_ _08981_/B _08717_/A _08717_/B VPWR VGND sg13cmos5l_nand2_1
X_09697_ _09697_/Y _09722_/A _09697_/B VPWR VGND sg13cmos5l_nor2_1
XFILLER_27_622 VPWR VGND sg13cmos5l_decap_8
XFILLER_92_28 VPWR VGND sg13cmos5l_decap_8
XFILLER_82_761 VPWR VGND sg13cmos5l_decap_8
X_08648_ _11392_/D _08648_/A _08648_/B VPWR VGND sg13cmos5l_nor2_1
XFILLER_55_964 VPWR VGND sg13cmos5l_decap_8
XFILLER_15_806 VPWR VGND sg13cmos5l_decap_4
XFILLER_26_143 VPWR VGND sg13cmos5l_fill_1
XFILLER_27_677 VPWR VGND sg13cmos5l_decap_8
XFILLER_27_688 VPWR VGND sg13cmos5l_fill_2
XFILLER_26_198 VPWR VGND sg13cmos5l_decap_8
X_08579_ _08584_/B _09933_/A _08578_/X VPWR VGND sg13cmos5l_nor2b_1
X_11550__1473 _11550_/RESET_B VPWR VGND sg13cmos5l_tiehi
XFILLER_14_349 VPWR VGND sg13cmos5l_fill_1
X_11590_ _11590_/Q clkload23/A _11590_/D _11590_/RESET_B VPWR VGND sg13cmos5l_dfrbpq_1
X_10610_ _10611_/B _10597_/A _10597_/B _06264_/A VPWR VGND sg13cmos5l_a21oi_1
XFILLER_50_680 VPWR VGND sg13cmos5l_fill_2
XFILLER_23_872 VPWR VGND sg13cmos5l_fill_1
X_11263__1638 _11263_/RESET_B VPWR VGND sg13cmos5l_tiehi
X_10541_ _10541_/Y _10289_/A _10547_/A2 _10539_/Y _10540_/Y _10614_/C1 VPWR VGND sg13cmos5l_a221oi_1
XFILLER_50_691 VPWR VGND sg13cmos5l_decap_4
X_11557__1449 _11557_/RESET_B VPWR VGND sg13cmos5l_tiehi
XFILLER_41_65 VPWR VGND sg13cmos5l_decap_8
XFILLER_6_504 VPWR VGND sg13cmos5l_decap_8
XFILLER_41_98 VPWR VGND sg13cmos5l_decap_4
X_10472_ _11535_/D _10461_/Y _10467_/Y _10471_/Y VPWR VGND sg13cmos5l_a21oi_1
X_10794__931 _10794_/RESET_B VPWR VGND sg13cmos5l_tiehi
XFILLER_96_319 VPWR VGND sg13cmos5l_decap_8
X_11598__1385 _11598_/RESET_B VPWR VGND sg13cmos5l_tiehi
Xheichips26_RiMaX_1830 uio_oe[15] VPWR VGND sg13cmos5l_tiehi
XFILLER_49_213 VPWR VGND sg13cmos5l_fill_2
XFILLER_49_202 VPWR VGND sg13cmos5l_decap_8
XFILLER_2_787 VPWR VGND sg13cmos5l_decap_4
X_11024_ _11024_/Q _11671_/CLK _11024_/D _11024_/RESET_B VPWR VGND sg13cmos5l_dfrbpq_1
XFILLER_106_91 VPWR VGND sg13cmos5l_decap_8
XFILLER_77_577 VPWR VGND sg13cmos5l_fill_2
XFILLER_49_279 VPWR VGND sg13cmos5l_decap_8
XFILLER_18_611 VPWR VGND sg13cmos5l_decap_4
XFILLER_66_73 VPWR VGND sg13cmos5l_decap_4
XFILLER_61_912 VPWR VGND sg13cmos5l_decap_4
XFILLER_72_282 VPWR VGND sg13cmos5l_fill_1
XFILLER_82_83 VPWR VGND sg13cmos5l_fill_1
XFILLER_21_809 VPWR VGND sg13cmos5l_decap_8
XFILLER_32_146 VPWR VGND sg13cmos5l_fill_1
XFILLER_14_883 VPWR VGND sg13cmos5l_fill_1
X_10808_ _10808_/Q clkload35/A _10808_/D _10808_/RESET_B VPWR VGND sg13cmos5l_dfrbpq_1
XFILLER_32_179 VPWR VGND sg13cmos5l_decap_8
X_11239__1662 _11239_/RESET_B VPWR VGND sg13cmos5l_tiehi
X_10739_ _11564_/D _10739_/A _10739_/B VPWR VGND sg13cmos5l_nor2_1
XFILLER_12_1022 VPWR VGND sg13cmos5l_decap_8
XFILLER_99_102 VPWR VGND sg13cmos5l_decap_8
X_07950_ _07950_/Y _07950_/A _07958_/B VPWR VGND sg13cmos5l_nand2_1
XFILLER_99_179 VPWR VGND sg13cmos5l_decap_8
Xhold2907 _11514_/D _10145_/X VPWR VGND sg13cmos5l_dlygate4sd3_1
X_06901_ _11635_/D _11706_/D hold2832/X _08640_/A VPWR VGND sg13cmos5l_mux2_1
Xhold2918 hold2918/X _11471_/Q VPWR VGND sg13cmos5l_dlygate4sd3_1
Xhold2929 hold2929/X _11460_/Q VPWR VGND sg13cmos5l_dlygate4sd3_1
X_07881_ _07881_/Y _07881_/A _07881_/B VPWR VGND sg13cmos5l_nor2_1
X_06832_ _06832_/Y _06832_/A _06835_/B VPWR VGND sg13cmos5l_nor2_1
X_09620_ _09620_/Y _09620_/A _09620_/B VPWR VGND sg13cmos5l_nand2_1
X_06763_ _06763_/Y _06269_/A _06444_/C _06773_/B1 _06761_/Y VPWR VGND sg13cmos5l_a22oi_1
X_09551_ _09551_/X _11254_/Q _11222_/Q _11190_/Q _11158_/Q _09551_/S0 _09551_/S1 VPWR
+ VGND sg13cmos5l_mux4_1
X_08502_ _08502_/Y _08502_/A _08504_/B VPWR VGND sg13cmos5l_nand2_1
XFILLER_102_49 VPWR VGND sg13cmos5l_decap_8
XFILLER_51_411 VPWR VGND sg13cmos5l_decap_4
X_06694_ _10809_/D _06146_/Y _06691_/Y _06693_/Y VPWR VGND sg13cmos5l_o21ai_1
X_09482_ _09482_/Y hold2711/X _09404_/B _09403_/C _09479_/Y VPWR VGND sg13cmos5l_a22oi_1
X_08433_ _08433_/Y _08433_/A _08433_/B VPWR VGND sg13cmos5l_nor2_1
XFILLER_52_956 VPWR VGND sg13cmos5l_fill_1
X_08364_ _08364_/Y _08364_/A _08364_/B VPWR VGND sg13cmos5l_nand2_1
XFILLER_51_499 VPWR VGND sg13cmos5l_fill_2
XFILLER_11_319 VPWR VGND sg13cmos5l_fill_2
XFILLER_32_691 VPWR VGND sg13cmos5l_fill_2
X_07315_ _07315_/Y _07313_/Y _08690_/A _07316_/A2 VPWR VGND sg13cmos5l_a21oi_1
X_08295_ _08295_/Y _08295_/A _08301_/B VPWR VGND sg13cmos5l_nor2_1
X_07246_ _10857_/D _07250_/A _07246_/B VPWR VGND sg13cmos5l_nand2_1
X_11397__1496 _11397_/RESET_B VPWR VGND sg13cmos5l_tiehi
XFILLER_106_903 VPWR VGND sg13cmos5l_decap_8
X_07177_ _07177_/Y _05953_/Y _07182_/C1 _07175_/Y _07176_/Y VPWR VGND sg13cmos5l_a22oi_1
XFILLER_3_507 VPWR VGND sg13cmos5l_fill_2
X_06128_ _06129_/B input20/X hold2293/X _07142_/A2 VPWR VGND sg13cmos5l_a21oi_1
XFILLER_105_468 VPWR VGND sg13cmos5l_fill_1
XFILLER_87_28 VPWR VGND sg13cmos5l_decap_8
XFILLER_79_809 VPWR VGND sg13cmos5l_decap_8
X_10819__956 _10819_/RESET_B VPWR VGND sg13cmos5l_tiehi
X_06059_ _06087_/A _06059_/A _08607_/B VPWR VGND sg13cmos5l_nor2_1
Xfanout332 _10785_/B _10791_/B VPWR VGND sg13cmos5l_buf_1
Xfanout310 _08321_/A1 _07467_/Y VPWR VGND sg13cmos5l_buf_1
Xfanout321 _07018_/B _07030_/B VPWR VGND sg13cmos5l_buf_1
Xfanout343 _10049_/A1 _06476_/Y VPWR VGND sg13cmos5l_buf_1
Xfanout365 _10168_/B _10662_/A VPWR VGND sg13cmos5l_buf_1
Xfanout354 _09775_/A fanout357/X VPWR VGND sg13cmos5l_buf_1
XFILLER_100_140 VPWR VGND sg13cmos5l_decap_8
X_09818_ _09818_/Y _10035_/B1 _09814_/X _09817_/Y VPWR VGND sg13cmos5l_o21ai_1
Xfanout398 _09738_/A1 _09602_/C1 VPWR VGND sg13cmos5l_buf_1
Xfanout387 _09633_/A _09574_/B1 VPWR VGND sg13cmos5l_buf_1
Xfanout376 _09745_/A _09996_/A VPWR VGND sg13cmos5l_buf_1
XFILLER_74_558 VPWR VGND sg13cmos5l_fill_1
XFILLER_36_10 VPWR VGND sg13cmos5l_fill_1
X_11317__1584 _11317_/RESET_B VPWR VGND sg13cmos5l_tiehi
X_09749_ _09749_/Y _10513_/A _09725_/B _09748_/X _09775_/A VPWR VGND sg13cmos5l_a22oi_1
XFILLER_55_750 VPWR VGND sg13cmos5l_decap_8
XFILLER_27_452 VPWR VGND sg13cmos5l_fill_2
XFILLER_36_87 VPWR VGND sg13cmos5l_fill_2
X_11711_ _11711_/Q _11713_/CLK _11711_/D _11711_/RESET_B VPWR VGND sg13cmos5l_dfrbpq_1
XFILLER_14_124 VPWR VGND sg13cmos5l_fill_1
X_11642_ _11642_/Q clkload27/A _11642_/D _11642_/RESET_B VPWR VGND sg13cmos5l_dfrbpq_1
XFILLER_30_628 VPWR VGND sg13cmos5l_fill_1
XFILLER_23_680 VPWR VGND sg13cmos5l_decap_8
X_11573_ _11573_/Q clkload26/A _11573_/D _11573_/RESET_B VPWR VGND sg13cmos5l_dfrbpq_1
Xinput18 input18/X uio_in[0] VPWR VGND sg13cmos5l_buf_1
XFILLER_11_886 VPWR VGND sg13cmos5l_fill_1
X_10524_ _10526_/B _10539_/A _10524_/B VPWR VGND sg13cmos5l_nand2_1
X_10455_ _10455_/Y _10382_/Y _10397_/Y _10419_/A VPWR VGND sg13cmos5l_o21ai_1
XFILLER_6_345 VPWR VGND sg13cmos5l_fill_2
XFILLER_97_617 VPWR VGND sg13cmos5l_decap_8
X_10386_ _10391_/B _10422_/A _10386_/B _10386_/C VPWR VGND sg13cmos5l_nand3_1
XFILLER_97_628 VPWR VGND sg13cmos5l_fill_2
X_11460__1352 _11460_/RESET_B VPWR VGND sg13cmos5l_tiehi
XFILLER_96_149 VPWR VGND sg13cmos5l_fill_1
XFILLER_78_853 VPWR VGND sg13cmos5l_decap_8
X_11007_ _11007_/Q clkload58/A _11007_/D _11007_/RESET_B VPWR VGND sg13cmos5l_dfrbpq_1
XFILLER_93_801 VPWR VGND sg13cmos5l_fill_1
XFILLER_78_897 VPWR VGND sg13cmos5l_decap_8
X_11467__1317 _11467_/RESET_B VPWR VGND sg13cmos5l_tiehi
XFILLER_92_333 VPWR VGND sg13cmos5l_fill_2
XFILLER_65_558 VPWR VGND sg13cmos5l_fill_2
XFILLER_46_761 VPWR VGND sg13cmos5l_decap_4
XFILLER_92_377 VPWR VGND sg13cmos5l_decap_8
XFILLER_45_271 VPWR VGND sg13cmos5l_decap_4
XFILLER_61_731 VPWR VGND sg13cmos5l_fill_1
XFILLER_33_444 VPWR VGND sg13cmos5l_fill_2
XFILLER_34_967 VPWR VGND sg13cmos5l_fill_1
XFILLER_61_797 VPWR VGND sg13cmos5l_fill_2
XFILLER_60_274 VPWR VGND sg13cmos5l_decap_8
XFILLER_21_606 VPWR VGND sg13cmos5l_fill_1
XFILLER_14_691 VPWR VGND sg13cmos5l_fill_2
X_07100_ _11715_/D hold2874/X _07210_/B _07100_/S VPWR VGND sg13cmos5l_mux2_1
XFILLER_9_150 VPWR VGND sg13cmos5l_fill_1
X_08080_ _08080_/Y _08080_/A _08088_/B VPWR VGND sg13cmos5l_nand2_1
X_07031_ _07031_/Y _07030_/B _07029_/Y _07030_/Y VPWR VGND sg13cmos5l_o21ai_1
Xhold2704 _11703_/D _07090_/X VPWR VGND sg13cmos5l_dlygate4sd3_1
X_08982_ _09022_/B _08982_/A VPWR VGND sg13cmos5l_inv_1
Xhold2726 _11687_/D _06913_/A VPWR VGND sg13cmos5l_dlygate4sd3_1
Xhold2715 _06065_/B _11641_/Q VPWR VGND sg13cmos5l_dlygate4sd3_1
Xhold2737 _10838_/D _07204_/Y VPWR VGND sg13cmos5l_dlygate4sd3_1
XFILLER_69_842 VPWR VGND sg13cmos5l_decap_8
X_07933_ _11056_/D _08063_/A1 _07946_/B _07932_/Y VPWR VGND sg13cmos5l_o21ai_1
Xhold2759 hold2759/X _11721_/Q VPWR VGND sg13cmos5l_dlygate4sd3_1
Xhold2748 _07242_/B _07241_/Y VPWR VGND sg13cmos5l_dlygate4sd3_1
X_07864_ _11022_/D _08451_/A1 _07875_/B _07863_/Y VPWR VGND sg13cmos5l_a21oi_1
XFILLER_95_182 VPWR VGND sg13cmos5l_fill_1
XFILLER_95_171 VPWR VGND sg13cmos5l_decap_8
XFILLER_95_160 VPWR VGND sg13cmos5l_fill_2
X_06815_ _06835_/B _06939_/A _07190_/C VPWR VGND sg13cmos5l_nand2_1
X_09603_ _09610_/A _10017_/A _09603_/B _09603_/C VPWR VGND sg13cmos5l_nor3_1
XFILLER_84_878 VPWR VGND sg13cmos5l_fill_2
XFILLER_37_761 VPWR VGND sg13cmos5l_fill_2
X_07795_ _10989_/D _08514_/A1 _07814_/B _07794_/Y VPWR VGND sg13cmos5l_o21ai_1
X_09534_ _09540_/B _09534_/A _09534_/B VPWR VGND sg13cmos5l_nor2_1
X_06746_ _06752_/B _06374_/B _06738_/B _06380_/Y VPWR VGND sg13cmos5l_o21ai_1
XFILLER_36_282 VPWR VGND sg13cmos5l_fill_2
X_09465_ _09465_/X _10995_/Q _10963_/Q _09576_/B VPWR VGND sg13cmos5l_mux2_1
X_06677_ _06687_/B _06670_/B _06360_/Y _06364_/A VPWR VGND sg13cmos5l_o21ai_1
XFILLER_24_422 VPWR VGND sg13cmos5l_fill_1
X_08416_ _11293_/D fanout79/X _08415_/B _08415_/Y VPWR VGND sg13cmos5l_a21oi_1
XFILLER_19_1028 VPWR VGND sg13cmos5l_fill_1
XFILLER_40_959 VPWR VGND sg13cmos5l_decap_8
X_09396_ _09396_/Y _11344_/Q _09491_/S _09495_/A1 VPWR VGND sg13cmos5l_a21oi_1
X_08347_ _11259_/D fanout83/X _08366_/B _08346_/Y VPWR VGND sg13cmos5l_o21ai_1
XFILLER_20_694 VPWR VGND sg13cmos5l_decap_8
X_08278_ _11225_/D fanout98/X _08293_/B _08277_/Y VPWR VGND sg13cmos5l_a21oi_1
X_11180__1721 _11180_/RESET_B VPWR VGND sg13cmos5l_tiehi
XFILLER_106_700 VPWR VGND sg13cmos5l_decap_8
X_07229_ _07229_/Y _10849_/Q _07237_/A2 _07243_/B1 _06905_/A VPWR VGND sg13cmos5l_a22oi_1
XFILLER_105_210 VPWR VGND sg13cmos5l_decap_8
XFILLER_98_49 VPWR VGND sg13cmos5l_decap_8
X_10240_ _10240_/Y _10326_/A _10240_/B VPWR VGND sg13cmos5l_nand2_1
XFILLER_4_849 VPWR VGND sg13cmos5l_decap_8
XFILLER_106_777 VPWR VGND sg13cmos5l_decap_8
XFILLER_105_287 VPWR VGND sg13cmos5l_decap_8
X_10171_ _10173_/B _10171_/A _10171_/B VPWR VGND sg13cmos5l_nand2_1
Xfanout140 _07946_/B _07948_/B VPWR VGND sg13cmos5l_buf_1
XFILLER_102_983 VPWR VGND sg13cmos5l_decap_8
XFILLER_59_363 VPWR VGND sg13cmos5l_decap_4
Xfanout151 _08528_/A1 _08333_/A1 VPWR VGND sg13cmos5l_buf_1
Xfanout173 _08553_/B _08543_/B VPWR VGND sg13cmos5l_buf_1
Xfanout162 _07431_/B _07371_/B VPWR VGND sg13cmos5l_buf_1
XFILLER_101_482 VPWR VGND sg13cmos5l_decap_4
XFILLER_74_333 VPWR VGND sg13cmos5l_fill_1
XFILLER_59_385 VPWR VGND sg13cmos5l_decap_4
XFILLER_47_536 VPWR VGND sg13cmos5l_decap_8
Xfanout195 _08273_/B _08299_/B VPWR VGND sg13cmos5l_buf_1
Xfanout184 _08401_/B _08376_/Y VPWR VGND sg13cmos5l_buf_1
XFILLER_16_901 VPWR VGND sg13cmos5l_decap_4
XFILLER_28_750 VPWR VGND sg13cmos5l_decap_8
XFILLER_90_837 VPWR VGND sg13cmos5l_fill_1
X_10859__1124 _10859_/RESET_B VPWR VGND sg13cmos5l_tiehi
X_11445__1400 _11445_/RESET_B VPWR VGND sg13cmos5l_tiehi
XFILLER_28_783 VPWR VGND sg13cmos5l_decap_4
XFILLER_34_219 VPWR VGND sg13cmos5l_fill_1
XFILLER_103_70 VPWR VGND sg13cmos5l_decap_8
XFILLER_55_591 VPWR VGND sg13cmos5l_fill_1
XFILLER_63_96 VPWR VGND sg13cmos5l_fill_2
XFILLER_15_488 VPWR VGND sg13cmos5l_decap_8
XFILLER_30_447 VPWR VGND sg13cmos5l_decap_4
X_11625_ _11625_/Q _11646_/CLK _11625_/D _11625_/RESET_B VPWR VGND sg13cmos5l_dfrbpq_1
X_11556_ _11556_/Q _11713_/CLK _11556_/D _11556_/RESET_B VPWR VGND sg13cmos5l_dfrbpq_1
XFILLER_11_661 VPWR VGND sg13cmos5l_decap_8
X_10507_ _10507_/Y _10526_/A _10507_/B _10507_/C VPWR VGND sg13cmos5l_nand3_1
X_11487_ _11487_/Q clkload21/A _11487_/D _11487_/RESET_B VPWR VGND sg13cmos5l_dfrbpq_1
XFILLER_98_915 VPWR VGND sg13cmos5l_decap_8
X_10438_ _10438_/Y _10539_/A _10437_/X _10494_/B1 VPWR VGND sg13cmos5l_a21oi_1
XFILLER_98_948 VPWR VGND sg13cmos5l_fill_1
X_10369_ _10369_/Y _10407_/A _10386_/B _10386_/C VPWR VGND sg13cmos5l_nand3_1
X_11649__1315 _11649_/RESET_B VPWR VGND sg13cmos5l_tiehi
XFILLER_97_436 VPWR VGND sg13cmos5l_fill_2
XFILLER_85_609 VPWR VGND sg13cmos5l_decap_8
XFILLER_97_469 VPWR VGND sg13cmos5l_fill_2
XFILLER_78_672 VPWR VGND sg13cmos5l_fill_1
XFILLER_26_4 VPWR VGND sg13cmos5l_fill_1
XFILLER_65_344 VPWR VGND sg13cmos5l_fill_1
XFILLER_65_333 VPWR VGND sg13cmos5l_decap_8
Xclkbuf_4_1_0_clk clkbuf_4_1_0_clk/X clkbuf_0_clk/X VPWR VGND sg13cmos5l_buf_8
XFILLER_26_709 VPWR VGND sg13cmos5l_decap_8
X_07580_ _10910_/D _07648_/B fanout76/X _07579_/Y VPWR VGND sg13cmos5l_a21oi_1
X_06600_ _06600_/Y _06603_/B _06400_/B _06643_/B1 _06597_/X VPWR VGND sg13cmos5l_a22oi_1
XFILLER_18_260 VPWR VGND sg13cmos5l_fill_1
XFILLER_19_761 VPWR VGND sg13cmos5l_fill_1
X_11570__1399 _11570_/RESET_B VPWR VGND sg13cmos5l_tiehi
X_06531_ _06533_/A _06531_/A _11649_/Q VPWR VGND sg13cmos5l_nand2_1
XFILLER_34_731 VPWR VGND sg13cmos5l_fill_2
XFILLER_34_753 VPWR VGND sg13cmos5l_decap_8
X_09250_ _09919_/B _09938_/A _10854_/Q VPWR VGND sg13cmos5l_nor2_1
XFILLER_34_775 VPWR VGND sg13cmos5l_decap_8
X_08201_ _11187_/D _08331_/A1 _08198_/B _08200_/Y VPWR VGND sg13cmos5l_o21ai_1
X_06462_ _06462_/Y _10892_/Q _06468_/B _09842_/B1 VPWR VGND sg13cmos5l_a21oi_1
X_06393_ _06402_/B _06772_/S _06325_/Y _06387_/Y _06388_/Y _06392_/Y VPWR VGND sg13cmos5l_a221oi_1
X_09181_ _09340_/A _09346_/A _10832_/Q VPWR VGND sg13cmos5l_xor2_1
X_08132_ _11153_/D _08457_/A1 _08153_/B _08131_/Y VPWR VGND sg13cmos5l_a21oi_1
X_08063_ _11120_/D _08063_/A1 _08076_/B _08062_/Y VPWR VGND sg13cmos5l_o21ai_1
X_07014_ _07014_/Y _07014_/A _07034_/B VPWR VGND sg13cmos5l_nand2_1
XFILLER_103_714 VPWR VGND sg13cmos5l_fill_1
XFILLER_102_224 VPWR VGND sg13cmos5l_decap_8
Xhold2501 hold2501/X _11581_/Q VPWR VGND sg13cmos5l_dlygate4sd3_1
X_08965_ _08965_/Y _11630_/Q _08943_/B _08950_/B _11631_/Q VPWR VGND sg13cmos5l_a22oi_1
Xhold2512 _11659_/D _06989_/X VPWR VGND sg13cmos5l_dlygate4sd3_1
X_07916_ _11048_/D fanout52/X _07917_/B _07915_/Y VPWR VGND sg13cmos5l_a21oi_1
Xhold2545 _10712_/B _11752_/Q VPWR VGND sg13cmos5l_dlygate4sd3_1
Xhold2523 hold2523/X _11673_/Q VPWR VGND sg13cmos5l_dlygate4sd3_1
Xhold2556 hold2556/X _11411_/Q VPWR VGND sg13cmos5l_dlygate4sd3_1
Xhold2534 _07425_/A _10888_/Q VPWR VGND sg13cmos5l_dlygate4sd3_1
Xhold1844 _07980_/A _11080_/Q VPWR VGND sg13cmos5l_dlygate4sd3_1
Xhold2578 _11576_/D _10760_/X VPWR VGND sg13cmos5l_dlygate4sd3_1
Xhold2589 _06022_/A _11748_/Q VPWR VGND sg13cmos5l_dlygate4sd3_1
XFILLER_56_311 VPWR VGND sg13cmos5l_fill_1
Xhold2567 _11375_/D _08623_/Y VPWR VGND sg13cmos5l_dlygate4sd3_1
X_08896_ _08906_/B _11385_/Q _08896_/B VPWR VGND sg13cmos5l_xnor2_1
Xhold1833 _08446_/A _11308_/Q VPWR VGND sg13cmos5l_dlygate4sd3_1
XFILLER_29_536 VPWR VGND sg13cmos5l_decap_8
Xhold1866 _08314_/A _11243_/Q VPWR VGND sg13cmos5l_dlygate4sd3_1
X_07847_ _11015_/D fanout53/X _07846_/B _07846_/Y VPWR VGND sg13cmos5l_o21ai_1
XFILLER_56_355 VPWR VGND sg13cmos5l_fill_1
Xhold1855 _08320_/A _11246_/Q VPWR VGND sg13cmos5l_dlygate4sd3_1
Xhold1877 _07826_/A _11005_/Q VPWR VGND sg13cmos5l_dlygate4sd3_1
X_11198__1703 _11198_/RESET_B VPWR VGND sg13cmos5l_tiehi
X_11390__1508 _11390_/RESET_B VPWR VGND sg13cmos5l_tiehi
X_07778_ _07778_/Y _07778_/A _07778_/B VPWR VGND sg13cmos5l_nor2_1
Xhold1888 _08074_/A _11126_/Q VPWR VGND sg13cmos5l_dlygate4sd3_1
Xhold1899 _08212_/A _11193_/Q VPWR VGND sg13cmos5l_dlygate4sd3_1
X_09517_ _09517_/Y _10965_/Q _09652_/S _06477_/B VPWR VGND sg13cmos5l_a21oi_1
X_06729_ _06729_/Y _06739_/A _06738_/B _06728_/Y VPWR VGND sg13cmos5l_o21ai_1
XFILLER_24_230 VPWR VGND sg13cmos5l_fill_1
X_09448_ _09448_/Y _11346_/Q _09576_/B _09495_/A1 VPWR VGND sg13cmos5l_a21oi_1
XFILLER_24_274 VPWR VGND sg13cmos5l_fill_1
XFILLER_24_285 VPWR VGND sg13cmos5l_decap_4
X_11727__1226 _11727_/RESET_B VPWR VGND sg13cmos5l_tiehi
XFILLER_8_418 VPWR VGND sg13cmos5l_fill_2
X_09379_ _09379_/Y _09506_/A _09379_/B _09379_/C VPWR VGND sg13cmos5l_nand3_1
X_11410_ _11410_/Q clkload37/A _11410_/D _11410_/RESET_B VPWR VGND sg13cmos5l_dfrbpq_1
XFILLER_21_981 VPWR VGND sg13cmos5l_decap_8
X_11341_ _11341_/Q clkload34/A _11341_/D _11341_/RESET_B VPWR VGND sg13cmos5l_dfrbpq_1
X_11272_ _11272_/Q clkload50/A _11272_/D _11272_/RESET_B VPWR VGND sg13cmos5l_dfrbpq_1
XFILLER_106_574 VPWR VGND sg13cmos5l_decap_8
XFILLER_79_414 VPWR VGND sg13cmos5l_decap_8
X_10223_ _10224_/B _10222_/A _10222_/C _10222_/B VPWR VGND sg13cmos5l_o21ai_1
X_10154_ _10154_/Y _05935_/A _10051_/B _10153_/Y VPWR VGND sg13cmos5l_a21oi_1
XFILLER_3_189 VPWR VGND sg13cmos5l_fill_1
XFILLER_95_929 VPWR VGND sg13cmos5l_decap_8
XFILLER_88_981 VPWR VGND sg13cmos5l_decap_8
XFILLER_58_41 VPWR VGND sg13cmos5l_decap_4
XFILLER_0_852 VPWR VGND sg13cmos5l_decap_8
XFILLER_59_160 VPWR VGND sg13cmos5l_decap_8
XFILLER_48_834 VPWR VGND sg13cmos5l_fill_1
XFILLER_47_300 VPWR VGND sg13cmos5l_decap_4
X_10085_ _10085_/X _06172_/A _10088_/A2 _10084_/Y VPWR VGND sg13cmos5l_a21o_1
XFILLER_75_653 VPWR VGND sg13cmos5l_decap_8
XFILLER_48_878 VPWR VGND sg13cmos5l_decap_4
XFILLER_48_867 VPWR VGND sg13cmos5l_decap_8
XFILLER_75_697 VPWR VGND sg13cmos5l_decap_4
X_10987_ _10987_/Q clkload32/A _10987_/D _10987_/RESET_B VPWR VGND sg13cmos5l_dfrbpq_1
XFILLER_43_550 VPWR VGND sg13cmos5l_decap_8
XFILLER_95_7 VPWR VGND sg13cmos5l_decap_8
XFILLER_70_380 VPWR VGND sg13cmos5l_fill_1
XFILLER_43_594 VPWR VGND sg13cmos5l_decap_8
XFILLER_30_211 VPWR VGND sg13cmos5l_decap_8
XFILLER_30_255 VPWR VGND sg13cmos5l_decap_8
X_11608_ _11608_/Q _11622_/CLK _11608_/D _11608_/RESET_B VPWR VGND sg13cmos5l_dfrbpq_1
X_11078__847 _11078_/RESET_B VPWR VGND sg13cmos5l_tiehi
X_11409__1472 _11409_/RESET_B VPWR VGND sg13cmos5l_tiehi
XFILLER_30_288 VPWR VGND sg13cmos5l_fill_2
XFILLER_8_963 VPWR VGND sg13cmos5l_decap_8
X_11539_ _11539_/Q clkload43/A _11539_/D _11539_/RESET_B VPWR VGND sg13cmos5l_dfrbpq_1
XFILLER_7_484 VPWR VGND sg13cmos5l_fill_2
XFILLER_99_81 VPWR VGND sg13cmos5l_decap_8
X_11276__1625 _11276_/RESET_B VPWR VGND sg13cmos5l_tiehi
XFILLER_86_907 VPWR VGND sg13cmos5l_decap_8
XFILLER_78_480 VPWR VGND sg13cmos5l_decap_4
X_08750_ _08751_/B _08750_/A _08750_/B VPWR VGND sg13cmos5l_nand2_1
XFILLER_66_620 VPWR VGND sg13cmos5l_decap_4
X_05962_ _05962_/Y _11316_/Q VPWR VGND sg13cmos5l_inv_1
X_07701_ _10944_/D fanout73/X _07704_/B _07700_/Y VPWR VGND sg13cmos5l_a21oi_1
XFILLER_94_951 VPWR VGND sg13cmos5l_decap_8
X_05893_ _05893_/Y _06772_/S VPWR VGND sg13cmos5l_inv_1
X_08681_ _11401_/D _08681_/A VPWR VGND sg13cmos5l_inv_1
X_07632_ _07632_/Y _10653_/A _07643_/D _07631_/Y VPWR VGND sg13cmos5l_a21oi_1
XFILLER_66_697 VPWR VGND sg13cmos5l_fill_2
XFILLER_38_388 VPWR VGND sg13cmos5l_decap_8
XFILLER_93_494 VPWR VGND sg13cmos5l_decap_8
XFILLER_81_634 VPWR VGND sg13cmos5l_fill_1
XFILLER_53_336 VPWR VGND sg13cmos5l_decap_8
XFILLER_0_70 VPWR VGND sg13cmos5l_decap_4
X_09302_ _09302_/Y _09302_/A _09302_/B VPWR VGND sg13cmos5l_nor2_1
XFILLER_62_870 VPWR VGND sg13cmos5l_decap_4
X_07563_ _07564_/C _11410_/Q _07556_/Y VPWR VGND sg13cmos5l_nor2b_1
XFILLER_34_550 VPWR VGND sg13cmos5l_decap_8
X_06514_ _06514_/Y _06512_/Y _06513_/Y _09574_/A1 VPWR VGND sg13cmos5l_a21oi_1
X_07494_ _07494_/Y _07493_/A _07490_/X _07492_/Y _07493_/Y VPWR VGND sg13cmos5l_a22oi_1
X_06445_ _06446_/B _06444_/A _09270_/A _06758_/A2 VPWR VGND sg13cmos5l_o21ai_1
X_09233_ _09239_/C _09721_/A _10846_/Q VPWR VGND sg13cmos5l_nor2_1
X_09164_ _09811_/B _10307_/A _09164_/B VPWR VGND sg13cmos5l_nand2_1
XFILLER_21_266 VPWR VGND sg13cmos5l_fill_1
X_08115_ _08246_/B _08376_/A _08376_/B VPWR VGND sg13cmos5l_nand2b_1
X_10843__1156 _10843_/RESET_B VPWR VGND sg13cmos5l_tiehi
X_06376_ _06376_/Y _06376_/A VPWR VGND sg13cmos5l_inv_1
X_09095_ _09120_/A _09109_/A _09102_/B VPWR VGND sg13cmos5l_xor2_1
X_08046_ _11112_/D fanout52/X _08047_/B _08045_/Y VPWR VGND sg13cmos5l_a21oi_1
X_11480__1223 _11480_/RESET_B VPWR VGND sg13cmos5l_tiehi
XFILLER_1_605 VPWR VGND sg13cmos5l_decap_8
XFILLER_95_28 VPWR VGND sg13cmos5l_decap_8
XFILLER_88_266 VPWR VGND sg13cmos5l_fill_2
X_09997_ _09998_/C _11620_/Q _11612_/Q _09275_/Y VPWR VGND sg13cmos5l_o21ai_1
Xhold2320 _09015_/A _11444_/Q VPWR VGND sg13cmos5l_dlygate4sd3_1
Xhold2331 _10866_/D _07294_/Y VPWR VGND sg13cmos5l_dlygate4sd3_1
XFILLER_57_620 VPWR VGND sg13cmos5l_fill_1
X_08948_ _08948_/Y _08948_/A _08948_/B VPWR VGND sg13cmos5l_nand2_1
Xhold2364 _08135_/A _11155_/Q VPWR VGND sg13cmos5l_dlygate4sd3_1
Xhold2353 _10860_/D _07258_/Y VPWR VGND sg13cmos5l_dlygate4sd3_1
Xhold2342 _10863_/D _07276_/Y VPWR VGND sg13cmos5l_dlygate4sd3_1
XFILLER_28_22 VPWR VGND sg13cmos5l_fill_2
XFILLER_29_300 VPWR VGND sg13cmos5l_fill_1
XFILLER_85_962 VPWR VGND sg13cmos5l_decap_4
Xhold2375 _07911_/A _11046_/Q VPWR VGND sg13cmos5l_dlygate4sd3_1
X_08879_ _08879_/Y _08889_/A _08875_/Y _08878_/Y VPWR VGND sg13cmos5l_a21oi_1
Xhold2397 _07672_/A _10930_/Q VPWR VGND sg13cmos5l_dlygate4sd3_1
Xhold2386 _07547_/A _10906_/Q VPWR VGND sg13cmos5l_dlygate4sd3_1
X_10910_ _10910_/Q clkload57/A _10910_/D _10910_/RESET_B VPWR VGND sg13cmos5l_dfrbpq_1
XFILLER_84_472 VPWR VGND sg13cmos5l_decap_8
XFILLER_72_601 VPWR VGND sg13cmos5l_fill_1
XFILLER_17_539 VPWR VGND sg13cmos5l_decap_8
XFILLER_53_870 VPWR VGND sg13cmos5l_decap_4
X_10841_ _10841_/Q clkload19/A _10841_/D _10841_/RESET_B VPWR VGND sg13cmos5l_dfrbpq_1
X_10772_ _10779_/D _10772_/A _11686_/D VPWR VGND sg13cmos5l_nand2_1
XFILLER_44_54 VPWR VGND sg13cmos5l_decap_4
XFILLER_12_244 VPWR VGND sg13cmos5l_decap_8
X_11354__1547 _11354_/RESET_B VPWR VGND sg13cmos5l_tiehi
XFILLER_60_53 VPWR VGND sg13cmos5l_decap_8
XFILLER_12_299 VPWR VGND sg13cmos5l_decap_8
X_11324_ _11324_/Q _11356_/CLK _11324_/D _11324_/RESET_B VPWR VGND sg13cmos5l_dfrbpq_1
XFILLER_69_40 VPWR VGND sg13cmos5l_decap_4
XFILLER_4_454 VPWR VGND sg13cmos5l_fill_2
X_11255_ _11255_/Q clkload9/A _11255_/D _11255_/RESET_B VPWR VGND sg13cmos5l_dfrbpq_1
XFILLER_106_371 VPWR VGND sg13cmos5l_decap_8
X_10206_ _10206_/Y hold2823/X _10172_/Y _10173_/Y hold2767/X _10226_/C1 VPWR VGND
+ sg13cmos5l_a221oi_1
X_11186_ _11186_/Q clkload9/A _11186_/D _11186_/RESET_B VPWR VGND sg13cmos5l_dfrbpq_1
XFILLER_94_225 VPWR VGND sg13cmos5l_fill_1
X_10137_ _10137_/Y _10614_/B2 _10854_/Q _10136_/Y VPWR VGND sg13cmos5l_o21ai_1
XFILLER_39_119 VPWR VGND sg13cmos5l_decap_4
XFILLER_0_671 VPWR VGND sg13cmos5l_decap_8
X_10068_ _11491_/D _07024_/A _10073_/B _10067_/Y _06525_/C VPWR VGND sg13cmos5l_a22oi_1
XFILLER_91_932 VPWR VGND sg13cmos5l_decap_8
X_11596__907 _11596_/RESET_B VPWR VGND sg13cmos5l_tiehi
XFILLER_85_72 VPWR VGND sg13cmos5l_fill_2
XFILLER_48_675 VPWR VGND sg13cmos5l_fill_2
XFILLER_36_826 VPWR VGND sg13cmos5l_decap_8
XFILLER_91_954 VPWR VGND sg13cmos5l_decap_8
XFILLER_91_943 VPWR VGND sg13cmos5l_fill_2
XFILLER_90_431 VPWR VGND sg13cmos5l_decap_8
XFILLER_36_859 VPWR VGND sg13cmos5l_fill_2
XFILLER_36_848 VPWR VGND sg13cmos5l_fill_2
XFILLER_44_870 VPWR VGND sg13cmos5l_fill_1
XFILLER_43_391 VPWR VGND sg13cmos5l_fill_1
XFILLER_31_542 VPWR VGND sg13cmos5l_fill_2
X_06230_ _06713_/A _06719_/B _06714_/A VPWR VGND sg13cmos5l_nor2_1
XFILLER_31_597 VPWR VGND sg13cmos5l_decap_4
X_06161_ _06164_/A _11498_/Q _09559_/A VPWR VGND sg13cmos5l_and2_1
XFILLER_105_809 VPWR VGND sg13cmos5l_decap_8
X_06092_ _06093_/C _06092_/A _06092_/B _06092_/C _06092_/D VPWR VGND sg13cmos5l_nor4_1
X_09920_ _09920_/Y _10006_/A _09920_/B _09948_/C VPWR VGND sg13cmos5l_nand3_1
XFILLER_98_520 VPWR VGND sg13cmos5l_fill_1
Xfanout706 _08867_/A _08889_/A VPWR VGND sg13cmos5l_buf_1
Xfanout717 _08376_/A _11564_/Q VPWR VGND sg13cmos5l_buf_1
XFILLER_86_704 VPWR VGND sg13cmos5l_fill_1
Xfanout728 _10267_/A _10436_/B2 VPWR VGND sg13cmos5l_buf_1
X_09851_ _09851_/Y _09844_/Y _09846_/Y _09850_/Y _09851_/B2 VPWR VGND sg13cmos5l_a22oi_1
Xfanout739 _10433_/B hold2919/X VPWR VGND sg13cmos5l_buf_1
XFILLER_100_525 VPWR VGND sg13cmos5l_fill_1
XFILLER_86_726 VPWR VGND sg13cmos5l_fill_1
X_08802_ _08802_/Y _11378_/Q _08817_/C VPWR VGND sg13cmos5l_nand2_1
X_09782_ _09782_/Y _10305_/A _10849_/Q _09755_/B VPWR VGND sg13cmos5l_a21oi_1
X_06994_ _06994_/Y _11500_/Q _07006_/A _07006_/B _11492_/Q VPWR VGND sg13cmos5l_a22oi_1
XFILLER_105_49 VPWR VGND sg13cmos5l_decap_8
XFILLER_85_258 VPWR VGND sg13cmos5l_fill_1
XFILLER_85_247 VPWR VGND sg13cmos5l_fill_1
X_08733_ _11413_/D _08733_/A VPWR VGND sg13cmos5l_inv_1
X_05945_ _05945_/Y _05945_/A VPWR VGND sg13cmos5l_inv_1
XFILLER_39_653 VPWR VGND sg13cmos5l_decap_8
XFILLER_67_995 VPWR VGND sg13cmos5l_fill_1
XFILLER_54_612 VPWR VGND sg13cmos5l_decap_8
XFILLER_54_601 VPWR VGND sg13cmos5l_fill_2
XFILLER_93_280 VPWR VGND sg13cmos5l_fill_2
X_05876_ _05876_/Y input6/X VPWR VGND sg13cmos5l_inv_1
X_08664_ _08817_/D _08811_/A _07470_/X _08667_/S VPWR VGND sg13cmos5l_mux2_1
XFILLER_39_697 VPWR VGND sg13cmos5l_decap_4
X_08595_ _08595_/Y _10923_/Q _10020_/B VPWR VGND sg13cmos5l_nand2_1
X_07615_ _07615_/Y _07615_/A _07640_/B VPWR VGND sg13cmos5l_nor2_1
X_07546_ _10905_/D _07595_/B fanout98/X _07545_/Y VPWR VGND sg13cmos5l_a21oi_1
XFILLER_22_553 VPWR VGND sg13cmos5l_decap_8
X_07477_ _07477_/X _11525_/Q _10800_/Q _07497_/A VPWR VGND sg13cmos5l_mux2_1
X_09216_ _09216_/Y _09217_/A _10844_/Q VPWR VGND sg13cmos5l_nor2_1
X_06428_ _06428_/X _10658_/A _10642_/A VPWR VGND sg13cmos5l_and2_1
X_09147_ _09147_/Y _09150_/B _09147_/B VPWR VGND sg13cmos5l_xnor2_1
XFILLER_5_218 VPWR VGND sg13cmos5l_fill_1
X_06359_ _06670_/B _06355_/A _06358_/X _06356_/Y VPWR VGND sg13cmos5l_o21ai_1
X_09078_ _09078_/Y _09075_/X _09097_/A _09104_/A VPWR VGND sg13cmos5l_o21ai_1
X_08029_ _08029_/Y _08029_/A _08047_/B VPWR VGND sg13cmos5l_nor2_1
XFILLER_89_520 VPWR VGND sg13cmos5l_decap_8
X_11040_ _11040_/Q clkload57/A _11040_/D _11040_/RESET_B VPWR VGND sg13cmos5l_dfrbpq_1
XFILLER_7_1007 VPWR VGND sg13cmos5l_decap_8
XFILLER_2_969 VPWR VGND sg13cmos5l_decap_8
X_11677__1287 _11677_/RESET_B VPWR VGND sg13cmos5l_tiehi
XFILLER_89_597 VPWR VGND sg13cmos5l_decap_8
Xhold2161 _07855_/A _11018_/Q VPWR VGND sg13cmos5l_dlygate4sd3_1
Xhold2150 _10787_/A _11593_/Q VPWR VGND sg13cmos5l_dlygate4sd3_1
XFILLER_76_247 VPWR VGND sg13cmos5l_decap_8
XFILLER_39_76 VPWR VGND sg13cmos5l_fill_1
Xhold2172 _07752_/A _10969_/Q VPWR VGND sg13cmos5l_dlygate4sd3_1
XFILLER_64_409 VPWR VGND sg13cmos5l_decap_8
XFILLER_55_20 VPWR VGND sg13cmos5l_fill_2
X_11536__1501 _11536_/RESET_B VPWR VGND sg13cmos5l_tiehi
X_11068__857 _11068_/RESET_B VPWR VGND sg13cmos5l_tiehi
Xhold2194 _07526_/A _10903_/Q VPWR VGND sg13cmos5l_dlygate4sd3_1
Xhold2183 _07869_/A _11025_/Q VPWR VGND sg13cmos5l_dlygate4sd3_1
XFILLER_45_645 VPWR VGND sg13cmos5l_decap_8
XFILLER_73_976 VPWR VGND sg13cmos5l_fill_1
XFILLER_45_689 VPWR VGND sg13cmos5l_decap_8
X_10824_ _10824_/Q clkload46/A _10824_/D _10824_/RESET_B VPWR VGND sg13cmos5l_dfrbpq_1
XFILLER_60_626 VPWR VGND sg13cmos5l_fill_2
XFILLER_44_188 VPWR VGND sg13cmos5l_decap_8
XFILLER_44_177 VPWR VGND sg13cmos5l_decap_8
XFILLER_32_328 VPWR VGND sg13cmos5l_fill_1
XFILLER_32_339 VPWR VGND sg13cmos5l_fill_2
XFILLER_41_862 VPWR VGND sg13cmos5l_fill_1
X_10755_ _10755_/Y _10755_/A _10760_/S VPWR VGND sg13cmos5l_nand2_1
X_10686_ _10686_/X _10687_/A _10687_/B VPWR VGND sg13cmos5l_and2_1
XFILLER_65_8 VPWR VGND sg13cmos5l_fill_2
X_11307_ _11307_/Q _11594_/CLK _11307_/D _11307_/RESET_B VPWR VGND sg13cmos5l_dfrbpq_1
XFILLER_5_774 VPWR VGND sg13cmos5l_fill_2
XFILLER_4_262 VPWR VGND sg13cmos5l_decap_8
X_11238_ _11238_/Q clkload52/A _11238_/D _11238_/RESET_B VPWR VGND sg13cmos5l_dfrbpq_1
XFILLER_67_203 VPWR VGND sg13cmos5l_decap_4
X_11169_ _11169_/Q _11361_/CLK _11169_/D _11169_/RESET_B VPWR VGND sg13cmos5l_dfrbpq_1
XFILLER_0_490 VPWR VGND sg13cmos5l_decap_8
XFILLER_36_623 VPWR VGND sg13cmos5l_decap_4
X_08380_ _11275_/D _08510_/A1 _08429_/B _08379_/Y VPWR VGND sg13cmos5l_a21oi_1
XFILLER_91_1000 VPWR VGND sg13cmos5l_fill_2
X_07400_ _07400_/Y _10614_/A1 _07400_/A2 _07399_/Y VPWR VGND sg13cmos5l_a21oi_1
XFILLER_64_998 VPWR VGND sg13cmos5l_decap_8
XFILLER_23_317 VPWR VGND sg13cmos5l_decap_8
XFILLER_23_339 VPWR VGND sg13cmos5l_decap_8
XFILLER_35_188 VPWR VGND sg13cmos5l_decap_8
X_07331_ _07331_/Y _11534_/Q _08730_/A VPWR VGND sg13cmos5l_nand2_1
XFILLER_84_0 VPWR VGND sg13cmos5l_decap_8
X_07262_ _07262_/Y _09180_/A _07262_/A2 _07261_/Y VPWR VGND sg13cmos5l_a21oi_1
X_07193_ _07193_/X _07193_/A _10783_/C VPWR VGND sg13cmos5l_and2_1
X_09001_ _09001_/Y _09051_/A1 _08996_/Y _09000_/Y VPWR VGND sg13cmos5l_a21oi_1
X_06213_ _10282_/A _10268_/A _10433_/A VPWR VGND sg13cmos5l_nand2_1
X_06144_ _06144_/X _06144_/A _06144_/B VPWR VGND sg13cmos5l_and2_1
XFILLER_105_628 VPWR VGND sg13cmos5l_decap_8
XFILLER_104_105 VPWR VGND sg13cmos5l_decap_8
X_06075_ _06076_/B _05941_/Y _10695_/A _06092_/C _10695_/B VPWR VGND sg13cmos5l_a22oi_1
X_09903_ _09903_/Y _11299_/Q _09903_/B VPWR VGND sg13cmos5l_nor2_1
Xfanout514 _09093_/B _08772_/A2 VPWR VGND sg13cmos5l_buf_1
Xfanout503 _09828_/B _09885_/B VPWR VGND sg13cmos5l_buf_1
XFILLER_101_812 VPWR VGND sg13cmos5l_fill_1
XFILLER_98_372 VPWR VGND sg13cmos5l_decap_8
XFILLER_98_361 VPWR VGND sg13cmos5l_decap_8
X_09834_ _09834_/Y _09944_/A _09834_/B VPWR VGND sg13cmos5l_nand2_1
Xfanout525 _07577_/A _07591_/A VPWR VGND sg13cmos5l_buf_1
Xfanout536 _08667_/S _08671_/S VPWR VGND sg13cmos5l_buf_1
Xfanout547 _07055_/B _10441_/B1 VPWR VGND sg13cmos5l_buf_1
Xfanout569 _07205_/B _07191_/A2 VPWR VGND sg13cmos5l_buf_1
Xfanout558 _07400_/A2 _07430_/A2 VPWR VGND sg13cmos5l_buf_1
X_09765_ _09766_/C _09761_/Y _09762_/Y _09763_/Y _09764_/Y _10038_/C1 VPWR VGND sg13cmos5l_a221oi_1
X_10982__1000 _10982_/RESET_B VPWR VGND sg13cmos5l_tiehi
XFILLER_46_409 VPWR VGND sg13cmos5l_decap_8
X_06977_ _06977_/X hold2515/X _08626_/A1 _06976_/Y VPWR VGND sg13cmos5l_a21o_1
XFILLER_73_228 VPWR VGND sg13cmos5l_fill_2
XFILLER_66_280 VPWR VGND sg13cmos5l_fill_1
XFILLER_55_954 VPWR VGND sg13cmos5l_fill_2
X_05928_ _07016_/A _06197_/A VPWR VGND sg13cmos5l_inv_1
XFILLER_39_494 VPWR VGND sg13cmos5l_fill_1
XFILLER_39_483 VPWR VGND sg13cmos5l_decap_8
X_08716_ _08717_/B _08721_/A _08716_/B VPWR VGND sg13cmos5l_nand2_1
X_09696_ _09697_/B _09696_/A _09721_/B VPWR VGND sg13cmos5l_nor2_1
XFILLER_27_634 VPWR VGND sg13cmos5l_decap_8
XFILLER_82_773 VPWR VGND sg13cmos5l_decap_8
X_08647_ _08647_/Y _11392_/Q _06092_/D _10695_/B _06092_/C VPWR VGND sg13cmos5l_a22oi_1
X_05859_ _10323_/B _11559_/Q VPWR VGND sg13cmos5l_inv_1
XFILLER_81_250 VPWR VGND sg13cmos5l_fill_1
X_08578_ _08578_/X _11242_/Q _11210_/Q _11178_/Q _11146_/Q _08573_/S _08599_/S1 VPWR
+ VGND sg13cmos5l_mux4_1
X_07529_ _07530_/B _11405_/Q _07542_/D VPWR VGND sg13cmos5l_nor2_1
X_11271__1630 _11271_/RESET_B VPWR VGND sg13cmos5l_tiehi
X_10540_ _10540_/Y _10583_/B _10524_/B _10644_/B1 VPWR VGND sg13cmos5l_a21oi_1
XFILLER_41_22 VPWR VGND sg13cmos5l_fill_1
XFILLER_41_11 VPWR VGND sg13cmos5l_fill_1
XFILLER_10_523 VPWR VGND sg13cmos5l_fill_2
XFILLER_22_394 VPWR VGND sg13cmos5l_decap_8
X_10471_ _10471_/Y fanout84/X _10470_/X _10488_/A VPWR VGND sg13cmos5l_o21ai_1
XFILLER_6_527 VPWR VGND sg13cmos5l_decap_4
XFILLER_10_567 VPWR VGND sg13cmos5l_decap_8
XFILLER_6_538 VPWR VGND sg13cmos5l_decap_4
Xheichips26_RiMaX_1820 uio_oe[5] VPWR VGND sg13cmos5l_tiehi
X_11023_ _11023_/Q clkload44/A _11023_/D _11023_/RESET_B VPWR VGND sg13cmos5l_dfrbpq_1
XFILLER_106_70 VPWR VGND sg13cmos5l_decap_8
XFILLER_103_182 VPWR VGND sg13cmos5l_decap_8
XFILLER_92_504 VPWR VGND sg13cmos5l_fill_1
XFILLER_77_589 VPWR VGND sg13cmos5l_decap_4
XFILLER_66_63 VPWR VGND sg13cmos5l_fill_1
XFILLER_49_258 VPWR VGND sg13cmos5l_decap_4
XFILLER_64_217 VPWR VGND sg13cmos5l_fill_2
XFILLER_17_100 VPWR VGND sg13cmos5l_fill_2
XFILLER_73_762 VPWR VGND sg13cmos5l_decap_8
XFILLER_73_740 VPWR VGND sg13cmos5l_decap_8
XFILLER_57_291 VPWR VGND sg13cmos5l_fill_1
XFILLER_73_795 VPWR VGND sg13cmos5l_fill_1
XFILLER_18_689 VPWR VGND sg13cmos5l_fill_1
XFILLER_33_637 VPWR VGND sg13cmos5l_decap_8
XFILLER_9_310 VPWR VGND sg13cmos5l_decap_8
XFILLER_14_862 VPWR VGND sg13cmos5l_decap_8
XFILLER_20_309 VPWR VGND sg13cmos5l_fill_2
X_10807_ _10807_/Q clkload15/A _10807_/D _10807_/RESET_B VPWR VGND sg13cmos5l_dfrbpq_1
X_10738_ _10738_/Y _08376_/A _10730_/Y _10731_/Y hold2449/X VPWR VGND sg13cmos5l_a22oi_1
XFILLER_41_681 VPWR VGND sg13cmos5l_fill_2
X_11101__1800 _11101_/RESET_B VPWR VGND sg13cmos5l_tiehi
X_10669_ _10669_/Y _10666_/Y _10668_/Y _10640_/A VPWR VGND sg13cmos5l_a21oi_1
XFILLER_56_4 VPWR VGND sg13cmos5l_fill_2
X_11525__1133 _11525_/RESET_B VPWR VGND sg13cmos5l_tiehi
XFILLER_99_158 VPWR VGND sg13cmos5l_decap_8
X_11134__1767 _11134_/RESET_B VPWR VGND sg13cmos5l_tiehi
XFILLER_101_119 VPWR VGND sg13cmos5l_decap_8
Xhold2908 hold2908/X _11486_/Q VPWR VGND sg13cmos5l_dlygate4sd3_1
X_06900_ _11706_/D hold2766/X _07175_/A _07091_/S VPWR VGND sg13cmos5l_mux2_1
Xhold2919 hold2919/X _11504_/Q VPWR VGND sg13cmos5l_dlygate4sd3_1
X_07880_ _11030_/D _08075_/A1 _07901_/B _07879_/Y VPWR VGND sg13cmos5l_a21oi_1
XFILLER_95_375 VPWR VGND sg13cmos5l_fill_1
X_06831_ _06874_/A _11713_/Q _06831_/B _07210_/B _06839_/D VPWR VGND sg13cmos5l_nor4_1
XFILLER_68_578 VPWR VGND sg13cmos5l_fill_2
XFILLER_95_397 VPWR VGND sg13cmos5l_fill_1
X_06762_ _06762_/Y _06266_/Y _06401_/D _06775_/B1 VPWR VGND sg13cmos5l_a21oi_1
XFILLER_55_217 VPWR VGND sg13cmos5l_decap_8
XFILLER_49_781 VPWR VGND sg13cmos5l_decap_4
X_09550_ _09550_/Y _09846_/A1 _09549_/X _09633_/A VPWR VGND sg13cmos5l_a21oi_1
XFILLER_102_28 VPWR VGND sg13cmos5l_decap_8
X_08501_ _11335_/D fanout53/X _08500_/B _08500_/Y VPWR VGND sg13cmos5l_o21ai_1
XFILLER_64_762 VPWR VGND sg13cmos5l_decap_8
XFILLER_36_442 VPWR VGND sg13cmos5l_fill_1
X_09481_ _09484_/B _09884_/A _09481_/B _09560_/B VPWR VGND sg13cmos5l_nor3_1
X_08432_ _11301_/D fanout58/X _08431_/B _08431_/Y VPWR VGND sg13cmos5l_a21oi_1
XFILLER_52_946 VPWR VGND sg13cmos5l_fill_2
XFILLER_52_913 VPWR VGND sg13cmos5l_decap_4
X_06693_ _06693_/Y _06773_/B1 _06690_/Y _06692_/Y VPWR VGND sg13cmos5l_a21oi_1
XFILLER_24_604 VPWR VGND sg13cmos5l_fill_1
XFILLER_63_283 VPWR VGND sg13cmos5l_fill_1
XFILLER_52_979 VPWR VGND sg13cmos5l_decap_8
XFILLER_51_456 VPWR VGND sg13cmos5l_decap_8
XFILLER_51_434 VPWR VGND sg13cmos5l_decap_8
XFILLER_24_648 VPWR VGND sg13cmos5l_fill_1
XFILLER_24_659 VPWR VGND sg13cmos5l_fill_1
X_08363_ _11267_/D fanout61/X _08372_/B _08362_/Y VPWR VGND sg13cmos5l_o21ai_1
X_07314_ _08690_/A _08895_/A _07326_/B VPWR VGND sg13cmos5l_nand2_1
X_08294_ _11233_/D fanout68/X _08293_/B _08293_/Y VPWR VGND sg13cmos5l_a21oi_1
X_07245_ _07245_/Y _10857_/Q _07205_/B _07249_/B1 _07197_/A VPWR VGND sg13cmos5l_a22oi_1
XFILLER_11_14 VPWR VGND sg13cmos5l_decap_8
X_07176_ _07176_/Y _08774_/A _11635_/Q _07185_/B hold2585/X _07182_/C1 VPWR VGND sg13cmos5l_a221oi_1
X_11058__867 _11058_/RESET_B VPWR VGND sg13cmos5l_tiehi
XFILLER_106_959 VPWR VGND sg13cmos5l_decap_8
X_06127_ _06127_/X input19/X _06127_/B VPWR VGND sg13cmos5l_and2_1
XFILLER_105_447 VPWR VGND sg13cmos5l_decap_8
X_06058_ _09884_/A _11372_/Q _06524_/C _10162_/A VPWR VGND sg13cmos5l_o21ai_1
Xfanout311 _08384_/A1 _08514_/A1 VPWR VGND sg13cmos5l_buf_1
Xfanout300 _07826_/B _07834_/B VPWR VGND sg13cmos5l_buf_1
Xfanout322 _07030_/B _07060_/A2 VPWR VGND sg13cmos5l_buf_1
Xfanout333 _10791_/B _06783_/Y VPWR VGND sg13cmos5l_buf_1
Xfanout355 _09858_/B2 fanout357/X VPWR VGND sg13cmos5l_buf_1
Xfanout344 _09395_/A _09693_/A1 VPWR VGND sg13cmos5l_buf_1
Xfanout366 _10131_/A2 _10092_/B1 VPWR VGND sg13cmos5l_buf_1
X_10923__1059 _10923_/RESET_B VPWR VGND sg13cmos5l_tiehi
XFILLER_98_1017 VPWR VGND sg13cmos5l_decap_8
X_09817_ _09817_/Y _09815_/Y _09816_/Y _10043_/C1 VPWR VGND sg13cmos5l_a21oi_1
XFILLER_87_898 VPWR VGND sg13cmos5l_decap_8
XFILLER_86_375 VPWR VGND sg13cmos5l_fill_1
XFILLER_74_504 VPWR VGND sg13cmos5l_decap_4
Xfanout377 _09996_/A _10051_/A VPWR VGND sg13cmos5l_buf_1
Xfanout388 _09574_/B1 _10017_/A VPWR VGND sg13cmos5l_buf_1
XFILLER_19_409 VPWR VGND sg13cmos5l_fill_2
Xfanout399 _09602_/C1 _06459_/Y VPWR VGND sg13cmos5l_buf_1
XFILLER_101_697 VPWR VGND sg13cmos5l_decap_4
XFILLER_98_1028 VPWR VGND sg13cmos5l_fill_1
XFILLER_46_239 VPWR VGND sg13cmos5l_decap_8
X_11289__1612 _11289_/RESET_B VPWR VGND sg13cmos5l_tiehi
XFILLER_27_420 VPWR VGND sg13cmos5l_decap_4
X_09748_ _09748_/X _09748_/A _09829_/B VPWR VGND sg13cmos5l_and2_1
XFILLER_100_196 VPWR VGND sg13cmos5l_decap_8
XFILLER_27_431 VPWR VGND sg13cmos5l_decap_8
X_09679_ _09679_/Y _11067_/Q _09981_/B VPWR VGND sg13cmos5l_nand2_1
X_11710_ _11710_/Q clkload21/A _11710_/D _11710_/RESET_B VPWR VGND sg13cmos5l_dfrbpq_1
XFILLER_42_401 VPWR VGND sg13cmos5l_decap_8
XFILLER_54_283 VPWR VGND sg13cmos5l_fill_1
XFILLER_43_968 VPWR VGND sg13cmos5l_decap_8
XFILLER_43_946 VPWR VGND sg13cmos5l_fill_1
XFILLER_14_114 VPWR VGND sg13cmos5l_fill_2
XFILLER_15_637 VPWR VGND sg13cmos5l_decap_4
X_11641_ _11641_/Q clkload23/A _11641_/D _11641_/RESET_B VPWR VGND sg13cmos5l_dfrbpq_1
XFILLER_30_607 VPWR VGND sg13cmos5l_decap_8
X_11572_ _11572_/Q clkload25/A _11572_/D _11572_/RESET_B VPWR VGND sg13cmos5l_dfrbpq_1
X_11212__1689 _11212_/RESET_B VPWR VGND sg13cmos5l_tiehi
Xinput19 input19/X uio_in[1] VPWR VGND sg13cmos5l_buf_1
X_10523_ _10524_/B _10523_/A _10523_/B VPWR VGND sg13cmos5l_xnor2_1
XFILLER_11_865 VPWR VGND sg13cmos5l_decap_8
XFILLER_7_847 VPWR VGND sg13cmos5l_decap_4
XFILLER_11_898 VPWR VGND sg13cmos5l_decap_8
X_10454_ _10460_/A _10454_/A _10454_/B _10454_/C VPWR VGND sg13cmos5l_nand3_1
X_10385_ _10385_/X _10385_/A _10453_/A VPWR VGND sg13cmos5l_xor2_1
XFILLER_105_981 VPWR VGND sg13cmos5l_decap_8
XFILLER_2_574 VPWR VGND sg13cmos5l_fill_1
XFILLER_96_128 VPWR VGND sg13cmos5l_decap_8
XFILLER_78_843 VPWR VGND sg13cmos5l_decap_4
XFILLER_77_331 VPWR VGND sg13cmos5l_decap_4
XFILLER_77_62 VPWR VGND sg13cmos5l_decap_8
XFILLER_28_8 VPWR VGND sg13cmos5l_decap_8
X_11006_ _11006_/Q clkload57/A _11006_/D _11006_/RESET_B VPWR VGND sg13cmos5l_dfrbpq_1
XFILLER_42_1027 VPWR VGND sg13cmos5l_fill_2
XFILLER_38_718 VPWR VGND sg13cmos5l_decap_8
XFILLER_93_846 VPWR VGND sg13cmos5l_fill_2
XFILLER_77_386 VPWR VGND sg13cmos5l_fill_2
XFILLER_37_228 VPWR VGND sg13cmos5l_fill_2
XFILLER_46_784 VPWR VGND sg13cmos5l_fill_2
XFILLER_45_250 VPWR VGND sg13cmos5l_decap_8
XFILLER_34_924 VPWR VGND sg13cmos5l_decap_8
XFILLER_60_231 VPWR VGND sg13cmos5l_decap_8
XFILLER_61_765 VPWR VGND sg13cmos5l_decap_4
XFILLER_33_467 VPWR VGND sg13cmos5l_decap_8
XFILLER_14_681 VPWR VGND sg13cmos5l_fill_1
XFILLER_13_180 VPWR VGND sg13cmos5l_fill_2
XFILLER_13_191 VPWR VGND sg13cmos5l_fill_1
X_11672__1292 _11672_/RESET_B VPWR VGND sg13cmos5l_tiehi
X_07030_ _07030_/Y _07030_/A _07030_/B VPWR VGND sg13cmos5l_nand2_1
X_11367__1534 _11367_/RESET_B VPWR VGND sg13cmos5l_tiehi
XFILLER_47_0 VPWR VGND sg13cmos5l_fill_2
Xhold2705 hold2705/X _11717_/Q VPWR VGND sg13cmos5l_dlygate4sd3_1
X_08981_ _08982_/A _11388_/Q _08981_/B VPWR VGND sg13cmos5l_xnor2_1
Xhold2727 hold2727/X _11558_/Q VPWR VGND sg13cmos5l_dlygate4sd3_1
Xhold2738 hold2738/X _11737_/Q VPWR VGND sg13cmos5l_dlygate4sd3_1
Xhold2716 hold2716/X _12766_/A VPWR VGND sg13cmos5l_dlygate4sd3_1
X_07932_ _07932_/Y _07932_/A _07946_/B VPWR VGND sg13cmos5l_nand2_1
XFILLER_69_898 VPWR VGND sg13cmos5l_fill_1
Xhold2749 hold2749/X _11720_/Q VPWR VGND sg13cmos5l_dlygate4sd3_1
X_07863_ _07863_/Y _07863_/A _07875_/B VPWR VGND sg13cmos5l_nor2_1
XFILLER_29_707 VPWR VGND sg13cmos5l_decap_8
XFILLER_29_729 VPWR VGND sg13cmos5l_fill_1
X_06814_ _06814_/Y _10728_/B _06879_/C VPWR VGND sg13cmos5l_nand2_1
XFILLER_68_386 VPWR VGND sg13cmos5l_fill_2
XFILLER_56_515 VPWR VGND sg13cmos5l_fill_2
X_09602_ _09603_/C _09598_/Y _09599_/Y _09600_/Y _09601_/Y _09602_/C1 VPWR VGND sg13cmos5l_a221oi_1
XFILLER_28_228 VPWR VGND sg13cmos5l_decap_8
X_07794_ _07794_/Y _07794_/A _07814_/B VPWR VGND sg13cmos5l_nand2_1
X_09533_ _09534_/B _09533_/A _09533_/B VPWR VGND sg13cmos5l_or2_1
XFILLER_52_710 VPWR VGND sg13cmos5l_fill_2
XFILLER_43_209 VPWR VGND sg13cmos5l_decap_8
X_06745_ _06745_/Y _06741_/A _06736_/Y _06307_/Y VPWR VGND sg13cmos5l_a21oi_1
XFILLER_36_294 VPWR VGND sg13cmos5l_decap_8
X_06676_ _10807_/D _06744_/A1 _06673_/Y _06675_/Y VPWR VGND sg13cmos5l_o21ai_1
X_09464_ _09464_/Y _09206_/C _09462_/Y _09463_/Y VPWR VGND sg13cmos5l_o21ai_1
X_08415_ _08415_/Y _08415_/A _08415_/B VPWR VGND sg13cmos5l_nor2_1
XFILLER_12_607 VPWR VGND sg13cmos5l_decap_4
X_09395_ _09401_/B _09395_/A _09395_/B VPWR VGND sg13cmos5l_nor2_1
X_08346_ _08346_/Y _08346_/A _08366_/B VPWR VGND sg13cmos5l_nand2_1
XFILLER_12_629 VPWR VGND sg13cmos5l_fill_2
X_08277_ _08277_/Y _08277_/A _08293_/B VPWR VGND sg13cmos5l_nor2_1
X_07228_ _07228_/Y _05978_/Y _07239_/A2 _07209_/Y _07227_/Y VPWR VGND sg13cmos5l_a22oi_1
XFILLER_98_28 VPWR VGND sg13cmos5l_decap_8
X_07159_ _07159_/Y hold2753/X _07160_/A2 _07163_/B1 VPWR VGND sg13cmos5l_o21ai_1
XFILLER_106_756 VPWR VGND sg13cmos5l_decap_8
XFILLER_105_266 VPWR VGND sg13cmos5l_decap_8
X_10170_ _11519_/D _10168_/Y _10169_/Y _08648_/A VPWR VGND sg13cmos5l_a21oi_1
Xfanout130 _08202_/B _08208_/B VPWR VGND sg13cmos5l_buf_1
XFILLER_102_962 VPWR VGND sg13cmos5l_decap_8
XFILLER_87_662 VPWR VGND sg13cmos5l_fill_1
Xfanout141 _07940_/B _07948_/B VPWR VGND sg13cmos5l_buf_1
Xfanout152 _08333_/A1 _07510_/Y VPWR VGND sg13cmos5l_buf_1
Xfanout174 _08529_/B _08543_/B VPWR VGND sg13cmos5l_buf_1
Xfanout163 _07371_/B _06955_/Y VPWR VGND sg13cmos5l_buf_1
Xfanout196 _08299_/B _08246_/Y VPWR VGND sg13cmos5l_buf_1
XFILLER_47_515 VPWR VGND sg13cmos5l_decap_8
Xfanout185 _08423_/B _08405_/B VPWR VGND sg13cmos5l_buf_1
XFILLER_90_805 VPWR VGND sg13cmos5l_fill_2
XFILLER_34_209 VPWR VGND sg13cmos5l_fill_2
X_11463__1346 _11463_/RESET_B VPWR VGND sg13cmos5l_tiehi
X_11624_ _11624_/Q clkload27/A _11624_/D _11624_/RESET_B VPWR VGND sg13cmos5l_dfrbpq_1
XFILLER_70_584 VPWR VGND sg13cmos5l_fill_2
XFILLER_42_286 VPWR VGND sg13cmos5l_decap_8
XFILLER_30_459 VPWR VGND sg13cmos5l_fill_2
X_11555_ _11555_/Q clkload21/A _11555_/D _11555_/RESET_B VPWR VGND sg13cmos5l_dfrbpq_1
XFILLER_10_150 VPWR VGND sg13cmos5l_decap_8
XFILLER_8_59 VPWR VGND sg13cmos5l_decap_8
X_11486_ _11486_/Q clkload45/A _11486_/D _11486_/RESET_B VPWR VGND sg13cmos5l_dfrbpq_1
X_10506_ _10507_/C _10525_/A _10506_/B _10506_/C VPWR VGND sg13cmos5l_nand3_1
XFILLER_10_172 VPWR VGND sg13cmos5l_decap_8
XFILLER_6_176 VPWR VGND sg13cmos5l_fill_2
X_10437_ _10437_/X _10437_/A _10437_/B _10437_/C _10437_/D VPWR VGND sg13cmos5l_and4_1
X_10368_ _10386_/C _10479_/C _10462_/A _09696_/A _10434_/B VPWR VGND sg13cmos5l_a22oi_1
X_10299_ _10300_/B _10296_/B _10296_/C _11474_/Q VPWR VGND sg13cmos5l_a21oi_1
XFILLER_66_824 VPWR VGND sg13cmos5l_fill_1
XFILLER_92_120 VPWR VGND sg13cmos5l_fill_2
XFILLER_65_356 VPWR VGND sg13cmos5l_decap_4
XFILLER_80_315 VPWR VGND sg13cmos5l_fill_2
XFILLER_80_304 VPWR VGND sg13cmos5l_fill_2
XFILLER_65_378 VPWR VGND sg13cmos5l_fill_2
XFILLER_25_209 VPWR VGND sg13cmos5l_fill_2
X_11048__877 _11048_/RESET_B VPWR VGND sg13cmos5l_tiehi
XFILLER_80_359 VPWR VGND sg13cmos5l_fill_2
XFILLER_80_348 VPWR VGND sg13cmos5l_decap_8
X_06530_ _06530_/Y _06530_/A _06530_/B VPWR VGND sg13cmos5l_nand2_1
X_06461_ _06461_/Y _10924_/Q _09529_/B VPWR VGND sg13cmos5l_nand2_1
X_08200_ _08200_/Y _08200_/A _08202_/B VPWR VGND sg13cmos5l_nand2_1
X_06392_ _06392_/Y _06407_/B _06392_/B VPWR VGND sg13cmos5l_nor2_1
X_09180_ _09180_/Y _09180_/A _10832_/Q VPWR VGND sg13cmos5l_nor2_1
X_08131_ _08131_/Y _08131_/A _08153_/B VPWR VGND sg13cmos5l_nor2_1
X_08062_ _08062_/Y _08062_/A _08076_/B VPWR VGND sg13cmos5l_nand2_1
X_07013_ _07013_/Y _11504_/Q _07024_/B _07012_/Y VPWR VGND sg13cmos5l_a21oi_1
XFILLER_102_203 VPWR VGND sg13cmos5l_decap_8
Xhold2513 hold2513/X _11583_/Q VPWR VGND sg13cmos5l_dlygate4sd3_1
Xhold2502 _11581_/D _10765_/X VPWR VGND sg13cmos5l_dlygate4sd3_1
X_08964_ _08964_/Y _08941_/A _08964_/B _08964_/C VPWR VGND sg13cmos5l_nand3b_1
X_07915_ _07915_/Y _07915_/A _07917_/B VPWR VGND sg13cmos5l_nor2_1
Xhold2546 _06826_/A _11609_/Q VPWR VGND sg13cmos5l_dlygate4sd3_1
XFILLER_69_651 VPWR VGND sg13cmos5l_fill_2
XFILLER_57_802 VPWR VGND sg13cmos5l_fill_2
Xhold2524 _11673_/D _07045_/X VPWR VGND sg13cmos5l_dlygate4sd3_1
Xhold2535 _07383_/A _10881_/Q VPWR VGND sg13cmos5l_dlygate4sd3_1
Xhold2579 _06821_/A _11607_/Q VPWR VGND sg13cmos5l_dlygate4sd3_1
Xhold1845 _07846_/A _11015_/Q VPWR VGND sg13cmos5l_dlygate4sd3_1
Xhold2568 _06863_/A _11622_/Q VPWR VGND sg13cmos5l_dlygate4sd3_1
Xhold2557 hold2557/X _11577_/Q VPWR VGND sg13cmos5l_dlygate4sd3_1
Xhold1834 _08500_/A _11335_/Q VPWR VGND sg13cmos5l_dlygate4sd3_1
XFILLER_57_846 VPWR VGND sg13cmos5l_decap_8
XFILLER_56_323 VPWR VGND sg13cmos5l_decap_8
X_08895_ _08895_/Y _08895_/A _08895_/B VPWR VGND sg13cmos5l_nand2_1
Xhold1867 _08242_/A _11208_/Q VPWR VGND sg13cmos5l_dlygate4sd3_1
Xhold1856 _10782_/A _11591_/Q VPWR VGND sg13cmos5l_dlygate4sd3_1
X_07846_ _07846_/Y _07846_/A _07846_/B VPWR VGND sg13cmos5l_nand2_1
XFILLER_83_142 VPWR VGND sg13cmos5l_decap_8
Xhold1878 _08192_/A _11183_/Q VPWR VGND sg13cmos5l_dlygate4sd3_1
XFILLER_84_676 VPWR VGND sg13cmos5l_decap_4
XFILLER_72_838 VPWR VGND sg13cmos5l_decap_8
XFILLER_71_304 VPWR VGND sg13cmos5l_decap_4
XFILLER_56_389 VPWR VGND sg13cmos5l_fill_1
X_07777_ _10981_/D fanout57/X _07778_/B _07776_/Y VPWR VGND sg13cmos5l_a21oi_1
Xhold1889 _08924_/A _11437_/Q VPWR VGND sg13cmos5l_dlygate4sd3_1
X_11720__1240 _11720_/RESET_B VPWR VGND sg13cmos5l_tiehi
X_09516_ _09516_/Y _10997_/Q _09630_/B VPWR VGND sg13cmos5l_nand2_1
X_06728_ _06728_/Y _06739_/A _06728_/B VPWR VGND sg13cmos5l_nand2_1
X_09447_ _09447_/X _11250_/Q _11218_/Q _11186_/Q _11154_/Q _09551_/S0 _09551_/S1 VPWR
+ VGND sg13cmos5l_mux4_1
XFILLER_24_253 VPWR VGND sg13cmos5l_fill_2
XFILLER_40_713 VPWR VGND sg13cmos5l_fill_2
X_06659_ _06659_/Y _06164_/A _06400_/B _06400_/D _06657_/A _06658_/Y VPWR VGND sg13cmos5l_a221oi_1
XFILLER_33_34 VPWR VGND sg13cmos5l_fill_2
X_09378_ _09379_/C _09378_/A _09456_/B VPWR VGND sg13cmos5l_nand2_1
X_11093__1808 _11093_/RESET_B VPWR VGND sg13cmos5l_tiehi
X_08329_ _11250_/D _08329_/A1 _08332_/B _08328_/Y VPWR VGND sg13cmos5l_o21ai_1
X_11340_ _11340_/Q clkload39/A _11340_/D _11340_/RESET_B VPWR VGND sg13cmos5l_dfrbpq_1
X_11271_ _11271_/Q _11364_/CLK _11271_/D _11271_/RESET_B VPWR VGND sg13cmos5l_dfrbpq_1
XFILLER_4_658 VPWR VGND sg13cmos5l_fill_1
XFILLER_4_636 VPWR VGND sg13cmos5l_decap_8
XFILLER_106_553 VPWR VGND sg13cmos5l_decap_8
X_10222_ _10232_/B _10222_/A _10222_/B _10222_/C VPWR VGND sg13cmos5l_nor3_1
X_10153_ _10153_/Y _05935_/A _09157_/B _10158_/A2 VPWR VGND sg13cmos5l_o21ai_1
XFILLER_58_20 VPWR VGND sg13cmos5l_fill_2
XFILLER_0_831 VPWR VGND sg13cmos5l_decap_8
XFILLER_94_407 VPWR VGND sg13cmos5l_fill_1
XFILLER_88_960 VPWR VGND sg13cmos5l_decap_8
XFILLER_66_109 VPWR VGND sg13cmos5l_decap_8
XFILLER_58_97 VPWR VGND sg13cmos5l_decap_4
XFILLER_48_846 VPWR VGND sg13cmos5l_decap_8
X_10084_ _10084_/Y _10356_/A1 _09477_/Y _10083_/Y VPWR VGND sg13cmos5l_a21oi_1
XFILLER_74_120 VPWR VGND sg13cmos5l_fill_2
XFILLER_47_356 VPWR VGND sg13cmos5l_decap_4
XFILLER_75_676 VPWR VGND sg13cmos5l_decap_8
XFILLER_74_153 VPWR VGND sg13cmos5l_fill_1
XFILLER_74_30 VPWR VGND sg13cmos5l_decap_8
X_10986_ _10986_/Q clkload32/A _10986_/D _10986_/RESET_B VPWR VGND sg13cmos5l_dfrbpq_1
XFILLER_15_242 VPWR VGND sg13cmos5l_fill_2
XFILLER_16_798 VPWR VGND sg13cmos5l_decap_8
XFILLER_31_713 VPWR VGND sg13cmos5l_fill_1
XFILLER_88_7 VPWR VGND sg13cmos5l_decap_8
X_11607_ _11607_/Q _11646_/CLK _11607_/D _11607_/RESET_B VPWR VGND sg13cmos5l_dfrbpq_1
XFILLER_8_931 VPWR VGND sg13cmos5l_decap_8
XFILLER_11_481 VPWR VGND sg13cmos5l_fill_1
XFILLER_7_452 VPWR VGND sg13cmos5l_fill_1
X_11538_ _11538_/Q clkload37/A _11538_/D _11538_/RESET_B VPWR VGND sg13cmos5l_dfrbpq_1
XFILLER_99_60 VPWR VGND sg13cmos5l_decap_8
X_11469_ _11469_/Q clkload35/A _11469_/D _11469_/RESET_B VPWR VGND sg13cmos5l_dfrbpq_1
XFILLER_79_971 VPWR VGND sg13cmos5l_fill_2
XFILLER_100_729 VPWR VGND sg13cmos5l_decap_8
X_07700_ _07700_/Y _07700_/A _07704_/B VPWR VGND sg13cmos5l_nor2_1
XFILLER_79_982 VPWR VGND sg13cmos5l_fill_1
XFILLER_39_813 VPWR VGND sg13cmos5l_fill_2
XFILLER_38_301 VPWR VGND sg13cmos5l_fill_2
X_05961_ _10331_/B _10838_/Q VPWR VGND sg13cmos5l_inv_1
XFILLER_93_440 VPWR VGND sg13cmos5l_fill_2
X_05892_ _05892_/Y _05892_/A VPWR VGND sg13cmos5l_inv_1
XFILLER_66_654 VPWR VGND sg13cmos5l_decap_8
X_08680_ _08681_/A hold2711/X _08846_/B _08876_/A _08856_/B1 VPWR VGND sg13cmos5l_a22oi_1
XFILLER_94_996 VPWR VGND sg13cmos5l_decap_8
XFILLER_94_985 VPWR VGND sg13cmos5l_decap_4
X_07631_ _07631_/Y _10653_/A _07643_/D _07650_/A VPWR VGND sg13cmos5l_o21ai_1
XFILLER_66_676 VPWR VGND sg13cmos5l_decap_8
XFILLER_81_657 VPWR VGND sg13cmos5l_decap_8
XFILLER_80_101 VPWR VGND sg13cmos5l_fill_2
XFILLER_65_197 VPWR VGND sg13cmos5l_fill_2
X_07562_ _07575_/C _11410_/Q _11409_/Q _11408_/Q _07562_/D VPWR VGND sg13cmos5l_and4_1
XFILLER_0_1013 VPWR VGND sg13cmos5l_decap_8
XFILLER_81_668 VPWR VGND sg13cmos5l_fill_1
XFILLER_80_145 VPWR VGND sg13cmos5l_fill_2
X_09301_ _09302_/B _09856_/A _09940_/A _09301_/S VPWR VGND sg13cmos5l_mux2_1
XFILLER_0_93 VPWR VGND sg13cmos5l_fill_1
X_06513_ _06513_/Y _10894_/Q _09544_/S _09553_/B1 VPWR VGND sg13cmos5l_a21oi_1
XFILLER_80_178 VPWR VGND sg13cmos5l_fill_2
XFILLER_55_1026 VPWR VGND sg13cmos5l_fill_2
XFILLER_22_713 VPWR VGND sg13cmos5l_fill_2
XFILLER_22_735 VPWR VGND sg13cmos5l_decap_8
X_07493_ _07493_/Y _07493_/A _07493_/B VPWR VGND sg13cmos5l_nor2_1
X_06444_ _06446_/A _06444_/A _09270_/A _06444_/C VPWR VGND sg13cmos5l_nand3_1
X_09232_ _09704_/A _10295_/A _10847_/Q VPWR VGND sg13cmos5l_xnor2_1
XFILLER_22_746 VPWR VGND sg13cmos5l_fill_1
X_09163_ _09166_/C _10424_/A _10850_/Q VPWR VGND sg13cmos5l_nor2_1
X_06375_ _06376_/A _06233_/X _10329_/A _06234_/A VPWR VGND sg13cmos5l_a21oi_1
X_08114_ _08311_/B _08376_/A _08376_/B VPWR VGND sg13cmos5l_nor2b_1
X_09094_ _09094_/X _09109_/A _09102_/B VPWR VGND sg13cmos5l_and2_1
X_08045_ _08045_/Y _08045_/A _08047_/B VPWR VGND sg13cmos5l_nor2_1
XFILLER_88_212 VPWR VGND sg13cmos5l_fill_2
XFILLER_0_127 VPWR VGND sg13cmos5l_fill_2
Xhold2310 _11599_/D _06799_/Y VPWR VGND sg13cmos5l_dlygate4sd3_1
XFILLER_89_768 VPWR VGND sg13cmos5l_decap_8
Xhold2321 _08425_/A _11298_/Q VPWR VGND sg13cmos5l_dlygate4sd3_1
X_09996_ _10002_/B _09996_/A _09996_/B VPWR VGND sg13cmos5l_nor2_1
XFILLER_0_138 VPWR VGND sg13cmos5l_fill_1
Xhold2343 _07714_/A _10951_/Q VPWR VGND sg13cmos5l_dlygate4sd3_1
Xhold2354 _08165_/A _11170_/Q VPWR VGND sg13cmos5l_dlygate4sd3_1
X_08947_ _11438_/D _08945_/Y _08946_/Y _08936_/Y VPWR VGND sg13cmos5l_o21ai_1
Xhold2332 _08251_/A _11212_/Q VPWR VGND sg13cmos5l_dlygate4sd3_1
XFILLER_29_312 VPWR VGND sg13cmos5l_fill_2
Xhold2387 _07724_/A _10955_/Q VPWR VGND sg13cmos5l_dlygate4sd3_1
XFILLER_85_941 VPWR VGND sg13cmos5l_decap_8
X_08878_ _08878_/Y _08867_/A _08877_/X _08880_/A1 VPWR VGND sg13cmos5l_o21ai_1
Xhold2365 _07503_/A _10899_/Q VPWR VGND sg13cmos5l_dlygate4sd3_1
Xhold2398 _07728_/A _10957_/Q VPWR VGND sg13cmos5l_dlygate4sd3_1
Xhold2376 _08283_/A _11228_/Q VPWR VGND sg13cmos5l_dlygate4sd3_1
X_11147__1754 _11147_/RESET_B VPWR VGND sg13cmos5l_tiehi
X_07829_ _11006_/D fanout77/X _07850_/B _07828_/Y VPWR VGND sg13cmos5l_o21ai_1
XFILLER_72_657 VPWR VGND sg13cmos5l_decap_4
XFILLER_72_624 VPWR VGND sg13cmos5l_decap_4
XFILLER_71_123 VPWR VGND sg13cmos5l_fill_1
XFILLER_56_175 VPWR VGND sg13cmos5l_fill_1
X_10840_ _10840_/Q clkload20/A _10840_/D _10840_/RESET_B VPWR VGND sg13cmos5l_dfrbpq_1
XFILLER_60_808 VPWR VGND sg13cmos5l_fill_2
X_10771_ _10771_/Y _10771_/A _10771_/B VPWR VGND sg13cmos5l_nand2_1
XFILLER_71_189 VPWR VGND sg13cmos5l_fill_2
XFILLER_52_392 VPWR VGND sg13cmos5l_decap_8
XFILLER_44_99 VPWR VGND sg13cmos5l_fill_2
XFILLER_40_576 VPWR VGND sg13cmos5l_decap_8
XFILLER_9_728 VPWR VGND sg13cmos5l_decap_4
XFILLER_60_32 VPWR VGND sg13cmos5l_decap_8
XFILLER_8_238 VPWR VGND sg13cmos5l_fill_2
X_11323_ _11323_/Q clkload55/A _11323_/D _11323_/RESET_B VPWR VGND sg13cmos5l_dfrbpq_1
XFILLER_5_956 VPWR VGND sg13cmos5l_fill_1
Xclkbuf_4_0_0_clk clkbuf_4_0_0_clk/X clkbuf_0_clk/X VPWR VGND sg13cmos5l_buf_8
XFILLER_106_350 VPWR VGND sg13cmos5l_decap_8
X_11038__887 _11038_/RESET_B VPWR VGND sg13cmos5l_tiehi
X_11254_ _11254_/Q clkload8/A _11254_/D _11254_/RESET_B VPWR VGND sg13cmos5l_dfrbpq_1
XFILLER_79_223 VPWR VGND sg13cmos5l_fill_2
X_10205_ _10205_/Y _09376_/A _06085_/A _10202_/Y _10204_/Y VPWR VGND sg13cmos5l_a22oi_1
XFILLER_68_908 VPWR VGND sg13cmos5l_decap_4
X_11185_ _11185_/Q clkload35/A _11185_/D _11185_/RESET_B VPWR VGND sg13cmos5l_dfrbpq_1
X_10136_ _10136_/Y _09908_/B _09908_/C _05935_/A VPWR VGND sg13cmos5l_o21ai_1
XFILLER_79_278 VPWR VGND sg13cmos5l_decap_4
XFILLER_0_650 VPWR VGND sg13cmos5l_decap_8
XFILLER_76_963 VPWR VGND sg13cmos5l_decap_8
X_10067_ _10067_/Y _06523_/A hold2886/X _10088_/A2 VPWR VGND sg13cmos5l_a21oi_1
XFILLER_85_84 VPWR VGND sg13cmos5l_fill_1
XFILLER_63_613 VPWR VGND sg13cmos5l_decap_8
XFILLER_48_687 VPWR VGND sg13cmos5l_fill_2
XFILLER_47_142 VPWR VGND sg13cmos5l_fill_1
XFILLER_36_805 VPWR VGND sg13cmos5l_decap_4
XFILLER_75_495 VPWR VGND sg13cmos5l_decap_4
XFILLER_63_624 VPWR VGND sg13cmos5l_fill_2
XFILLER_48_698 VPWR VGND sg13cmos5l_fill_1
XFILLER_47_197 VPWR VGND sg13cmos5l_decap_8
XFILLER_63_679 VPWR VGND sg13cmos5l_decap_8
XFILLER_62_189 VPWR VGND sg13cmos5l_fill_2
X_10936__1046 _10936_/RESET_B VPWR VGND sg13cmos5l_tiehi
X_10969_ _10969_/Q clkload41/A _10969_/D _10969_/RESET_B VPWR VGND sg13cmos5l_dfrbpq_1
XFILLER_15_1021 VPWR VGND sg13cmos5l_decap_8
XFILLER_31_576 VPWR VGND sg13cmos5l_decap_8
XFILLER_8_772 VPWR VGND sg13cmos5l_fill_1
XFILLER_8_761 VPWR VGND sg13cmos5l_decap_8
X_06160_ _06179_/A _06160_/A _06685_/A _06664_/A _06673_/A VPWR VGND sg13cmos5l_nor4_1
X_06091_ _11391_/D _06091_/A _10703_/B VPWR VGND sg13cmos5l_and2_1
X_11225__1676 _11225_/RESET_B VPWR VGND sg13cmos5l_tiehi
Xfanout718 _08376_/B _11563_/Q VPWR VGND sg13cmos5l_buf_1
Xfanout707 _08889_/A _08916_/B1 VPWR VGND sg13cmos5l_buf_1
Xfanout729 _10436_/B2 _10250_/B VPWR VGND sg13cmos5l_buf_1
X_09850_ _09850_/Y _11297_/Q _09850_/A2 _09849_/Y VPWR VGND sg13cmos5l_o21ai_1
XFILLER_105_28 VPWR VGND sg13cmos5l_decap_8
XFILLER_100_515 VPWR VGND sg13cmos5l_fill_2
X_08801_ _08801_/Y _08801_/A _08811_/B VPWR VGND sg13cmos5l_nand2_1
X_09781_ _11476_/D _10423_/A _09807_/A _09780_/Y VPWR VGND sg13cmos5l_a21oi_1
X_11432__1426 _11432_/RESET_B VPWR VGND sg13cmos5l_tiehi
X_06993_ _06993_/X hold2517/X _07062_/S _06992_/Y VPWR VGND sg13cmos5l_a21o_1
X_11483__1217 _11483_/RESET_B VPWR VGND sg13cmos5l_tiehi
X_05944_ _05944_/Y _05944_/A VPWR VGND sg13cmos5l_inv_1
X_08732_ _08733_/A hold2741/X _09004_/B _09036_/B _09013_/B1 VPWR VGND sg13cmos5l_a22oi_1
XFILLER_67_974 VPWR VGND sg13cmos5l_decap_8
XFILLER_66_462 VPWR VGND sg13cmos5l_fill_2
X_08663_ _11396_/D _08663_/A VPWR VGND sg13cmos5l_inv_1
XFILLER_26_304 VPWR VGND sg13cmos5l_fill_1
XFILLER_93_292 VPWR VGND sg13cmos5l_fill_1
X_05875_ _05875_/Y input7/X VPWR VGND sg13cmos5l_inv_1
XFILLER_54_646 VPWR VGND sg13cmos5l_decap_8
XFILLER_38_197 VPWR VGND sg13cmos5l_fill_2
X_08594_ _08594_/Y _10955_/Q _08588_/B _08599_/S1 VPWR VGND sg13cmos5l_a21oi_1
X_07614_ _10915_/D _07648_/B fanout61/X _07613_/Y VPWR VGND sg13cmos5l_a21oi_1
XFILLER_81_454 VPWR VGND sg13cmos5l_fill_1
XFILLER_42_808 VPWR VGND sg13cmos5l_decap_8
XFILLER_41_329 VPWR VGND sg13cmos5l_fill_1
X_07545_ _07545_/Y _07545_/A _07595_/B VPWR VGND sg13cmos5l_nor2_1
XFILLER_50_830 VPWR VGND sg13cmos5l_fill_1
X_07476_ _10895_/D _07537_/B _08518_/A1 _07475_/Y VPWR VGND sg13cmos5l_a21oi_1
X_06427_ _10823_/D _06759_/A1 _06424_/Y _06426_/Y VPWR VGND sg13cmos5l_o21ai_1
XFILLER_50_896 VPWR VGND sg13cmos5l_decap_8
XFILLER_22_576 VPWR VGND sg13cmos5l_decap_8
X_09215_ _09565_/B _09542_/B _09215_/B VPWR VGND sg13cmos5l_nand2b_1
X_11644__1321 _11644_/RESET_B VPWR VGND sg13cmos5l_tiehi
X_09146_ _11453_/D _09143_/Y _09144_/Y _09145_/Y VPWR VGND sg13cmos5l_o21ai_1
X_06358_ _06358_/X _06358_/A _06358_/B VPWR VGND sg13cmos5l_or2_1
X_09077_ _09097_/A _09109_/A _09077_/B VPWR VGND sg13cmos5l_xnor2_1
X_06289_ _06292_/A _11500_/Q _06289_/B VPWR VGND sg13cmos5l_nor2_1
XFILLER_30_46 VPWR VGND sg13cmos5l_fill_2
X_08028_ _11103_/D fanout75/X _08033_/B _08027_/Y VPWR VGND sg13cmos5l_a21oi_1
XFILLER_2_915 VPWR VGND sg13cmos5l_fill_1
XFILLER_2_948 VPWR VGND sg13cmos5l_decap_8
XFILLER_104_887 VPWR VGND sg13cmos5l_decap_8
XFILLER_103_386 VPWR VGND sg13cmos5l_fill_1
X_09979_ _09979_/Y _11014_/Q _09981_/B VPWR VGND sg13cmos5l_nand2_1
Xhold2151 _11593_/D _10788_/Y VPWR VGND sg13cmos5l_dlygate4sd3_1
Xhold2162 _08287_/A _11230_/Q VPWR VGND sg13cmos5l_dlygate4sd3_1
Xhold2173 _08267_/A _11220_/Q VPWR VGND sg13cmos5l_dlygate4sd3_1
Xhold2140 _08545_/A _11357_/Q VPWR VGND sg13cmos5l_dlygate4sd3_1
Xhold2195 _08569_/A _11369_/Q VPWR VGND sg13cmos5l_dlygate4sd3_1
XFILLER_73_900 VPWR VGND sg13cmos5l_fill_1
Xhold2184 _08039_/A _11109_/Q VPWR VGND sg13cmos5l_dlygate4sd3_1
XFILLER_18_849 VPWR VGND sg13cmos5l_fill_1
XFILLER_73_988 VPWR VGND sg13cmos5l_decap_4
XFILLER_45_679 VPWR VGND sg13cmos5l_decap_4
X_10823_ _10823_/Q clkload46/A _10823_/D _10823_/RESET_B VPWR VGND sg13cmos5l_dfrbpq_1
X_11303__1598 _11303_/RESET_B VPWR VGND sg13cmos5l_tiehi
XFILLER_53_690 VPWR VGND sg13cmos5l_fill_2
XFILLER_13_521 VPWR VGND sg13cmos5l_fill_1
XFILLER_25_392 VPWR VGND sg13cmos5l_fill_1
X_10754_ _11572_/D hold2560/X _06141_/B _10760_/S VPWR VGND sg13cmos5l_mux2_1
XFILLER_40_340 VPWR VGND sg13cmos5l_fill_1
XFILLER_13_554 VPWR VGND sg13cmos5l_decap_8
X_10685_ _10685_/Y _10685_/A _10685_/B _10685_/C VPWR VGND sg13cmos5l_nor3_1
X_11306_ _11306_/Q clkload32/A _11306_/D _11306_/RESET_B VPWR VGND sg13cmos5l_dfrbpq_1
XFILLER_5_742 VPWR VGND sg13cmos5l_decap_4
XFILLER_5_797 VPWR VGND sg13cmos5l_decap_8
X_11237_ _11237_/Q clkload53/A _11237_/D _11237_/RESET_B VPWR VGND sg13cmos5l_dfrbpq_1
XFILLER_95_502 VPWR VGND sg13cmos5l_decap_8
X_11168_ _11168_/Q clkload56/A _11168_/D _11168_/RESET_B VPWR VGND sg13cmos5l_dfrbpq_1
XFILLER_68_716 VPWR VGND sg13cmos5l_fill_2
XFILLER_1_981 VPWR VGND sg13cmos5l_decap_8
XFILLER_95_535 VPWR VGND sg13cmos5l_decap_4
X_10119_ _11507_/D _10117_/Y _10118_/Y _10116_/Y VPWR VGND sg13cmos5l_o21ai_1
XFILLER_83_719 VPWR VGND sg13cmos5l_decap_4
X_11099_ _11099_/Q clkload54/A _11099_/D _11099_/RESET_B VPWR VGND sg13cmos5l_dfrbpq_1
XFILLER_82_218 VPWR VGND sg13cmos5l_decap_4
XFILLER_35_112 VPWR VGND sg13cmos5l_fill_1
XFILLER_36_657 VPWR VGND sg13cmos5l_fill_2
X_11754__915 _11754_/RESET_B VPWR VGND sg13cmos5l_tiehi
XFILLER_17_871 VPWR VGND sg13cmos5l_decap_4
XFILLER_44_690 VPWR VGND sg13cmos5l_fill_1
X_07330_ _07330_/Y _07359_/B _07328_/Y _07329_/Y VPWR VGND sg13cmos5l_a21oi_1
XFILLER_31_340 VPWR VGND sg13cmos5l_decap_4
XFILLER_31_351 VPWR VGND sg13cmos5l_decap_4
X_09000_ _09000_/Y _09036_/D _08999_/Y _09030_/A1 VPWR VGND sg13cmos5l_o21ai_1
X_07261_ _07261_/Y _07259_/Y _07260_/Y _07262_/A2 VPWR VGND sg13cmos5l_a21oi_1
XFILLER_31_395 VPWR VGND sg13cmos5l_decap_8
X_07192_ _07192_/Y _07192_/A _07192_/B VPWR VGND sg13cmos5l_nand2_1
X_06212_ _06752_/A _10268_/A _10433_/A VPWR VGND sg13cmos5l_or2_1
X_06143_ _06144_/B _11596_/Q _10827_/Q _10828_/Q VPWR VGND sg13cmos5l_nor3_1
XFILLER_105_607 VPWR VGND sg13cmos5l_decap_8
X_06074_ _10695_/B _06092_/A _06092_/D VPWR VGND sg13cmos5l_nor2_1
X_09902_ _09908_/B _09902_/A _09902_/B VPWR VGND sg13cmos5l_nor2_1
Xfanout515 _09155_/B _08772_/A2 VPWR VGND sg13cmos5l_buf_1
Xfanout504 _09336_/B _09885_/B VPWR VGND sg13cmos5l_buf_1
X_09833_ _09834_/B hold2825/X _09911_/B _09832_/Y VPWR VGND sg13cmos5l_a21oi_1
Xfanout548 _10165_/B _10441_/B1 VPWR VGND sg13cmos5l_buf_1
Xfanout537 _08671_/S _08694_/A VPWR VGND sg13cmos5l_buf_1
Xfanout526 _07591_/A _07448_/A VPWR VGND sg13cmos5l_buf_1
XFILLER_100_323 VPWR VGND sg13cmos5l_decap_8
XFILLER_86_557 VPWR VGND sg13cmos5l_decap_4
Xfanout559 _07429_/B1 _07430_/A2 VPWR VGND sg13cmos5l_buf_1
XFILLER_59_749 VPWR VGND sg13cmos5l_fill_1
XFILLER_58_248 VPWR VGND sg13cmos5l_decap_8
X_09764_ _09764_/Y _11038_/Q _09870_/B _09987_/B1 VPWR VGND sg13cmos5l_a21oi_1
X_06976_ _06976_/Y _06974_/Y _06975_/Y _07050_/B1 VPWR VGND sg13cmos5l_a21oi_1
X_08715_ _11409_/D _08715_/A VPWR VGND sg13cmos5l_inv_1
X_05927_ _07020_/A _06203_/A VPWR VGND sg13cmos5l_inv_1
XFILLER_27_613 VPWR VGND sg13cmos5l_decap_4
X_09695_ _09695_/Y _10424_/A _09480_/B _09775_/A VPWR VGND sg13cmos5l_o21ai_1
X_05858_ _05858_/Y _10747_/A VPWR VGND sg13cmos5l_inv_1
X_08646_ _10749_/A _08646_/A _10751_/A VPWR VGND sg13cmos5l_and2_1
XFILLER_82_752 VPWR VGND sg13cmos5l_decap_4
XFILLER_26_134 VPWR VGND sg13cmos5l_decap_8
XFILLER_55_999 VPWR VGND sg13cmos5l_decap_8
XFILLER_25_35 VPWR VGND sg13cmos5l_decap_4
X_08577_ _08584_/A _08572_/Y _08574_/Y _08576_/Y VPWR VGND sg13cmos5l_a21oi_1
X_11028__897 _11028_/RESET_B VPWR VGND sg13cmos5l_tiehi
XFILLER_22_340 VPWR VGND sg13cmos5l_decap_8
X_07528_ _07528_/Y _11405_/Q _07542_/D VPWR VGND sg13cmos5l_nand2_1
XFILLER_50_682 VPWR VGND sg13cmos5l_fill_1
X_07459_ _07459_/Y _10191_/A _07472_/D _07452_/B VPWR VGND sg13cmos5l_a21oi_1
XFILLER_23_896 VPWR VGND sg13cmos5l_fill_1
X_10470_ _10470_/X _10470_/A _10548_/B VPWR VGND sg13cmos5l_and2_1
X_09129_ _09129_/Y _09124_/Y _09128_/Y _09061_/A VPWR VGND sg13cmos5l_a21oi_1
XFILLER_41_89 VPWR VGND sg13cmos5l_fill_1
X_11074__851 _11074_/RESET_B VPWR VGND sg13cmos5l_tiehi
XFILLER_89_340 VPWR VGND sg13cmos5l_fill_2
XFILLER_1_222 VPWR VGND sg13cmos5l_fill_2
Xheichips26_RiMaX_1821 uio_oe[6] VPWR VGND sg13cmos5l_tiehi
X_11022_ _11022_/Q clkload34/A _11022_/D _11022_/RESET_B VPWR VGND sg13cmos5l_dfrbpq_1
XFILLER_103_161 VPWR VGND sg13cmos5l_decap_8
XFILLER_77_557 VPWR VGND sg13cmos5l_fill_2
XFILLER_2_28 VPWR VGND sg13cmos5l_decap_8
XFILLER_66_53 VPWR VGND sg13cmos5l_fill_1
XFILLER_58_771 VPWR VGND sg13cmos5l_fill_1
XFILLER_85_590 VPWR VGND sg13cmos5l_decap_8
XFILLER_46_922 VPWR VGND sg13cmos5l_decap_8
XFILLER_45_443 VPWR VGND sg13cmos5l_decap_8
X_11081__844 _11081_/RESET_B VPWR VGND sg13cmos5l_tiehi
XFILLER_46_999 VPWR VGND sg13cmos5l_fill_2
XFILLER_33_616 VPWR VGND sg13cmos5l_decap_4
XFILLER_82_74 VPWR VGND sg13cmos5l_decap_8
XFILLER_61_969 VPWR VGND sg13cmos5l_fill_1
XFILLER_9_300 VPWR VGND sg13cmos5l_fill_1
X_10806_ _10806_/Q clkload16/A _10806_/D _10806_/RESET_B VPWR VGND sg13cmos5l_dfrbpq_1
X_10737_ _11563_/D _10739_/A _10737_/B VPWR VGND sg13cmos5l_nor2_1
XFILLER_13_373 VPWR VGND sg13cmos5l_fill_2
XFILLER_13_384 VPWR VGND sg13cmos5l_decap_4
XFILLER_40_192 VPWR VGND sg13cmos5l_decap_4
X_10668_ _10668_/Y _10668_/A _10859_/Q VPWR VGND sg13cmos5l_xnor2_1
X_10599_ _10599_/Y _10622_/A _10622_/B _10644_/B1 VPWR VGND sg13cmos5l_a21oi_1
X_10886__1096 _10886_/RESET_B VPWR VGND sg13cmos5l_tiehi
XFILLER_99_137 VPWR VGND sg13cmos5l_decap_8
XFILLER_5_594 VPWR VGND sg13cmos5l_decap_8
XFILLER_96_800 VPWR VGND sg13cmos5l_fill_1
Xhold2909 _06251_/A _11515_/Q VPWR VGND sg13cmos5l_dlygate4sd3_1
X_06830_ _06839_/D _11709_/Q _11710_/Q _11711_/Q _11712_/Q VPWR VGND sg13cmos5l_or4_1
XFILLER_83_549 VPWR VGND sg13cmos5l_decap_4
X_06761_ _06761_/Y _06761_/A _06761_/B VPWR VGND sg13cmos5l_xnor2_1
X_08500_ _08500_/Y _08500_/A _08500_/B VPWR VGND sg13cmos5l_nand2_1
XFILLER_37_966 VPWR VGND sg13cmos5l_fill_1
X_06692_ _06692_/Y _06692_/A _06722_/B VPWR VGND sg13cmos5l_nor2_1
X_09480_ _09560_/B _09480_/A _09480_/B VPWR VGND sg13cmos5l_nor2_1
XFILLER_91_582 VPWR VGND sg13cmos5l_fill_2
X_08431_ _08431_/Y _08431_/A _08431_/B VPWR VGND sg13cmos5l_nor2_1
XFILLER_63_262 VPWR VGND sg13cmos5l_fill_2
XFILLER_51_402 VPWR VGND sg13cmos5l_fill_1
XFILLER_23_104 VPWR VGND sg13cmos5l_fill_2
X_08362_ _08362_/Y _08362_/A _08372_/B VPWR VGND sg13cmos5l_nand2_1
XFILLER_51_479 VPWR VGND sg13cmos5l_fill_1
X_08293_ _08293_/Y _08293_/A _08293_/B VPWR VGND sg13cmos5l_nor2_1
XFILLER_32_693 VPWR VGND sg13cmos5l_fill_1
X_07313_ _07313_/Y _11531_/Q _08689_/A VPWR VGND sg13cmos5l_nand2_1
X_07244_ _10856_/D _07244_/A _07244_/B VPWR VGND sg13cmos5l_nand2_1
X_07175_ _07175_/Y _07175_/A _07185_/A VPWR VGND sg13cmos5l_nand2_1
XFILLER_106_938 VPWR VGND sg13cmos5l_decap_8
XFILLER_105_426 VPWR VGND sg13cmos5l_decap_8
X_06126_ _11761_/D _06953_/A _06126_/B VPWR VGND sg13cmos5l_nor2_1
X_06057_ _06057_/Y _09301_/S _09278_/A VPWR VGND sg13cmos5l_nor2b_1
Xfanout312 _08514_/A1 _08319_/A1 VPWR VGND sg13cmos5l_buf_1
Xfanout301 _07834_/B _07820_/B VPWR VGND sg13cmos5l_buf_1
Xfanout323 _07034_/B _07059_/B1 VPWR VGND sg13cmos5l_buf_1
XFILLER_87_844 VPWR VGND sg13cmos5l_decap_8
XFILLER_86_332 VPWR VGND sg13cmos5l_decap_4
Xfanout356 _09998_/A fanout357/X VPWR VGND sg13cmos5l_buf_1
Xfanout345 _09852_/A1 _09693_/A1 VPWR VGND sg13cmos5l_buf_1
Xfanout334 _09578_/A2 _09607_/A2 VPWR VGND sg13cmos5l_buf_1
X_09816_ _09816_/Y _10912_/Q _09814_/S _10042_/B1 VPWR VGND sg13cmos5l_a21oi_1
Xfanout389 _10044_/A _09989_/A VPWR VGND sg13cmos5l_buf_1
XFILLER_87_888 VPWR VGND sg13cmos5l_decap_4
XFILLER_87_877 VPWR VGND sg13cmos5l_fill_2
Xfanout378 _09316_/B _09298_/Y VPWR VGND sg13cmos5l_buf_1
XFILLER_47_719 VPWR VGND sg13cmos5l_fill_2
Xfanout367 _10092_/B1 _10158_/A2 VPWR VGND sg13cmos5l_buf_1
XFILLER_100_175 VPWR VGND sg13cmos5l_decap_8
X_09747_ _09829_/B _09885_/A _09747_/B VPWR VGND sg13cmos5l_nand2_1
X_10931__1051 _10931_/RESET_B VPWR VGND sg13cmos5l_tiehi
X_06959_ _06959_/Y _06959_/A _07034_/B VPWR VGND sg13cmos5l_nand2_1
XFILLER_28_933 VPWR VGND sg13cmos5l_fill_2
XFILLER_43_903 VPWR VGND sg13cmos5l_decap_4
XFILLER_27_454 VPWR VGND sg13cmos5l_fill_1
XFILLER_82_571 VPWR VGND sg13cmos5l_fill_2
X_09678_ _09678_/Y _11131_/Q _09957_/B _09991_/B1 VPWR VGND sg13cmos5l_a21oi_1
XFILLER_42_413 VPWR VGND sg13cmos5l_decap_8
XFILLER_14_104 VPWR VGND sg13cmos5l_fill_2
XFILLER_27_487 VPWR VGND sg13cmos5l_decap_4
XFILLER_28_999 VPWR VGND sg13cmos5l_fill_2
XFILLER_70_755 VPWR VGND sg13cmos5l_decap_8
X_08629_ _08629_/Y _08625_/A _08628_/Y hold2716/X VPWR VGND sg13cmos5l_o21ai_1
XFILLER_54_295 VPWR VGND sg13cmos5l_fill_2
XFILLER_42_446 VPWR VGND sg13cmos5l_decap_4
XFILLER_42_424 VPWR VGND sg13cmos5l_fill_2
XFILLER_36_89 VPWR VGND sg13cmos5l_fill_1
XFILLER_27_498 VPWR VGND sg13cmos5l_fill_1
X_11640_ _11640_/Q clkload30/A _11640_/D _11640_/RESET_B VPWR VGND sg13cmos5l_dfrbpq_1
XFILLER_52_11 VPWR VGND sg13cmos5l_decap_4
X_11184__1717 _11184_/RESET_B VPWR VGND sg13cmos5l_tiehi
X_11571_ _11571_/Q clkload25/A _11571_/D _11571_/RESET_B VPWR VGND sg13cmos5l_dfrbpq_1
XFILLER_52_55 VPWR VGND sg13cmos5l_decap_4
X_11220__1681 _11220_/RESET_B VPWR VGND sg13cmos5l_tiehi
XFILLER_11_822 VPWR VGND sg13cmos5l_fill_2
X_10522_ _10522_/Y _10534_/A _10520_/Y _10521_/Y VPWR VGND sg13cmos5l_o21ai_1
XFILLER_7_804 VPWR VGND sg13cmos5l_fill_1
XFILLER_6_325 VPWR VGND sg13cmos5l_decap_4
X_10453_ _10454_/C _10453_/A _10453_/B _10453_/C _10453_/D VPWR VGND sg13cmos5l_nor4_1
X_10384_ _10384_/Y _10385_/A _10453_/A VPWR VGND sg13cmos5l_nor2_1
XFILLER_7_0 VPWR VGND sg13cmos5l_decap_8
XFILLER_2_520 VPWR VGND sg13cmos5l_fill_1
XFILLER_105_960 VPWR VGND sg13cmos5l_decap_8
XFILLER_77_30 VPWR VGND sg13cmos5l_decap_8
XFILLER_89_192 VPWR VGND sg13cmos5l_fill_2
XFILLER_78_833 VPWR VGND sg13cmos5l_decap_4
XFILLER_77_365 VPWR VGND sg13cmos5l_fill_2
XFILLER_77_85 VPWR VGND sg13cmos5l_fill_2
X_11005_ _11005_/Q clkload42/A _11005_/D _11005_/RESET_B VPWR VGND sg13cmos5l_dfrbpq_1
XFILLER_77_376 VPWR VGND sg13cmos5l_decap_4
XFILLER_92_335 VPWR VGND sg13cmos5l_fill_1
XFILLER_58_590 VPWR VGND sg13cmos5l_fill_2
X_11528__1127 _11528_/RESET_B VPWR VGND sg13cmos5l_tiehi
XFILLER_18_432 VPWR VGND sg13cmos5l_decap_8
XFILLER_19_955 VPWR VGND sg13cmos5l_decap_8
XFILLER_93_84 VPWR VGND sg13cmos5l_fill_2
XFILLER_34_936 VPWR VGND sg13cmos5l_fill_2
X_11631__1335 _11631_/RESET_B VPWR VGND sg13cmos5l_tiehi
XFILLER_61_744 VPWR VGND sg13cmos5l_decap_8
XFILLER_33_446 VPWR VGND sg13cmos5l_fill_1
XFILLER_42_980 VPWR VGND sg13cmos5l_decap_8
XFILLER_14_693 VPWR VGND sg13cmos5l_fill_1
Xclkbuf_leaf_40_clk clkload53/A clkbuf_4_14_0_clk/X VPWR VGND sg13cmos5l_buf_8
X_10973__1009 _10973_/RESET_B VPWR VGND sg13cmos5l_tiehi
XFILLER_5_380 VPWR VGND sg13cmos5l_decap_4
XFILLER_87_118 VPWR VGND sg13cmos5l_fill_2
X_08980_ _09019_/A _11388_/Q _08981_/B VPWR VGND sg13cmos5l_nor2_1
XFILLER_102_429 VPWR VGND sg13cmos5l_decap_4
Xhold2728 _11558_/D _10722_/Y VPWR VGND sg13cmos5l_dlygate4sd3_1
Xhold2706 _11685_/D _06911_/X VPWR VGND sg13cmos5l_dlygate4sd3_1
XFILLER_69_822 VPWR VGND sg13cmos5l_fill_1
Xhold2717 _08630_/B _08629_/Y VPWR VGND sg13cmos5l_dlygate4sd3_1
X_07931_ _11055_/D _08518_/A1 _07942_/B _07930_/Y VPWR VGND sg13cmos5l_o21ai_1
XFILLER_84_814 VPWR VGND sg13cmos5l_decap_8
XFILLER_84_803 VPWR VGND sg13cmos5l_fill_2
X_11262__1639 _11262_/RESET_B VPWR VGND sg13cmos5l_tiehi
Xhold2739 _06506_/B _11370_/Q VPWR VGND sg13cmos5l_dlygate4sd3_1
X_07862_ _11021_/D _08384_/A1 _07875_/B _07861_/Y VPWR VGND sg13cmos5l_a21oi_1
X_06813_ _06813_/Y _06813_/A _10785_/B VPWR VGND sg13cmos5l_nand2_1
XFILLER_84_825 VPWR VGND sg13cmos5l_fill_1
X_09601_ _09601_/Y _10904_/Q _09363_/B _09601_/B1 VPWR VGND sg13cmos5l_a21oi_1
XFILLER_3_1011 VPWR VGND sg13cmos5l_decap_8
X_07793_ _10988_/D _08512_/A1 _07826_/B _07792_/Y VPWR VGND sg13cmos5l_o21ai_1
X_09532_ _09533_/B _09852_/A1 _09527_/X _09531_/Y VPWR VGND sg13cmos5l_o21ai_1
XFILLER_92_880 VPWR VGND sg13cmos5l_decap_8
XFILLER_64_571 VPWR VGND sg13cmos5l_decap_8
XFILLER_58_1013 VPWR VGND sg13cmos5l_decap_8
XFILLER_37_763 VPWR VGND sg13cmos5l_fill_1
X_06744_ _10815_/D _06744_/A1 _06741_/Y _06743_/Y VPWR VGND sg13cmos5l_o21ai_1
XFILLER_52_733 VPWR VGND sg13cmos5l_fill_2
XFILLER_37_796 VPWR VGND sg13cmos5l_decap_8
X_06675_ _06675_/Y _06363_/A _06665_/B _06732_/B _06673_/A _06674_/Y VPWR VGND sg13cmos5l_a221oi_1
X_09463_ _09463_/Y _09206_/C _09462_/Y _09345_/A VPWR VGND sg13cmos5l_a21oi_1
X_11064__861 _11064_/RESET_B VPWR VGND sg13cmos5l_tiehi
XFILLER_51_254 VPWR VGND sg13cmos5l_decap_8
X_08414_ _11292_/D fanout81/X _08423_/B _08413_/Y VPWR VGND sg13cmos5l_a21oi_1
X_09394_ _09395_/B _11248_/Q _11216_/Q _11184_/Q _11152_/Q _09551_/S0 _09551_/S1 VPWR
+ VGND sg13cmos5l_mux4_1
X_11597__1386 _11597_/RESET_B VPWR VGND sg13cmos5l_tiehi
XFILLER_51_287 VPWR VGND sg13cmos5l_decap_8
X_08345_ _11258_/D fanout96/X _08350_/B _08344_/Y VPWR VGND sg13cmos5l_o21ai_1
Xclkbuf_leaf_31_clk _11364_/CLK clkload5/A VPWR VGND sg13cmos5l_buf_8
X_10825__962 _10825_/RESET_B VPWR VGND sg13cmos5l_tiehi
X_08276_ _11224_/D _08471_/A1 _08281_/B _08275_/Y VPWR VGND sg13cmos5l_a21oi_1
XFILLER_20_674 VPWR VGND sg13cmos5l_decap_4
X_07227_ _07227_/Y _08955_/A _11389_/Q _07227_/B1 hold2703/X _07166_/X VPWR VGND sg13cmos5l_a221oi_1
X_07158_ _11744_/D _05877_/Y _07160_/A2 _07157_/Y VPWR VGND sg13cmos5l_a21oi_1
X_10949__1033 _10949_/RESET_B VPWR VGND sg13cmos5l_tiehi
XFILLER_106_735 VPWR VGND sg13cmos5l_decap_8
X_06109_ _06109_/Y _08627_/C _06109_/B _06124_/B VPWR VGND sg13cmos5l_nand3_1
XFILLER_105_245 VPWR VGND sg13cmos5l_decap_8
X_11071__854 _11071_/RESET_B VPWR VGND sg13cmos5l_tiehi
X_07089_ _07089_/X _11734_/Q hold2678/X _07098_/B VPWR VGND sg13cmos5l_mux2_1
XFILLER_0_7 VPWR VGND sg13cmos5l_decap_8
Xfanout120 _08488_/B _08478_/B VPWR VGND sg13cmos5l_buf_1
Xfanout131 _08208_/B _08234_/B VPWR VGND sg13cmos5l_buf_1
XFILLER_75_803 VPWR VGND sg13cmos5l_fill_1
Xfanout153 _08331_/A1 _07502_/Y VPWR VGND sg13cmos5l_buf_1
Xfanout142 _07966_/B _07942_/B VPWR VGND sg13cmos5l_buf_1
Xfanout164 _07383_/B _07347_/B VPWR VGND sg13cmos5l_buf_1
XFILLER_101_462 VPWR VGND sg13cmos5l_fill_2
X_11238__1663 _11238_/RESET_B VPWR VGND sg13cmos5l_tiehi
XFILLER_75_847 VPWR VGND sg13cmos5l_decap_4
XFILLER_47_44 VPWR VGND sg13cmos5l_decap_8
Xfanout186 _08415_/B _08405_/B VPWR VGND sg13cmos5l_buf_1
Xfanout175 _08543_/B _08535_/B VPWR VGND sg13cmos5l_buf_1
Xfanout197 _08293_/B _08281_/B VPWR VGND sg13cmos5l_buf_1
XFILLER_43_711 VPWR VGND sg13cmos5l_decap_8
X_11739__1202 _11739_/RESET_B VPWR VGND sg13cmos5l_tiehi
XFILLER_43_722 VPWR VGND sg13cmos5l_fill_1
XFILLER_15_435 VPWR VGND sg13cmos5l_decap_4
XFILLER_42_254 VPWR VGND sg13cmos5l_fill_2
XFILLER_42_243 VPWR VGND sg13cmos5l_fill_2
XFILLER_15_457 VPWR VGND sg13cmos5l_fill_2
XFILLER_31_917 VPWR VGND sg13cmos5l_decap_8
X_11623_ _11623_/Q clkload29/A _11623_/D _11623_/RESET_B VPWR VGND sg13cmos5l_dfrbpq_1
XFILLER_42_265 VPWR VGND sg13cmos5l_decap_8
XFILLER_24_980 VPWR VGND sg13cmos5l_decap_8
XFILLER_30_416 VPWR VGND sg13cmos5l_decap_8
XFILLER_30_427 VPWR VGND sg13cmos5l_fill_2
Xclkbuf_leaf_22_clk _11339_/CLK clkload2/A VPWR VGND sg13cmos5l_buf_8
X_11554_ _11554_/Q clkload23/A _11554_/D _11554_/RESET_B VPWR VGND sg13cmos5l_dfrbpq_1
XFILLER_7_612 VPWR VGND sg13cmos5l_fill_2
X_11485_ _11485_/Q clkload45/A _11485_/D _11485_/RESET_B VPWR VGND sg13cmos5l_dfrbpq_1
X_10505_ _10507_/B _10539_/A _10525_/B _10525_/C VPWR VGND sg13cmos5l_nand3_1
XFILLER_7_656 VPWR VGND sg13cmos5l_decap_8
XFILLER_7_689 VPWR VGND sg13cmos5l_decap_4
X_10436_ _10437_/D _10424_/A _10479_/C _06229_/B _10436_/B2 VPWR VGND sg13cmos5l_a22oi_1
X_10367_ _10386_/B _06229_/B _10424_/B _06236_/A _09641_/A VPWR VGND sg13cmos5l_a22oi_1
X_10298_ _10481_/A _10298_/A _10462_/B VPWR VGND sg13cmos5l_nand2_1
XFILLER_93_633 VPWR VGND sg13cmos5l_fill_2
XFILLER_93_688 VPWR VGND sg13cmos5l_decap_8
XFILLER_18_251 VPWR VGND sg13cmos5l_fill_2
XFILLER_19_752 VPWR VGND sg13cmos5l_decap_8
X_11552__1467 _11552_/RESET_B VPWR VGND sg13cmos5l_tiehi
XFILLER_34_733 VPWR VGND sg13cmos5l_fill_1
XFILLER_34_744 VPWR VGND sg13cmos5l_fill_1
X_06460_ _06460_/X _10494_/B1 _11632_/Q _06458_/X VPWR VGND sg13cmos5l_a21o_1
XFILLER_21_405 VPWR VGND sg13cmos5l_fill_2
X_10809__946 _10809_/RESET_B VPWR VGND sg13cmos5l_tiehi
Xclkbuf_leaf_13_clk clkload22/A clkbuf_4_4_0_clk/X VPWR VGND sg13cmos5l_buf_8
X_06391_ _06392_/B _06772_/S _06390_/Y _06388_/Y VPWR VGND sg13cmos5l_a21oi_1
X_08130_ _11152_/D _08520_/A1 _08135_/B _08129_/Y VPWR VGND sg13cmos5l_a21oi_1
X_08061_ _11119_/D _08453_/A1 _08078_/B _08060_/Y VPWR VGND sg13cmos5l_o21ai_1
X_10998__984 _10998_/RESET_B VPWR VGND sg13cmos5l_tiehi
X_11316__1585 _11316_/RESET_B VPWR VGND sg13cmos5l_tiehi
X_07012_ _07012_/Y _07012_/A _07024_/B VPWR VGND sg13cmos5l_nor2_1
XFILLER_89_928 VPWR VGND sg13cmos5l_decap_4
XFILLER_0_309 VPWR VGND sg13cmos5l_fill_2
XFILLER_88_438 VPWR VGND sg13cmos5l_decap_8
X_08963_ _08967_/A _08913_/A _08913_/B _08962_/Y VPWR VGND sg13cmos5l_a21oi_1
Xhold2503 hold2503/X _11675_/Q VPWR VGND sg13cmos5l_dlygate4sd3_1
XFILLER_25_1001 VPWR VGND sg13cmos5l_fill_1
XFILLER_102_259 VPWR VGND sg13cmos5l_decap_8
X_07914_ _11047_/D fanout53/X _07913_/B _07913_/Y VPWR VGND sg13cmos5l_a21oi_1
Xhold2536 _05892_/A _11625_/Q VPWR VGND sg13cmos5l_dlygate4sd3_1
Xhold2547 _11609_/D _06827_/Y VPWR VGND sg13cmos5l_dlygate4sd3_1
Xhold2514 _11583_/D _10767_/X VPWR VGND sg13cmos5l_dlygate4sd3_1
Xhold2525 _07353_/A _10876_/Q VPWR VGND sg13cmos5l_dlygate4sd3_1
Xhold1835 _08482_/A _11326_/Q VPWR VGND sg13cmos5l_dlygate4sd3_1
Xhold2558 _11577_/D _10761_/X VPWR VGND sg13cmos5l_dlygate4sd3_1
Xhold2569 _10771_/A _11587_/Q VPWR VGND sg13cmos5l_dlygate4sd3_1
X_08894_ _11434_/D _08892_/Y _08893_/Y _08882_/Y VPWR VGND sg13cmos5l_o21ai_1
Xhold1857 _11591_/D _10784_/Y VPWR VGND sg13cmos5l_dlygate4sd3_1
XFILLER_83_132 VPWR VGND sg13cmos5l_decap_4
X_07845_ _11014_/D fanout56/X _07844_/B _07844_/Y VPWR VGND sg13cmos5l_o21ai_1
Xhold1868 _07808_/A _10996_/Q VPWR VGND sg13cmos5l_dlygate4sd3_1
Xhold1846 _07950_/A _11065_/Q VPWR VGND sg13cmos5l_dlygate4sd3_1
Xhold1879 _08494_/A _11332_/Q VPWR VGND sg13cmos5l_dlygate4sd3_1
XFILLER_72_828 VPWR VGND sg13cmos5l_fill_1
XFILLER_72_817 VPWR VGND sg13cmos5l_decap_8
X_07776_ _07776_/Y _07776_/A _07778_/B VPWR VGND sg13cmos5l_nor2_1
XFILLER_65_891 VPWR VGND sg13cmos5l_fill_2
XFILLER_37_593 VPWR VGND sg13cmos5l_decap_8
XFILLER_37_582 VPWR VGND sg13cmos5l_decap_4
X_09515_ _09515_/Y _09731_/A _09515_/B _09515_/C VPWR VGND sg13cmos5l_nand3_1
XFILLER_25_711 VPWR VGND sg13cmos5l_fill_2
X_06727_ _06728_/B _06727_/A _06727_/B VPWR VGND sg13cmos5l_and2_1
X_09446_ _09453_/A _09443_/Y _09444_/Y _09445_/X _09572_/B1 _09574_/B1 VPWR VGND sg13cmos5l_a221oi_1
X_10855__1132 _10855_/RESET_B VPWR VGND sg13cmos5l_tiehi
X_06658_ _06658_/Y _06658_/A _06733_/B VPWR VGND sg13cmos5l_nor2_1
XFILLER_33_13 VPWR VGND sg13cmos5l_fill_2
X_06589_ _06590_/B _06631_/S _06279_/X _06588_/X VPWR VGND sg13cmos5l_o21ai_1
XFILLER_40_758 VPWR VGND sg13cmos5l_decap_4
XFILLER_40_747 VPWR VGND sg13cmos5l_decap_4
XFILLER_12_438 VPWR VGND sg13cmos5l_fill_2
X_09377_ _09377_/Y _09429_/A _09336_/B _09644_/A VPWR VGND sg13cmos5l_o21ai_1
XFILLER_33_68 VPWR VGND sg13cmos5l_fill_2
X_11512__1159 _11512_/RESET_B VPWR VGND sg13cmos5l_tiehi
X_08328_ _08328_/Y _08328_/A _08328_/B VPWR VGND sg13cmos5l_nand2_1
X_08259_ _08259_/Y _08259_/A _08263_/B VPWR VGND sg13cmos5l_nor2_1
XFILLER_106_532 VPWR VGND sg13cmos5l_decap_8
X_11270_ _11270_/Q clkload52/A _11270_/D _11270_/RESET_B VPWR VGND sg13cmos5l_dfrbpq_1
X_10221_ _10222_/C _11397_/Q _10834_/Q _10202_/A _10202_/B _10199_/X VPWR VGND sg13cmos5l_a221oi_1
X_10152_ _10152_/Y _10149_/B _10151_/Y _10149_/Y VPWR VGND sg13cmos5l_o21ai_1
XFILLER_95_909 VPWR VGND sg13cmos5l_fill_2
X_10083_ _10083_/Y _10070_/A _10838_/Q _10092_/B1 VPWR VGND sg13cmos5l_o21ai_1
XFILLER_102_782 VPWR VGND sg13cmos5l_decap_8
XFILLER_75_622 VPWR VGND sg13cmos5l_fill_2
XFILLER_58_76 VPWR VGND sg13cmos5l_fill_2
XFILLER_48_825 VPWR VGND sg13cmos5l_decap_8
XFILLER_0_887 VPWR VGND sg13cmos5l_decap_8
XFILLER_101_292 VPWR VGND sg13cmos5l_fill_1
XFILLER_101_281 VPWR VGND sg13cmos5l_decap_8
XFILLER_101_270 VPWR VGND sg13cmos5l_decap_4
XFILLER_90_603 VPWR VGND sg13cmos5l_fill_2
XFILLER_74_42 VPWR VGND sg13cmos5l_decap_8
XFILLER_47_379 VPWR VGND sg13cmos5l_decap_8
XFILLER_90_625 VPWR VGND sg13cmos5l_decap_8
XFILLER_74_187 VPWR VGND sg13cmos5l_decap_8
X_10985_ _10985_/Q clkload51/A _10985_/D _10985_/RESET_B VPWR VGND sg13cmos5l_dfrbpq_1
XFILLER_31_758 VPWR VGND sg13cmos5l_decap_8
X_11606_ _11606_/Q clkload27/A _11606_/D _11606_/RESET_B VPWR VGND sg13cmos5l_dfrbpq_1
X_11537_ _11537_/Q clkload37/A _11537_/D _11537_/RESET_B VPWR VGND sg13cmos5l_dfrbpq_1
XFILLER_8_998 VPWR VGND sg13cmos5l_decap_8
X_11468_ _11468_/Q clkload20/A _11468_/D _11468_/RESET_B VPWR VGND sg13cmos5l_dfrbpq_1
X_11399_ _11399_/Q _11528_/CLK _11399_/D _11399_/RESET_B VPWR VGND sg13cmos5l_dfrbpq_1
X_10419_ _10420_/B _10419_/A _10419_/B _10453_/C VPWR VGND sg13cmos5l_nand3_1
X_11054__871 _11054_/RESET_B VPWR VGND sg13cmos5l_tiehi
XFILLER_31_4 VPWR VGND sg13cmos5l_decap_4
XFILLER_66_611 VPWR VGND sg13cmos5l_fill_2
X_05960_ _05960_/Y _11315_/Q VPWR VGND sg13cmos5l_inv_1
Xclkbuf_leaf_2_clk clkload11/A clkbuf_4_1_0_clk/X VPWR VGND sg13cmos5l_buf_8
XFILLER_94_964 VPWR VGND sg13cmos5l_decap_8
X_05891_ _10710_/B _10691_/B VPWR VGND sg13cmos5l_inv_1
XFILLER_66_644 VPWR VGND sg13cmos5l_fill_1
XFILLER_39_847 VPWR VGND sg13cmos5l_fill_2
X_07630_ _08758_/B _11547_/Q _10822_/Q _07642_/S VPWR VGND sg13cmos5l_mux2_1
XFILLER_38_357 VPWR VGND sg13cmos5l_decap_8
XFILLER_26_519 VPWR VGND sg13cmos5l_decap_4
XFILLER_54_839 VPWR VGND sg13cmos5l_decap_8
X_07561_ _08716_/B _11537_/Q _10812_/Q _07582_/S VPWR VGND sg13cmos5l_mux2_1
X_09300_ _09305_/C _09297_/Y _09316_/B VPWR VGND sg13cmos5l_nand2b_1
XFILLER_46_390 VPWR VGND sg13cmos5l_fill_1
X_06512_ _06512_/Y _10926_/Q _06512_/B VPWR VGND sg13cmos5l_nand2_1
XFILLER_62_894 VPWR VGND sg13cmos5l_decap_4
X_07492_ _07492_/Y _11400_/Q _10229_/A _07500_/D VPWR VGND sg13cmos5l_nand3_1
XFILLER_34_585 VPWR VGND sg13cmos5l_decap_8
X_06443_ _06443_/Y _06443_/A _06443_/B VPWR VGND sg13cmos5l_xnor2_1
X_09231_ _09729_/B _10295_/A _09231_/B VPWR VGND sg13cmos5l_nand2_1
X_11061__864 _11061_/RESET_B VPWR VGND sg13cmos5l_tiehi
X_09162_ _09171_/B _10250_/A _10851_/Q VPWR VGND sg13cmos5l_xnor2_1
XFILLER_9_70 VPWR VGND sg13cmos5l_fill_2
XFILLER_21_279 VPWR VGND sg13cmos5l_decap_4
X_06374_ _06374_/Y _06374_/A _06374_/B _06374_/C VPWR VGND sg13cmos5l_nor3_1
X_08113_ _11145_/D fanout50/X _08112_/B _08112_/Y VPWR VGND sg13cmos5l_o21ai_1
XFILLER_30_791 VPWR VGND sg13cmos5l_decap_8
X_09093_ _09093_/Y _09093_/A _09093_/B VPWR VGND sg13cmos5l_nand2_1
X_11723__1234 _11723_/RESET_B VPWR VGND sg13cmos5l_tiehi
X_08044_ _11111_/D fanout54/X _08043_/B _08043_/Y VPWR VGND sg13cmos5l_a21oi_1
XFILLER_88_224 VPWR VGND sg13cmos5l_fill_2
Xhold2311 _08177_/A _11176_/Q VPWR VGND sg13cmos5l_dlygate4sd3_1
X_09995_ _09996_/B _09902_/A _09990_/X _09994_/Y VPWR VGND sg13cmos5l_o21ai_1
Xhold2322 _07511_/A _10900_/Q VPWR VGND sg13cmos5l_dlygate4sd3_1
Xhold2300 _08389_/A _11280_/Q VPWR VGND sg13cmos5l_dlygate4sd3_1
Xhold2344 _07756_/A _10971_/Q VPWR VGND sg13cmos5l_dlygate4sd3_1
Xhold2355 _08789_/A _11426_/Q VPWR VGND sg13cmos5l_dlygate4sd3_1
X_08946_ _08946_/Y _08921_/A _08943_/B _08946_/B1 VPWR VGND sg13cmos5l_o21ai_1
Xhold2333 _08383_/A _11277_/Q VPWR VGND sg13cmos5l_dlygate4sd3_1
Xhold2377 _07441_/A _10890_/Q VPWR VGND sg13cmos5l_dlygate4sd3_1
Xhold2388 _08559_/A _11364_/Q VPWR VGND sg13cmos5l_dlygate4sd3_1
Xhold2366 _07607_/A _10914_/Q VPWR VGND sg13cmos5l_dlygate4sd3_1
X_08877_ _08877_/X _08890_/B _08877_/B VPWR VGND sg13cmos5l_xor2_1
X_10899__1083 _10899_/RESET_B VPWR VGND sg13cmos5l_tiehi
X_07828_ _07828_/Y _07828_/A _07850_/B VPWR VGND sg13cmos5l_nand2_1
XFILLER_57_688 VPWR VGND sg13cmos5l_fill_1
Xhold2399 _08131_/A _11153_/Q VPWR VGND sg13cmos5l_dlygate4sd3_1
XFILLER_17_519 VPWR VGND sg13cmos5l_fill_2
XFILLER_56_198 VPWR VGND sg13cmos5l_decap_4
XFILLER_45_839 VPWR VGND sg13cmos5l_fill_2
X_07759_ _10972_/D fanout80/X _07768_/B _07758_/Y VPWR VGND sg13cmos5l_a21oi_1
X_10770_ _10770_/X hold2532/X _11586_/Q _10770_/S VPWR VGND sg13cmos5l_mux2_1
XFILLER_25_585 VPWR VGND sg13cmos5l_decap_8
X_11648__1316 _11648_/RESET_B VPWR VGND sg13cmos5l_tiehi
X_09429_ _09430_/B _09429_/A _09456_/B VPWR VGND sg13cmos5l_nor2_1
XFILLER_100_84 VPWR VGND sg13cmos5l_decap_8
XFILLER_5_913 VPWR VGND sg13cmos5l_decap_4
X_11405__1480 _11405_/RESET_B VPWR VGND sg13cmos5l_tiehi
XFILLER_5_28 VPWR VGND sg13cmos5l_decap_8
X_11322_ _11322_/Q _11361_/CLK _11322_/D _11322_/RESET_B VPWR VGND sg13cmos5l_dfrbpq_1
XFILLER_5_968 VPWR VGND sg13cmos5l_fill_2
X_11253_ _11253_/Q clkload40/A _11253_/D _11253_/RESET_B VPWR VGND sg13cmos5l_dfrbpq_1
X_11533__1521 _11533_/RESET_B VPWR VGND sg13cmos5l_tiehi
XFILLER_79_202 VPWR VGND sg13cmos5l_fill_2
X_10204_ _10204_/Y _10204_/A VPWR VGND sg13cmos5l_inv_1
X_11184_ _11184_/Q _11668_/CLK _11184_/D _11184_/RESET_B VPWR VGND sg13cmos5l_dfrbpq_1
XFILLER_94_216 VPWR VGND sg13cmos5l_decap_8
XFILLER_79_268 VPWR VGND sg13cmos5l_fill_1
X_10135_ _10135_/Y _10135_/A _10135_/B VPWR VGND sg13cmos5l_nand2_1
X_10066_ _11490_/D _07020_/A _10088_/A2 _10065_/Y _06509_/A VPWR VGND sg13cmos5l_a22oi_1
XFILLER_48_677 VPWR VGND sg13cmos5l_fill_1
XFILLER_75_485 VPWR VGND sg13cmos5l_decap_4
XFILLER_47_176 VPWR VGND sg13cmos5l_decap_8
XFILLER_35_316 VPWR VGND sg13cmos5l_decap_8
X_10988__994 _10988_/RESET_B VPWR VGND sg13cmos5l_tiehi
XFILLER_63_658 VPWR VGND sg13cmos5l_decap_8
XFILLER_16_530 VPWR VGND sg13cmos5l_fill_2
XFILLER_90_477 VPWR VGND sg13cmos5l_decap_8
XFILLER_50_319 VPWR VGND sg13cmos5l_fill_1
XFILLER_44_894 VPWR VGND sg13cmos5l_decap_8
X_10968_ _10968_/Q _11349_/CLK _10968_/D _10968_/RESET_B VPWR VGND sg13cmos5l_dfrbpq_1
X_10899_ _10899_/Q clkload17/A _10899_/D _10899_/RESET_B VPWR VGND sg13cmos5l_dfrbpq_1
XFILLER_15_1000 VPWR VGND sg13cmos5l_decap_8
XFILLER_31_566 VPWR VGND sg13cmos5l_decap_4
XFILLER_79_4 VPWR VGND sg13cmos5l_fill_2
XFILLER_102_1025 VPWR VGND sg13cmos5l_decap_4
X_06090_ _06090_/Y hold2636/X _06089_/Y _06093_/A VPWR VGND sg13cmos5l_a21oi_1
XFILLER_7_261 VPWR VGND sg13cmos5l_fill_2
X_11197__1704 _11197_/RESET_B VPWR VGND sg13cmos5l_tiehi
X_10995__987 _10995_/RESET_B VPWR VGND sg13cmos5l_tiehi
Xfanout708 _08774_/A _08916_/B1 VPWR VGND sg13cmos5l_buf_1
X_08800_ _11426_/D _08798_/Y _08799_/Y _08789_/Y VPWR VGND sg13cmos5l_o21ai_1
Xfanout719 _07497_/A _07447_/S VPWR VGND sg13cmos5l_buf_1
XFILLER_61_1020 VPWR VGND sg13cmos5l_decap_8
X_09780_ _09780_/Y _09754_/Y _09755_/Y _09773_/Y _09316_/B _09779_/Y VPWR VGND sg13cmos5l_a221oi_1
XFILLER_39_611 VPWR VGND sg13cmos5l_fill_2
X_06992_ _06992_/Y _06990_/Y _06991_/Y _07062_/S VPWR VGND sg13cmos5l_a21oi_1
X_05943_ _07205_/A _06831_/B VPWR VGND sg13cmos5l_inv_1
XFILLER_66_430 VPWR VGND sg13cmos5l_fill_1
X_08731_ _09036_/B _08731_/A _08731_/B VPWR VGND sg13cmos5l_nand2_1
X_08662_ _08663_/A hold2780/X _08811_/B _08817_/C _08831_/B1 VPWR VGND sg13cmos5l_a22oi_1
XFILLER_93_282 VPWR VGND sg13cmos5l_fill_1
X_07613_ _07613_/Y _07613_/A _07648_/B VPWR VGND sg13cmos5l_nor2_1
X_05874_ _05874_/Y input8/X VPWR VGND sg13cmos5l_inv_1
XFILLER_38_187 VPWR VGND sg13cmos5l_fill_1
X_08593_ _08593_/Y _10987_/Q _10020_/B VPWR VGND sg13cmos5l_nand2_1
X_07544_ _07544_/Y _07591_/A _07543_/Y _07541_/Y VPWR VGND sg13cmos5l_o21ai_1
XFILLER_62_680 VPWR VGND sg13cmos5l_decap_4
X_07475_ _07475_/Y _07475_/A _07537_/B VPWR VGND sg13cmos5l_nor2_1
XFILLER_22_511 VPWR VGND sg13cmos5l_decap_8
X_06426_ _06426_/Y _06248_/A _06444_/C _06758_/B1 _10658_/A _06425_/Y VPWR VGND sg13cmos5l_a221oi_1
XFILLER_10_706 VPWR VGND sg13cmos5l_fill_2
X_09214_ _09542_/B _09214_/A _10841_/Q VPWR VGND sg13cmos5l_xnor2_1
XFILLER_22_599 VPWR VGND sg13cmos5l_fill_2
X_09145_ _09145_/Y _09145_/A _09155_/B VPWR VGND sg13cmos5l_nand2_1
X_06357_ _06358_/B _06658_/A _06166_/Y _06162_/Y VPWR VGND sg13cmos5l_o21ai_1
X_09076_ _09076_/Y _09109_/A _09077_/B VPWR VGND sg13cmos5l_nand2_1
X_06288_ _06645_/B _11494_/Q _06185_/B _06625_/B _06287_/Y VPWR VGND sg13cmos5l_a22oi_1
X_08027_ _08027_/Y _08027_/A _08033_/B VPWR VGND sg13cmos5l_nor2_1
XFILLER_100_7 VPWR VGND sg13cmos5l_decap_8
XFILLER_104_811 VPWR VGND sg13cmos5l_decap_8
XFILLER_89_500 VPWR VGND sg13cmos5l_fill_2
XFILLER_2_927 VPWR VGND sg13cmos5l_decap_8
XFILLER_104_866 VPWR VGND sg13cmos5l_decap_8
XFILLER_103_365 VPWR VGND sg13cmos5l_decap_8
Xhold2130 _08037_/A _11108_/Q VPWR VGND sg13cmos5l_dlygate4sd3_1
XFILLER_89_577 VPWR VGND sg13cmos5l_decap_8
XFILLER_77_728 VPWR VGND sg13cmos5l_fill_2
X_09978_ _09978_/Y _09977_/Y _10005_/C VPWR VGND sg13cmos5l_nand2b_1
XFILLER_39_45 VPWR VGND sg13cmos5l_fill_1
XFILLER_39_34 VPWR VGND sg13cmos5l_decap_8
XFILLER_103_398 VPWR VGND sg13cmos5l_decap_8
Xhold2141 _08307_/A _11240_/Q VPWR VGND sg13cmos5l_dlygate4sd3_1
Xhold2152 _05949_/A _11575_/Q VPWR VGND sg13cmos5l_dlygate4sd3_1
Xhold2163 _08157_/A _11166_/Q VPWR VGND sg13cmos5l_dlygate4sd3_1
XFILLER_58_942 VPWR VGND sg13cmos5l_fill_2
X_08929_ _08929_/Y _08961_/B _08929_/B VPWR VGND sg13cmos5l_xnor2_1
Xhold2185 _07696_/A _10942_/Q VPWR VGND sg13cmos5l_dlygate4sd3_1
XFILLER_69_290 VPWR VGND sg13cmos5l_fill_2
Xhold2174 _08151_/A _11163_/Q VPWR VGND sg13cmos5l_dlygate4sd3_1
Xhold2196 _08257_/A _11215_/Q VPWR VGND sg13cmos5l_dlygate4sd3_1
X_11554__1459 _11554_/RESET_B VPWR VGND sg13cmos5l_tiehi
XFILLER_72_411 VPWR VGND sg13cmos5l_fill_1
XFILLER_55_44 VPWR VGND sg13cmos5l_fill_1
XFILLER_55_33 VPWR VGND sg13cmos5l_decap_8
XFILLER_17_305 VPWR VGND sg13cmos5l_decap_8
XFILLER_18_828 VPWR VGND sg13cmos5l_decap_8
XFILLER_84_293 VPWR VGND sg13cmos5l_decap_8
XFILLER_73_967 VPWR VGND sg13cmos5l_decap_8
XFILLER_45_669 VPWR VGND sg13cmos5l_fill_2
X_11275__1626 _11275_/RESET_B VPWR VGND sg13cmos5l_tiehi
X_10822_ _10822_/Q clkload47/A _10822_/D _10822_/RESET_B VPWR VGND sg13cmos5l_dfrbpq_1
XFILLER_32_308 VPWR VGND sg13cmos5l_decap_4
XFILLER_32_319 VPWR VGND sg13cmos5l_decap_4
X_10753_ _10753_/X _11685_/Q hold2583/X _10760_/S VPWR VGND sg13cmos5l_mux2_1
XFILLER_41_853 VPWR VGND sg13cmos5l_decap_8
X_11311__1590 _11311_/RESET_B VPWR VGND sg13cmos5l_tiehi
XFILLER_13_511 VPWR VGND sg13cmos5l_decap_4
XFILLER_13_533 VPWR VGND sg13cmos5l_fill_2
XFILLER_25_371 VPWR VGND sg13cmos5l_decap_4
X_11044__881 _11044_/RESET_B VPWR VGND sg13cmos5l_tiehi
X_10684_ _10685_/C _11747_/Q _10469_/Y _10468_/Y VPWR VGND sg13cmos5l_a21oi_1
XFILLER_40_374 VPWR VGND sg13cmos5l_fill_1
X_11305_ _11305_/Q clkload51/A _11305_/D _11305_/RESET_B VPWR VGND sg13cmos5l_dfrbpq_1
XFILLER_5_765 VPWR VGND sg13cmos5l_decap_4
XFILLER_5_787 VPWR VGND sg13cmos5l_fill_1
X_11236_ _11236_/Q _11339_/CLK _11236_/D _11236_/RESET_B VPWR VGND sg13cmos5l_dfrbpq_1
XFILLER_45_1026 VPWR VGND sg13cmos5l_fill_2
X_11051__874 _11051_/RESET_B VPWR VGND sg13cmos5l_tiehi
X_11167_ _11167_/Q clkload50/A _11167_/D _11167_/RESET_B VPWR VGND sg13cmos5l_dfrbpq_1
XFILLER_1_960 VPWR VGND sg13cmos5l_decap_8
XFILLER_96_84 VPWR VGND sg13cmos5l_fill_1
X_10118_ _10118_/Y _10494_/B1 _09773_/Y _10123_/A VPWR VGND sg13cmos5l_o21ai_1
XFILLER_49_920 VPWR VGND sg13cmos5l_fill_1
XFILLER_76_761 VPWR VGND sg13cmos5l_decap_8
XFILLER_48_463 VPWR VGND sg13cmos5l_decap_8
X_11098_ _11098_/Q clkload41/A _11098_/D _11098_/RESET_B VPWR VGND sg13cmos5l_dfrbpq_1
X_10049_ _10049_/Y _10049_/A1 _10048_/Y _10044_/Y VPWR VGND sg13cmos5l_a21oi_1
XFILLER_75_260 VPWR VGND sg13cmos5l_decap_4
XFILLER_64_967 VPWR VGND sg13cmos5l_decap_8
XFILLER_35_146 VPWR VGND sg13cmos5l_decap_8
XFILLER_50_149 VPWR VGND sg13cmos5l_fill_1
X_07260_ _07260_/Y _08789_/A _07296_/B VPWR VGND sg13cmos5l_nand2_1
XFILLER_31_374 VPWR VGND sg13cmos5l_decap_8
X_07191_ _07192_/B _10835_/Q _07191_/A2 _07185_/X _07189_/X VPWR VGND sg13cmos5l_a22oi_1
X_06211_ _10583_/A _10581_/A _06211_/B VPWR VGND sg13cmos5l_nand2_1
X_06142_ _06142_/Y _08621_/B _06943_/B VPWR VGND sg13cmos5l_nand2_1
X_06073_ _06092_/D _10713_/A _06080_/C VPWR VGND sg13cmos5l_nand2_1
X_09901_ _09902_/B _11267_/Q _11235_/Q _11203_/Q _11171_/Q _10021_/A2 _10021_/B1 VPWR
+ VGND sg13cmos5l_mux4_1
XFILLER_6_71 VPWR VGND sg13cmos5l_fill_2
XFILLER_99_864 VPWR VGND sg13cmos5l_fill_1
Xfanout505 _09885_/B _09276_/Y VPWR VGND sg13cmos5l_buf_1
XFILLER_101_825 VPWR VGND sg13cmos5l_fill_1
XFILLER_86_503 VPWR VGND sg13cmos5l_decap_4
Xfanout527 _07638_/A _07599_/A VPWR VGND sg13cmos5l_buf_1
Xfanout516 _08772_/A2 _08948_/B VPWR VGND sg13cmos5l_buf_1
XFILLER_59_717 VPWR VGND sg13cmos5l_decap_4
X_09832_ _09832_/Y _09884_/A _09831_/Y _09829_/Y VPWR VGND sg13cmos5l_o21ai_1
Xfanout538 _08689_/A _08694_/A VPWR VGND sg13cmos5l_buf_1
X_11353__1548 _11353_/RESET_B VPWR VGND sg13cmos5l_tiehi
XFILLER_100_302 VPWR VGND sg13cmos5l_decap_4
X_09763_ _09763_/Y _11070_/Q _09823_/B VPWR VGND sg13cmos5l_nand2_1
Xfanout549 _10441_/B1 _07006_/Y VPWR VGND sg13cmos5l_buf_1
X_08714_ _08715_/A hold2840/X _09004_/B _08973_/A _09013_/B1 VPWR VGND sg13cmos5l_a22oi_1
X_06975_ _06975_/Y _06990_/B1 _11495_/Q VPWR VGND sg13cmos5l_nand2b_1
XFILLER_94_580 VPWR VGND sg13cmos5l_decap_8
X_09694_ _09700_/B _09745_/A _09694_/B VPWR VGND sg13cmos5l_nor2_1
X_05926_ _07024_/A _06181_/A VPWR VGND sg13cmos5l_inv_1
XFILLER_94_591 VPWR VGND sg13cmos5l_fill_2
X_05857_ _05857_/Y _11594_/Q VPWR VGND sg13cmos5l_inv_1
X_08645_ _11390_/D _11715_/D _08645_/A1 _08645_/S VPWR VGND sg13cmos5l_mux2_1
XFILLER_55_978 VPWR VGND sg13cmos5l_decap_8
X_08576_ _08576_/Y _06476_/A _08575_/X _06476_/B VPWR VGND sg13cmos5l_o21ai_1
XFILLER_54_488 VPWR VGND sg13cmos5l_fill_2
XFILLER_25_14 VPWR VGND sg13cmos5l_fill_2
XFILLER_70_959 VPWR VGND sg13cmos5l_fill_2
X_07527_ _08694_/B _11532_/Q _10807_/Q _07527_/S VPWR VGND sg13cmos5l_mux2_1
XFILLER_50_650 VPWR VGND sg13cmos5l_decap_8
X_07458_ _07458_/X _10191_/A _07472_/D VPWR VGND sg13cmos5l_or2_1
XFILLER_10_525 VPWR VGND sg13cmos5l_fill_1
X_06409_ _06409_/Y _06255_/Y _06257_/Y _10641_/A VPWR VGND sg13cmos5l_o21ai_1
X_07389_ _07389_/Y _07389_/A _07389_/B VPWR VGND sg13cmos5l_nor2_1
X_09128_ _09128_/Y _09148_/A VPWR VGND sg13cmos5l_inv_1
X_11608__1372 _11608_/RESET_B VPWR VGND sg13cmos5l_tiehi
X_09059_ _09059_/Y _09068_/A _09068_/D _09068_/B VPWR VGND sg13cmos5l_a21oi_1
XFILLER_9_4 VPWR VGND sg13cmos5l_decap_8
XFILLER_2_757 VPWR VGND sg13cmos5l_decap_8
XFILLER_2_735 VPWR VGND sg13cmos5l_decap_4
XFILLER_103_140 VPWR VGND sg13cmos5l_decap_8
Xheichips26_RiMaX_1822 uio_oe[7] VPWR VGND sg13cmos5l_tiehi
X_11021_ _11021_/Q clkload33/A _11021_/D _11021_/RESET_B VPWR VGND sg13cmos5l_dfrbpq_1
X_11329__1572 _11329_/RESET_B VPWR VGND sg13cmos5l_tiehi
XFILLER_100_891 VPWR VGND sg13cmos5l_decap_8
XFILLER_73_720 VPWR VGND sg13cmos5l_decap_8
XFILLER_64_219 VPWR VGND sg13cmos5l_fill_1
XFILLER_58_783 VPWR VGND sg13cmos5l_fill_1
XFILLER_57_271 VPWR VGND sg13cmos5l_decap_4
XFILLER_57_282 VPWR VGND sg13cmos5l_decap_4
XFILLER_45_433 VPWR VGND sg13cmos5l_fill_2
XFILLER_18_647 VPWR VGND sg13cmos5l_decap_8
X_10985__997 _10985_/RESET_B VPWR VGND sg13cmos5l_tiehi
XFILLER_73_786 VPWR VGND sg13cmos5l_decap_8
XFILLER_72_296 VPWR VGND sg13cmos5l_decap_4
X_10805_ _10805_/Q clkload16/A _10805_/D _10805_/RESET_B VPWR VGND sg13cmos5l_dfrbpq_1
XFILLER_32_116 VPWR VGND sg13cmos5l_decap_4
XFILLER_60_469 VPWR VGND sg13cmos5l_fill_1
X_10736_ _10736_/Y _08376_/B _10730_/Y _10731_/Y hold2434/X VPWR VGND sg13cmos5l_a22oi_1
XFILLER_41_683 VPWR VGND sg13cmos5l_fill_1
XFILLER_41_672 VPWR VGND sg13cmos5l_decap_4
XFILLER_13_363 VPWR VGND sg13cmos5l_fill_1
X_10667_ _10667_/Y _11422_/Q _10859_/Q VPWR VGND sg13cmos5l_nand2_1
X_10598_ _10613_/A _10622_/A _10622_/B VPWR VGND sg13cmos5l_or2_1
XFILLER_99_116 VPWR VGND sg13cmos5l_decap_8
XFILLER_56_6 VPWR VGND sg13cmos5l_fill_1
XFILLER_5_551 VPWR VGND sg13cmos5l_decap_4
XFILLER_31_90 VPWR VGND sg13cmos5l_fill_1
XFILLER_96_823 VPWR VGND sg13cmos5l_decap_8
X_11219_ _11219_/Q clkload10/A _11219_/D _11219_/RESET_B VPWR VGND sg13cmos5l_dfrbpq_1
XFILLER_96_834 VPWR VGND sg13cmos5l_fill_2
XFILLER_95_322 VPWR VGND sg13cmos5l_decap_8
XFILLER_49_761 VPWR VGND sg13cmos5l_decap_4
XFILLER_76_580 VPWR VGND sg13cmos5l_decap_8
X_06760_ _06761_/B _06389_/C _06385_/C _06760_/S VPWR VGND sg13cmos5l_mux2_1
XFILLER_37_912 VPWR VGND sg13cmos5l_fill_2
XFILLER_64_731 VPWR VGND sg13cmos5l_fill_2
XFILLER_36_433 VPWR VGND sg13cmos5l_decap_8
X_06691_ _06691_/Y _06692_/A _06732_/B _06758_/A2 VPWR VGND sg13cmos5l_a21oi_1
XFILLER_91_550 VPWR VGND sg13cmos5l_fill_2
X_08430_ _11300_/D fanout59/X _08429_/B _08429_/Y VPWR VGND sg13cmos5l_a21oi_1
XFILLER_36_466 VPWR VGND sg13cmos5l_decap_8
XFILLER_24_617 VPWR VGND sg13cmos5l_decap_8
XFILLER_23_116 VPWR VGND sg13cmos5l_fill_2
XFILLER_24_639 VPWR VGND sg13cmos5l_decap_4
X_08361_ _11266_/D fanout63/X _08368_/B _08360_/Y VPWR VGND sg13cmos5l_o21ai_1
XFILLER_32_650 VPWR VGND sg13cmos5l_fill_1
X_08292_ _11232_/D fanout72/X _08301_/B _08291_/Y VPWR VGND sg13cmos5l_a21oi_1
X_11676__1288 _11676_/RESET_B VPWR VGND sg13cmos5l_tiehi
X_07312_ _07312_/Y _07317_/B _07310_/Y hold2270/X VPWR VGND sg13cmos5l_a21oi_1
X_07243_ _07243_/Y _10856_/Q _07205_/B _07243_/B1 _07193_/A VPWR VGND sg13cmos5l_a22oi_1
XFILLER_106_917 VPWR VGND sg13cmos5l_decap_8
X_07174_ _07174_/Y _05952_/Y _07182_/C1 _07172_/Y _07173_/Y VPWR VGND sg13cmos5l_a22oi_1
XFILLER_11_49 VPWR VGND sg13cmos5l_fill_2
XFILLER_105_405 VPWR VGND sg13cmos5l_decap_8
X_06125_ _06126_/B _06109_/B _06127_/B _07132_/A2 VPWR VGND sg13cmos5l_a21oi_1
X_06056_ _09301_/S _11372_/Q _06524_/C VPWR VGND sg13cmos5l_nor2_1
Xfanout313 _08319_/A1 _07460_/Y VPWR VGND sg13cmos5l_buf_1
Xfanout302 _07820_/B _07813_/A2 VPWR VGND sg13cmos5l_buf_1
XFILLER_99_683 VPWR VGND sg13cmos5l_fill_2
X_09815_ _09815_/Y _10944_/Q _09823_/B VPWR VGND sg13cmos5l_nand2_1
Xfanout357 fanout357/X _06057_/Y VPWR VGND sg13cmos5l_buf_1
XFILLER_59_547 VPWR VGND sg13cmos5l_decap_4
Xfanout346 _09693_/A1 _06474_/Y VPWR VGND sg13cmos5l_buf_1
Xfanout335 _09850_/A2 _09607_/A2 VPWR VGND sg13cmos5l_buf_1
X_11034__891 _11034_/RESET_B VPWR VGND sg13cmos5l_tiehi
Xfanout324 _07038_/B _07059_/B1 VPWR VGND sg13cmos5l_buf_1
XFILLER_87_867 VPWR VGND sg13cmos5l_fill_2
Xfanout368 _10123_/A _10158_/A2 VPWR VGND sg13cmos5l_buf_1
Xfanout379 _07226_/B1 _07209_/Y VPWR VGND sg13cmos5l_buf_1
XFILLER_100_154 VPWR VGND sg13cmos5l_decap_8
X_06958_ _06958_/Y _06952_/B _08616_/A VPWR VGND sg13cmos5l_nand2b_1
XFILLER_46_208 VPWR VGND sg13cmos5l_decap_8
X_09746_ _09746_/Y _06229_/B _09721_/B _09644_/A VPWR VGND sg13cmos5l_o21ai_1
X_09677_ _09677_/Y _11099_/Q _09955_/B VPWR VGND sg13cmos5l_nand2_1
XFILLER_39_282 VPWR VGND sg13cmos5l_decap_8
X_05909_ _09613_/A _06229_/B VPWR VGND sg13cmos5l_inv_1
XFILLER_28_967 VPWR VGND sg13cmos5l_fill_2
X_06889_ _11629_/D _11694_/D hold2449/X _08635_/S VPWR VGND sg13cmos5l_mux2_1
XFILLER_55_764 VPWR VGND sg13cmos5l_fill_2
X_08628_ _08628_/Y _08628_/A _08628_/B _08628_/C VPWR VGND sg13cmos5l_nand3_1
XFILLER_55_797 VPWR VGND sg13cmos5l_fill_1
X_08559_ _08559_/Y _08559_/A _08559_/B VPWR VGND sg13cmos5l_nor2_1
XFILLER_14_138 VPWR VGND sg13cmos5l_fill_2
X_11570_ _11570_/Q clkload25/A _11570_/D _11570_/RESET_B VPWR VGND sg13cmos5l_dfrbpq_1
XFILLER_11_834 VPWR VGND sg13cmos5l_fill_2
X_10521_ _10521_/Y _10534_/A _10520_/Y _10449_/Y VPWR VGND sg13cmos5l_a21oi_1
X_11041__884 _11041_/RESET_B VPWR VGND sg13cmos5l_tiehi
XFILLER_10_344 VPWR VGND sg13cmos5l_decap_4
XFILLER_10_355 VPWR VGND sg13cmos5l_decap_8
X_10452_ _10452_/Y _10453_/C _10453_/D VPWR VGND sg13cmos5l_nor2_1
XFILLER_6_359 VPWR VGND sg13cmos5l_fill_2
X_10383_ _10453_/A _11404_/Q _10841_/Q VPWR VGND sg13cmos5l_xnor2_1
XFILLER_97_609 VPWR VGND sg13cmos5l_decap_4
X_11004_ _11004_/Q clkload33/A _11004_/D _11004_/RESET_B VPWR VGND sg13cmos5l_dfrbpq_1
XFILLER_77_344 VPWR VGND sg13cmos5l_decap_4
X_11521__1141 _11521_/RESET_B VPWR VGND sg13cmos5l_tiehi
XFILLER_93_848 VPWR VGND sg13cmos5l_fill_1
XFILLER_19_923 VPWR VGND sg13cmos5l_fill_2
XFILLER_18_411 VPWR VGND sg13cmos5l_decap_8
XFILLER_93_63 VPWR VGND sg13cmos5l_decap_8
XFILLER_73_572 VPWR VGND sg13cmos5l_decap_8
XFILLER_45_285 VPWR VGND sg13cmos5l_decap_4
X_11768_ _11768_/Q clkload25/A _11768_/D _11768_/RESET_B VPWR VGND sg13cmos5l_dfrbpq_1
XFILLER_14_672 VPWR VGND sg13cmos5l_decap_8
X_10719_ _10720_/A _10731_/A _10719_/B _10719_/C VPWR VGND sg13cmos5l_nor3_1
XFILLER_41_491 VPWR VGND sg13cmos5l_fill_1
XFILLER_13_182 VPWR VGND sg13cmos5l_fill_1
X_11699_ _11699_/Q clkload31/A _11699_/D _11699_/RESET_B VPWR VGND sg13cmos5l_dfrbpq_1
XFILLER_61_4 VPWR VGND sg13cmos5l_fill_2
X_10981__1001 _10981_/RESET_B VPWR VGND sg13cmos5l_tiehi
X_07930_ _07930_/Y _07930_/A _07942_/B VPWR VGND sg13cmos5l_nand2_1
XFILLER_47_2 VPWR VGND sg13cmos5l_fill_1
Xhold2729 _08646_/A _11392_/Q VPWR VGND sg13cmos5l_dlygate4sd3_1
Xhold2718 _10698_/A _11551_/Q VPWR VGND sg13cmos5l_dlygate4sd3_1
Xhold2707 _07198_/B _11382_/Q VPWR VGND sg13cmos5l_dlygate4sd3_1
XFILLER_69_856 VPWR VGND sg13cmos5l_decap_4
X_07861_ _07861_/Y _07861_/A _07875_/B VPWR VGND sg13cmos5l_nor2_1
XFILLER_96_686 VPWR VGND sg13cmos5l_decap_4
X_06812_ _06812_/Y _06798_/Y _06807_/Y _06811_/Y VPWR VGND sg13cmos5l_o21ai_1
X_11270__1631 _11270_/RESET_B VPWR VGND sg13cmos5l_tiehi
XFILLER_68_399 VPWR VGND sg13cmos5l_decap_8
XFILLER_68_388 VPWR VGND sg13cmos5l_fill_1
X_09600_ _09600_/Y _10936_/Q _09600_/B VPWR VGND sg13cmos5l_nand2_1
X_07792_ _07792_/Y _07792_/A _07826_/B VPWR VGND sg13cmos5l_nand2_1
XFILLER_28_208 VPWR VGND sg13cmos5l_fill_2
X_09531_ _09531_/Y _09528_/Y _09530_/Y _09851_/B2 VPWR VGND sg13cmos5l_o21ai_1
X_06743_ _06743_/Y _10252_/B _06665_/B _06742_/Y _06223_/A VPWR VGND sg13cmos5l_a22oi_1
X_06674_ _06674_/Y _06674_/A _06733_/B VPWR VGND sg13cmos5l_nor2_1
X_09462_ _09462_/Y _09198_/A _10837_/Q _09439_/A VPWR VGND sg13cmos5l_a21oi_1
XFILLER_91_391 VPWR VGND sg13cmos5l_decap_4
X_08413_ _08413_/Y _08413_/A _08423_/B VPWR VGND sg13cmos5l_nor2_1
X_09393_ _09393_/X _09572_/B1 _09387_/X _09574_/B1 VPWR VGND sg13cmos5l_a21o_1
X_08344_ _08344_/Y _08344_/A _08350_/B VPWR VGND sg13cmos5l_nand2_1
XFILLER_32_491 VPWR VGND sg13cmos5l_fill_2
X_08275_ _08275_/Y _08275_/A _08281_/B VPWR VGND sg13cmos5l_nor2_1
X_07226_ _07226_/Y _05976_/Y _07239_/A2 _07226_/B1 _07225_/Y VPWR VGND sg13cmos5l_a22oi_1
XFILLER_106_714 VPWR VGND sg13cmos5l_decap_8
X_07157_ _07157_/Y hold2767/X _07160_/A2 _07163_/B1 VPWR VGND sg13cmos5l_o21ai_1
XFILLER_105_224 VPWR VGND sg13cmos5l_decap_8
XFILLER_65_1018 VPWR VGND sg13cmos5l_fill_2
X_06108_ _06576_/B _12765_/A _06108_/B VPWR VGND sg13cmos5l_nand2b_1
XFILLER_79_609 VPWR VGND sg13cmos5l_decap_8
X_07088_ _11698_/D hold2847/X _06779_/D _07088_/S VPWR VGND sg13cmos5l_mux2_1
X_06039_ _06041_/C _11619_/Q _11616_/Q _11615_/Q _11614_/Q VPWR VGND sg13cmos5l_nor4_1
Xfanout110 _10776_/B _10771_/B VPWR VGND sg13cmos5l_buf_1
Xfanout121 _08464_/B _08478_/B VPWR VGND sg13cmos5l_buf_1
Xfanout132 _08234_/B _08181_/Y VPWR VGND sg13cmos5l_buf_1
XFILLER_101_430 VPWR VGND sg13cmos5l_fill_1
Xfanout154 _08526_/A1 _07502_/Y VPWR VGND sg13cmos5l_buf_1
Xfanout143 _07958_/B _07942_/B VPWR VGND sg13cmos5l_buf_1
Xfanout165 _07347_/B _07317_/B VPWR VGND sg13cmos5l_buf_1
XFILLER_102_997 VPWR VGND sg13cmos5l_decap_8
XFILLER_75_815 VPWR VGND sg13cmos5l_decap_8
XFILLER_74_303 VPWR VGND sg13cmos5l_fill_2
Xfanout187 _08405_/B _08376_/Y VPWR VGND sg13cmos5l_buf_1
X_11100__1801 _11100_/RESET_B VPWR VGND sg13cmos5l_tiehi
Xfanout176 _08535_/B _08506_/Y VPWR VGND sg13cmos5l_buf_1
Xfanout198 _08285_/B _08281_/B VPWR VGND sg13cmos5l_buf_1
XFILLER_90_807 VPWR VGND sg13cmos5l_fill_1
X_09729_ _09731_/B _09729_/A _09729_/B _09729_/C VPWR VGND sg13cmos5l_nand3_1
XFILLER_28_720 VPWR VGND sg13cmos5l_fill_1
XFILLER_16_926 VPWR VGND sg13cmos5l_decap_8
XFILLER_103_84 VPWR VGND sg13cmos5l_decap_8
XFILLER_63_33 VPWR VGND sg13cmos5l_fill_2
XFILLER_15_414 VPWR VGND sg13cmos5l_decap_8
XFILLER_63_66 VPWR VGND sg13cmos5l_decap_8
XFILLER_63_44 VPWR VGND sg13cmos5l_fill_2
XFILLER_43_778 VPWR VGND sg13cmos5l_decap_8
XFILLER_15_469 VPWR VGND sg13cmos5l_decap_8
X_11622_ _11622_/Q _11622_/CLK _11622_/D _11622_/RESET_B VPWR VGND sg13cmos5l_dfrbpq_1
X_11133__1768 _11133_/RESET_B VPWR VGND sg13cmos5l_tiehi
XFILLER_8_28 VPWR VGND sg13cmos5l_decap_8
X_11553_ _11553_/Q clkload23/A _11553_/D _11553_/RESET_B VPWR VGND sg13cmos5l_dfrbpq_1
XFILLER_7_602 VPWR VGND sg13cmos5l_fill_1
XFILLER_11_675 VPWR VGND sg13cmos5l_fill_1
X_11484_ _11484_/Q _11715_/CLK _11484_/D _11484_/RESET_B VPWR VGND sg13cmos5l_dfrbpq_1
X_10504_ _10525_/C _10504_/A _10504_/B VPWR VGND sg13cmos5l_xnor2_1
X_10435_ _10437_/C _06216_/A _09641_/A _10298_/A _10268_/A _10434_/X VPWR VGND sg13cmos5l_a221oi_1
XFILLER_6_178 VPWR VGND sg13cmos5l_fill_1
X_10366_ _10366_/Y _10366_/A _10366_/B VPWR VGND sg13cmos5l_xnor2_1
XFILLER_88_74 VPWR VGND sg13cmos5l_fill_2
X_10297_ _10462_/B _10297_/A _10297_/B VPWR VGND sg13cmos5l_xnor2_1
XFILLER_3_896 VPWR VGND sg13cmos5l_decap_8
XFILLER_2_351 VPWR VGND sg13cmos5l_decap_8
XFILLER_2_395 VPWR VGND sg13cmos5l_fill_1
XFILLER_38_517 VPWR VGND sg13cmos5l_decap_8
XFILLER_92_122 VPWR VGND sg13cmos5l_fill_1
XFILLER_77_196 VPWR VGND sg13cmos5l_decap_8
XFILLER_77_185 VPWR VGND sg13cmos5l_fill_1
X_11378__1520 _11378_/RESET_B VPWR VGND sg13cmos5l_tiehi
XFILLER_92_155 VPWR VGND sg13cmos5l_fill_2
X_11396__1498 _11396_/RESET_B VPWR VGND sg13cmos5l_tiehi
XFILLER_80_328 VPWR VGND sg13cmos5l_decap_4
XFILLER_22_907 VPWR VGND sg13cmos5l_fill_2
XFILLER_34_767 VPWR VGND sg13cmos5l_fill_2
XFILLER_61_597 VPWR VGND sg13cmos5l_fill_1
XFILLER_61_586 VPWR VGND sg13cmos5l_decap_8
X_11109__1792 _11109_/RESET_B VPWR VGND sg13cmos5l_tiehi
XFILLER_33_255 VPWR VGND sg13cmos5l_fill_1
XFILLER_33_277 VPWR VGND sg13cmos5l_decap_8
XFILLER_34_789 VPWR VGND sg13cmos5l_decap_4
X_06390_ _06390_/Y _06323_/Y _06390_/B VPWR VGND sg13cmos5l_nand2b_1
XFILLER_105_1023 VPWR VGND sg13cmos5l_decap_4
X_08060_ _08060_/Y _08060_/A _08078_/B VPWR VGND sg13cmos5l_nand2_1
X_07011_ _07011_/Y _07038_/B _07009_/Y _07010_/Y VPWR VGND sg13cmos5l_o21ai_1
X_11288__1613 _11288_/RESET_B VPWR VGND sg13cmos5l_tiehi
X_08962_ _08962_/Y _08962_/A VPWR VGND sg13cmos5l_inv_1
Xhold2504 _11675_/D _07051_/X VPWR VGND sg13cmos5l_dlygate4sd3_1
XFILLER_102_238 VPWR VGND sg13cmos5l_decap_8
X_07913_ _07913_/Y _07913_/A _07913_/B VPWR VGND sg13cmos5l_nor2_1
Xhold2537 _11625_/D _06880_/Y VPWR VGND sg13cmos5l_dlygate4sd3_1
Xhold2526 _06924_/A _11639_/Q VPWR VGND sg13cmos5l_dlygate4sd3_1
XFILLER_57_804 VPWR VGND sg13cmos5l_fill_1
X_08893_ _08893_/Y _08921_/A _08891_/A _08922_/A VPWR VGND sg13cmos5l_o21ai_1
Xhold2515 hold2515/X _11656_/Q VPWR VGND sg13cmos5l_dlygate4sd3_1
X_07844_ _07844_/Y _07844_/A _07844_/B VPWR VGND sg13cmos5l_nand2_1
XFILLER_69_675 VPWR VGND sg13cmos5l_decap_8
Xhold2548 hold2548/X _11417_/Q VPWR VGND sg13cmos5l_dlygate4sd3_1
Xhold2559 _07395_/A _10883_/Q VPWR VGND sg13cmos5l_dlygate4sd3_1
Xhold1836 _08464_/A _11317_/Q VPWR VGND sg13cmos5l_dlygate4sd3_1
Xhold1858 _08230_/A _11202_/Q VPWR VGND sg13cmos5l_dlygate4sd3_1
Xhold1847 _07976_/A _11078_/Q VPWR VGND sg13cmos5l_dlygate4sd3_1
Xhold1869 _07806_/A _10995_/Q VPWR VGND sg13cmos5l_dlygate4sd3_1
X_11031__894 _11031_/RESET_B VPWR VGND sg13cmos5l_tiehi
X_07775_ _10980_/D fanout59/X _07780_/B _07774_/Y VPWR VGND sg13cmos5l_a21oi_1
XFILLER_37_561 VPWR VGND sg13cmos5l_decap_8
XFILLER_17_15 VPWR VGND sg13cmos5l_fill_2
XFILLER_83_177 VPWR VGND sg13cmos5l_fill_1
XFILLER_24_200 VPWR VGND sg13cmos5l_fill_2
X_09514_ _09515_/C _09514_/A _09514_/B _09514_/C VPWR VGND sg13cmos5l_nand3_1
X_06726_ _06727_/B _06710_/Y _06726_/B VPWR VGND sg13cmos5l_nand2b_1
XFILLER_80_840 VPWR VGND sg13cmos5l_fill_2
XFILLER_52_553 VPWR VGND sg13cmos5l_fill_1
XFILLER_52_542 VPWR VGND sg13cmos5l_fill_2
XFILLER_52_531 VPWR VGND sg13cmos5l_decap_8
X_09445_ _09445_/X _11122_/Q _11090_/Q _11058_/Q _11026_/Q _09440_/B _09575_/S1 VPWR
+ VGND sg13cmos5l_mux4_1
X_06657_ _06657_/Y _06657_/A _06657_/B VPWR VGND sg13cmos5l_xnor2_1
XFILLER_25_756 VPWR VGND sg13cmos5l_decap_4
XFILLER_71_1000 VPWR VGND sg13cmos5l_decap_4
X_06588_ _06588_/X _06639_/A _06588_/B _06588_/C VPWR VGND sg13cmos5l_or3_1
X_09376_ _09376_/Y _09376_/A _09456_/B VPWR VGND sg13cmos5l_nor2_1
X_08327_ _11249_/D _08457_/A1 _08348_/B _08326_/Y VPWR VGND sg13cmos5l_o21ai_1
X_08258_ _11215_/D _08453_/A1 _08281_/B _08257_/Y VPWR VGND sg13cmos5l_a21oi_1
XFILLER_20_472 VPWR VGND sg13cmos5l_decap_8
XFILLER_21_995 VPWR VGND sg13cmos5l_fill_2
X_07209_ _07209_/Y _07210_/B _07185_/A _07237_/A2 VPWR VGND sg13cmos5l_a21oi_1
XFILLER_106_511 VPWR VGND sg13cmos5l_decap_8
X_10220_ _10222_/B _10220_/A _10835_/Q VPWR VGND sg13cmos5l_xnor2_1
X_08189_ _11181_/D _08319_/A1 _08198_/B _08188_/Y VPWR VGND sg13cmos5l_o21ai_1
XFILLER_106_588 VPWR VGND sg13cmos5l_decap_8
X_10151_ _10151_/Y _10157_/A1 hold2849/X _10150_/Y VPWR VGND sg13cmos5l_o21ai_1
XFILLER_58_22 VPWR VGND sg13cmos5l_fill_1
XFILLER_58_11 VPWR VGND sg13cmos5l_fill_2
XFILLER_88_940 VPWR VGND sg13cmos5l_fill_1
XFILLER_58_55 VPWR VGND sg13cmos5l_decap_8
XFILLER_0_866 VPWR VGND sg13cmos5l_decap_8
X_10082_ _10082_/X _06174_/A _10073_/B _10081_/Y VPWR VGND sg13cmos5l_a21o_1
XFILLER_102_761 VPWR VGND sg13cmos5l_fill_2
XFILLER_88_995 VPWR VGND sg13cmos5l_fill_2
XFILLER_75_601 VPWR VGND sg13cmos5l_decap_8
XFILLER_74_122 VPWR VGND sg13cmos5l_fill_1
XFILLER_59_174 VPWR VGND sg13cmos5l_fill_2
X_11671__1293 _11671_/RESET_B VPWR VGND sg13cmos5l_tiehi
X_10984_ _10984_/Q clkload51/A _10984_/D _10984_/RESET_B VPWR VGND sg13cmos5l_dfrbpq_1
XFILLER_74_199 VPWR VGND sg13cmos5l_decap_8
XFILLER_74_65 VPWR VGND sg13cmos5l_decap_8
X_11366__1535 _11366_/RESET_B VPWR VGND sg13cmos5l_tiehi
XFILLER_71_851 VPWR VGND sg13cmos5l_decap_4
XFILLER_43_531 VPWR VGND sg13cmos5l_decap_8
XFILLER_71_873 VPWR VGND sg13cmos5l_decap_8
XFILLER_70_350 VPWR VGND sg13cmos5l_fill_1
XFILLER_43_564 VPWR VGND sg13cmos5l_decap_8
XFILLER_90_42 VPWR VGND sg13cmos5l_decap_8
XFILLER_70_394 VPWR VGND sg13cmos5l_decap_8
XFILLER_15_299 VPWR VGND sg13cmos5l_fill_2
XFILLER_30_225 VPWR VGND sg13cmos5l_fill_2
X_11605_ _11605_/Q clkload29/A _11605_/D _11605_/RESET_B VPWR VGND sg13cmos5l_dfrbpq_1
XFILLER_11_450 VPWR VGND sg13cmos5l_fill_1
XFILLER_30_247 VPWR VGND sg13cmos5l_decap_4
XFILLER_30_269 VPWR VGND sg13cmos5l_decap_4
X_11536_ _11536_/Q clkload37/A _11536_/D _11536_/RESET_B VPWR VGND sg13cmos5l_dfrbpq_1
XFILLER_8_977 VPWR VGND sg13cmos5l_decap_8
X_11467_ _11467_/Q clkload15/A _11467_/D _11467_/RESET_B VPWR VGND sg13cmos5l_dfrbpq_1
XFILLER_99_95 VPWR VGND sg13cmos5l_decap_8
X_11398_ _11398_/Q _11528_/CLK _11398_/D _11398_/RESET_B VPWR VGND sg13cmos5l_dfrbpq_1
X_10418_ _10418_/Y _10419_/A _10419_/B _10453_/C VPWR VGND sg13cmos5l_a21oi_1
X_10349_ _10378_/B _10331_/A _10331_/B _10334_/A VPWR VGND sg13cmos5l_a21oi_1
XFILLER_97_258 VPWR VGND sg13cmos5l_fill_1
XFILLER_39_826 VPWR VGND sg13cmos5l_decap_8
XFILLER_39_815 VPWR VGND sg13cmos5l_fill_1
XFILLER_24_4 VPWR VGND sg13cmos5l_fill_1
X_05890_ _05890_/Y input2/X VPWR VGND sg13cmos5l_inv_1
XFILLER_39_837 VPWR VGND sg13cmos5l_decap_4
XFILLER_81_615 VPWR VGND sg13cmos5l_fill_1
XFILLER_65_144 VPWR VGND sg13cmos5l_fill_2
XFILLER_80_103 VPWR VGND sg13cmos5l_fill_1
X_07560_ _10907_/D _07629_/B fanout82/X _07554_/Y VPWR VGND sg13cmos5l_a21oi_1
XFILLER_80_136 VPWR VGND sg13cmos5l_decap_4
X_06511_ _06511_/X _10990_/Q _10958_/Q _09491_/S VPWR VGND sg13cmos5l_mux2_1
XFILLER_61_372 VPWR VGND sg13cmos5l_fill_1
XFILLER_55_1028 VPWR VGND sg13cmos5l_fill_1
XFILLER_55_1006 VPWR VGND sg13cmos5l_fill_2
X_09230_ _09729_/A _10267_/D _10848_/Q VPWR VGND sg13cmos5l_xnor2_1
XFILLER_22_715 VPWR VGND sg13cmos5l_fill_1
X_07491_ _07493_/B _10229_/A _07500_/D _11400_/Q VPWR VGND sg13cmos5l_a21oi_1
XFILLER_34_564 VPWR VGND sg13cmos5l_decap_8
X_06442_ _06443_/B _06442_/A _06442_/B VPWR VGND sg13cmos5l_nand2_1
XFILLER_22_759 VPWR VGND sg13cmos5l_fill_1
X_09161_ _09837_/B _10250_/A _10126_/B VPWR VGND sg13cmos5l_nand2_1
X_06373_ _06374_/C _06756_/A _06748_/A _06373_/C VPWR VGND sg13cmos5l_nand3_1
X_08112_ _08112_/Y _08112_/A _08112_/B VPWR VGND sg13cmos5l_nand2_1
X_09092_ _11449_/D _09090_/Y _09091_/Y _09084_/Y VPWR VGND sg13cmos5l_o21ai_1
X_08043_ _08043_/Y _08043_/A _08043_/B VPWR VGND sg13cmos5l_nor2_1
X_10858__1126 _10858_/RESET_B VPWR VGND sg13cmos5l_tiehi
X_11444__1402 _11444_/RESET_B VPWR VGND sg13cmos5l_tiehi
XFILLER_88_214 VPWR VGND sg13cmos5l_fill_1
X_09994_ _09994_/Y _09994_/A1 _09993_/Y _09989_/Y VPWR VGND sg13cmos5l_a21oi_1
XFILLER_103_536 VPWR VGND sg13cmos5l_decap_8
Xhold2301 _08507_/A _11338_/Q VPWR VGND sg13cmos5l_dlygate4sd3_1
XFILLER_88_247 VPWR VGND sg13cmos5l_decap_8
Xhold2312 _08393_/A _11282_/Q VPWR VGND sg13cmos5l_dlygate4sd3_1
XFILLER_97_781 VPWR VGND sg13cmos5l_fill_1
Xhold2334 _08305_/A _11239_/Q VPWR VGND sg13cmos5l_dlygate4sd3_1
Xhold2323 _08171_/A _11173_/Q VPWR VGND sg13cmos5l_dlygate4sd3_1
X_08945_ _08945_/Y _08955_/A _08942_/X _08953_/B _08944_/Y _09131_/A VPWR VGND sg13cmos5l_a221oi_1
Xhold2345 _07744_/A _10965_/Q VPWR VGND sg13cmos5l_dlygate4sd3_1
Xhold2389 _07917_/A _11049_/Q VPWR VGND sg13cmos5l_dlygate4sd3_1
Xhold2378 _07774_/A _10980_/Q VPWR VGND sg13cmos5l_dlygate4sd3_1
XFILLER_69_494 VPWR VGND sg13cmos5l_fill_2
XFILLER_56_111 VPWR VGND sg13cmos5l_decap_8
X_08876_ _08891_/B _08876_/A _08890_/B _08890_/D VPWR VGND sg13cmos5l_nand3_1
Xhold2367 _08515_/A _11342_/Q VPWR VGND sg13cmos5l_dlygate4sd3_1
Xhold2356 _08139_/A _11157_/Q VPWR VGND sg13cmos5l_dlygate4sd3_1
XFILLER_29_314 VPWR VGND sg13cmos5l_fill_1
XFILLER_29_325 VPWR VGND sg13cmos5l_decap_8
XFILLER_57_667 VPWR VGND sg13cmos5l_decap_8
XFILLER_56_155 VPWR VGND sg13cmos5l_fill_1
XFILLER_56_144 VPWR VGND sg13cmos5l_fill_2
XFILLER_56_133 VPWR VGND sg13cmos5l_decap_8
XFILLER_45_818 VPWR VGND sg13cmos5l_decap_8
X_07827_ _11005_/D fanout79/X _07826_/B _07826_/Y VPWR VGND sg13cmos5l_o21ai_1
XFILLER_85_998 VPWR VGND sg13cmos5l_decap_4
XFILLER_71_114 VPWR VGND sg13cmos5l_decap_8
X_07758_ _07758_/Y _07758_/A _07768_/B VPWR VGND sg13cmos5l_nor2_1
X_06709_ _06710_/B _06709_/A _06709_/B _06709_/C VPWR VGND sg13cmos5l_nor3_1
XFILLER_40_501 VPWR VGND sg13cmos5l_decap_8
X_07689_ _10938_/D fanout97/X _07694_/B _07688_/Y VPWR VGND sg13cmos5l_a21oi_1
XFILLER_25_553 VPWR VGND sg13cmos5l_fill_1
XFILLER_52_383 VPWR VGND sg13cmos5l_decap_4
XFILLER_13_748 VPWR VGND sg13cmos5l_fill_2
X_09428_ _09428_/Y _09395_/A _09423_/X _09427_/Y VPWR VGND sg13cmos5l_o21ai_1
XFILLER_100_63 VPWR VGND sg13cmos5l_decap_8
X_09359_ _09359_/Y _10959_/Q _09363_/B _09605_/B1 VPWR VGND sg13cmos5l_a21oi_1
XFILLER_12_258 VPWR VGND sg13cmos5l_decap_8
X_11321_ _11321_/Q clkload39/A _11321_/D _11321_/RESET_B VPWR VGND sg13cmos5l_dfrbpq_1
XFILLER_4_402 VPWR VGND sg13cmos5l_decap_8
X_11689__1275 _11689_/RESET_B VPWR VGND sg13cmos5l_tiehi
X_11252_ _11252_/Q clkload10/A _11252_/D _11252_/RESET_B VPWR VGND sg13cmos5l_dfrbpq_1
XFILLER_106_385 VPWR VGND sg13cmos5l_decap_8
X_10203_ _10204_/A _10202_/A _10202_/B _10353_/A VPWR VGND sg13cmos5l_o21ai_1
X_11183_ _11183_/Q clkload43/A _11183_/D _11183_/RESET_B VPWR VGND sg13cmos5l_dfrbpq_1
X_10134_ _10134_/X _06265_/A _10135_/B _10133_/Y VPWR VGND sg13cmos5l_a21o_1
XFILLER_48_612 VPWR VGND sg13cmos5l_fill_2
XFILLER_48_601 VPWR VGND sg13cmos5l_decap_8
XFILLER_102_591 VPWR VGND sg13cmos5l_fill_1
X_10065_ _10065_/Y _06523_/A hold2883/X _10088_/A2 VPWR VGND sg13cmos5l_a21oi_1
XFILLER_0_685 VPWR VGND sg13cmos5l_decap_8
XFILLER_0_696 VPWR VGND sg13cmos5l_fill_2
XFILLER_75_453 VPWR VGND sg13cmos5l_decap_8
Xhold2890 hold2890/X _11499_/Q VPWR VGND sg13cmos5l_dlygate4sd3_1
XFILLER_18_80 VPWR VGND sg13cmos5l_fill_1
XFILLER_28_391 VPWR VGND sg13cmos5l_fill_1
XFILLER_90_489 VPWR VGND sg13cmos5l_fill_1
X_10967_ _10967_/Q clkload17/A _10967_/D _10967_/RESET_B VPWR VGND sg13cmos5l_dfrbpq_1
XFILLER_31_501 VPWR VGND sg13cmos5l_fill_2
XFILLER_93_7 VPWR VGND sg13cmos5l_decap_8
X_10898_ _10898_/Q clkload17/A _10898_/D _10898_/RESET_B VPWR VGND sg13cmos5l_dfrbpq_1
XFILLER_31_512 VPWR VGND sg13cmos5l_decap_8
XFILLER_8_730 VPWR VGND sg13cmos5l_fill_1
XFILLER_12_781 VPWR VGND sg13cmos5l_fill_1
XFILLER_102_1004 VPWR VGND sg13cmos5l_decap_8
X_11519_ _11519_/Q clkload21/A _11519_/D _11519_/RESET_B VPWR VGND sg13cmos5l_dfrbpq_1
XFILLER_8_785 VPWR VGND sg13cmos5l_decap_8
Xfanout709 _08916_/B1 _10776_/A VPWR VGND sg13cmos5l_buf_1
XFILLER_86_718 VPWR VGND sg13cmos5l_fill_2
XFILLER_67_910 VPWR VGND sg13cmos5l_decap_8
X_06991_ _06991_/Y _07006_/B _11499_/Q VPWR VGND sg13cmos5l_nand2b_1
XFILLER_79_792 VPWR VGND sg13cmos5l_fill_1
X_11726__1228 _11726_/RESET_B VPWR VGND sg13cmos5l_tiehi
X_05942_ _06109_/B input19/X VPWR VGND sg13cmos5l_inv_1
X_08730_ _08731_/B _08730_/A _08730_/B VPWR VGND sg13cmos5l_nand2_1
X_11092__1809 _11092_/RESET_B VPWR VGND sg13cmos5l_tiehi
XFILLER_94_762 VPWR VGND sg13cmos5l_fill_2
XFILLER_94_751 VPWR VGND sg13cmos5l_decap_8
XFILLER_82_913 VPWR VGND sg13cmos5l_decap_4
X_08661_ _08817_/C _08801_/A _07463_/X _08667_/S VPWR VGND sg13cmos5l_mux2_1
X_05873_ _07479_/A _11398_/Q VPWR VGND sg13cmos5l_inv_1
XFILLER_15_0 VPWR VGND sg13cmos5l_fill_1
XFILLER_93_261 VPWR VGND sg13cmos5l_fill_2
X_07612_ _07612_/Y _07599_/A _08745_/B _07611_/Y VPWR VGND sg13cmos5l_a21oi_1
XFILLER_53_114 VPWR VGND sg13cmos5l_decap_8
XFILLER_53_103 VPWR VGND sg13cmos5l_fill_2
X_08592_ _08598_/B _08588_/Y _08589_/Y _08590_/Y _08591_/Y _06476_/A VPWR VGND sg13cmos5l_a221oi_1
XFILLER_82_957 VPWR VGND sg13cmos5l_decap_8
XFILLER_81_489 VPWR VGND sg13cmos5l_fill_2
XFILLER_35_873 VPWR VGND sg13cmos5l_fill_1
X_07543_ _07543_/Y _11407_/Q _07543_/B VPWR VGND sg13cmos5l_xnor2_1
XFILLER_50_821 VPWR VGND sg13cmos5l_decap_8
X_07474_ _07474_/Y _07493_/A _07470_/X _07479_/B _07473_/Y VPWR VGND sg13cmos5l_a22oi_1
X_06425_ _06425_/Y _06429_/A _06425_/B VPWR VGND sg13cmos5l_nor2_1
X_09213_ _09565_/A _09214_/A _10841_/Q VPWR VGND sg13cmos5l_nand2_1
X_09144_ _09144_/Y _09154_/A1 _09138_/B _09154_/B1 VPWR VGND sg13cmos5l_o21ai_1
X_06356_ _06356_/Y _06162_/Y _06650_/A _06658_/A VPWR VGND sg13cmos5l_a21oi_1
X_09075_ _09075_/X _09075_/A _09075_/B _09075_/C VPWR VGND sg13cmos5l_and3_1
X_06287_ _06287_/Y _07036_/A _09456_/A _07032_/A _09429_/A VPWR VGND sg13cmos5l_a22oi_1
X_08026_ _11102_/D fanout77/X _08033_/B _08025_/Y VPWR VGND sg13cmos5l_a21oi_1
Xhold2120 _07698_/A _10943_/Q VPWR VGND sg13cmos5l_dlygate4sd3_1
XFILLER_77_707 VPWR VGND sg13cmos5l_decap_8
X_09977_ _09977_/Y _09976_/A _09976_/B _10006_/A VPWR VGND sg13cmos5l_o21ai_1
Xhold2142 _08299_/A _11236_/Q VPWR VGND sg13cmos5l_dlygate4sd3_1
Xhold2153 _11575_/D _10759_/Y VPWR VGND sg13cmos5l_dlygate4sd3_1
X_08928_ _08929_/B _11386_/Q _08921_/B _08940_/A VPWR VGND sg13cmos5l_a21oi_1
X_11408__1474 _11408_/RESET_B VPWR VGND sg13cmos5l_tiehi
Xhold2164 _07768_/A _10977_/Q VPWR VGND sg13cmos5l_dlygate4sd3_1
Xhold2131 _07736_/A _10961_/Q VPWR VGND sg13cmos5l_dlygate4sd3_1
XFILLER_29_111 VPWR VGND sg13cmos5l_fill_1
XFILLER_57_442 VPWR VGND sg13cmos5l_decap_8
Xhold2197 _07746_/A _10966_/Q VPWR VGND sg13cmos5l_dlygate4sd3_1
Xhold2175 _07517_/A _10901_/Q VPWR VGND sg13cmos5l_dlygate4sd3_1
Xhold2186 _07883_/A _11032_/Q VPWR VGND sg13cmos5l_dlygate4sd3_1
XFILLER_73_935 VPWR VGND sg13cmos5l_decap_8
XFILLER_57_486 VPWR VGND sg13cmos5l_fill_2
X_08859_ _08864_/A _11383_/Q _08876_/A VPWR VGND sg13cmos5l_xnor2_1
XFILLER_44_147 VPWR VGND sg13cmos5l_decap_4
XFILLER_26_840 VPWR VGND sg13cmos5l_fill_1
X_10821_ _10821_/Q clkload47/A _10821_/D _10821_/RESET_B VPWR VGND sg13cmos5l_dfrbpq_1
X_10752_ _10752_/Y _05948_/Y _06879_/B _06875_/B VPWR VGND sg13cmos5l_o21ai_1
XFILLER_71_11 VPWR VGND sg13cmos5l_fill_2
XFILLER_13_545 VPWR VGND sg13cmos5l_decap_4
X_10683_ _10683_/Y _10654_/A _10680_/Y _10682_/Y VPWR VGND sg13cmos5l_a21oi_1
XFILLER_71_66 VPWR VGND sg13cmos5l_decap_4
XFILLER_9_527 VPWR VGND sg13cmos5l_decap_8
XFILLER_9_538 VPWR VGND sg13cmos5l_fill_2
X_11304_ _11304_/Q clkload56/A _11304_/D _11304_/RESET_B VPWR VGND sg13cmos5l_dfrbpq_1
X_11235_ _11235_/Q clkload45/A _11235_/D _11235_/RESET_B VPWR VGND sg13cmos5l_dfrbpq_1
XFILLER_84_1010 VPWR VGND sg13cmos5l_fill_1
XFILLER_106_182 VPWR VGND sg13cmos5l_decap_8
X_11166_ _11166_/Q clkload52/A _11166_/D _11166_/RESET_B VPWR VGND sg13cmos5l_dfrbpq_1
XFILLER_68_718 VPWR VGND sg13cmos5l_fill_1
XFILLER_96_63 VPWR VGND sg13cmos5l_decap_8
XFILLER_95_548 VPWR VGND sg13cmos5l_decap_8
X_10117_ _10117_/Y _10584_/A _10117_/B VPWR VGND sg13cmos5l_nor2_1
X_11097_ _11097_/Q clkload40/A _11097_/D _11097_/RESET_B VPWR VGND sg13cmos5l_dfrbpq_1
X_10048_ _10048_/Y _11304_/Q _10019_/B _10047_/Y VPWR VGND sg13cmos5l_o21ai_1
XFILLER_76_740 VPWR VGND sg13cmos5l_decap_8
XFILLER_49_976 VPWR VGND sg13cmos5l_fill_2
XFILLER_49_965 VPWR VGND sg13cmos5l_fill_2
X_10842__1158 _10842_/RESET_B VPWR VGND sg13cmos5l_tiehi
XFILLER_91_754 VPWR VGND sg13cmos5l_fill_2
XFILLER_64_979 VPWR VGND sg13cmos5l_fill_1
X_06210_ _06756_/A _10581_/A _06211_/B VPWR VGND sg13cmos5l_and2_1
X_07190_ _07190_/Y _10776_/A _07190_/B _07190_/C VPWR VGND sg13cmos5l_nand3_1
X_06141_ _06141_/Y _11573_/Q _06141_/B _06141_/C _06141_/D VPWR VGND sg13cmos5l_nor4_1
XFILLER_8_582 VPWR VGND sg13cmos5l_fill_2
X_11146__1755 _11146_/RESET_B VPWR VGND sg13cmos5l_tiehi
X_06072_ _06092_/C _06072_/A _06072_/B VPWR VGND sg13cmos5l_nor2_1
XFILLER_104_119 VPWR VGND sg13cmos5l_decap_8
X_09900_ _09900_/X _10043_/C1 _09899_/X _10044_/A VPWR VGND sg13cmos5l_a21o_1
Xfanout506 _08811_/B _10704_/B VPWR VGND sg13cmos5l_buf_1
XFILLER_101_804 VPWR VGND sg13cmos5l_fill_2
XFILLER_99_898 VPWR VGND sg13cmos5l_fill_1
XFILLER_99_887 VPWR VGND sg13cmos5l_decap_8
XFILLER_98_342 VPWR VGND sg13cmos5l_fill_1
Xfanout528 _07599_/A _07448_/A VPWR VGND sg13cmos5l_buf_1
Xfanout539 _08694_/A _07251_/X VPWR VGND sg13cmos5l_buf_1
X_09831_ _09831_/Y _10295_/A _09970_/B _09910_/B VPWR VGND sg13cmos5l_o21ai_1
Xfanout517 _08948_/B fanout518/X VPWR VGND sg13cmos5l_buf_1
XFILLER_98_397 VPWR VGND sg13cmos5l_fill_1
XFILLER_98_386 VPWR VGND sg13cmos5l_fill_2
X_09762_ _09762_/Y _11134_/Q _09823_/B _09990_/S1 VPWR VGND sg13cmos5l_a21oi_1
X_11361__1540 _11361_/RESET_B VPWR VGND sg13cmos5l_tiehi
X_06974_ _06974_/Y _06175_/A _07006_/A _06990_/B1 _11487_/Q VPWR VGND sg13cmos5l_a22oi_1
XFILLER_100_369 VPWR VGND sg13cmos5l_decap_8
XFILLER_100_336 VPWR VGND sg13cmos5l_decap_4
X_08713_ _08973_/A _08713_/A _08713_/B VPWR VGND sg13cmos5l_nand2_1
X_05925_ _06274_/B _09405_/A VPWR VGND sg13cmos5l_inv_1
XFILLER_55_913 VPWR VGND sg13cmos5l_decap_4
X_09693_ _09694_/B _09693_/A1 _09688_/X _09692_/Y VPWR VGND sg13cmos5l_o21ai_1
XFILLER_66_294 VPWR VGND sg13cmos5l_decap_8
X_08644_ _11389_/D _11703_/D hold2826/X _08645_/S VPWR VGND sg13cmos5l_mux2_1
XFILLER_27_648 VPWR VGND sg13cmos5l_decap_4
X_08575_ _08575_/X _11114_/Q _11082_/Q _11050_/Q _11018_/Q _08573_/S _08599_/S1 VPWR
+ VGND sg13cmos5l_mux4_1
XFILLER_82_787 VPWR VGND sg13cmos5l_fill_2
XFILLER_81_242 VPWR VGND sg13cmos5l_fill_1
XFILLER_70_905 VPWR VGND sg13cmos5l_decap_4
XFILLER_42_629 VPWR VGND sg13cmos5l_fill_2
XFILLER_63_990 VPWR VGND sg13cmos5l_fill_1
X_07526_ _07526_/Y _07526_/A _07526_/B VPWR VGND sg13cmos5l_nor2_1
XFILLER_23_832 VPWR VGND sg13cmos5l_decap_4
XFILLER_50_695 VPWR VGND sg13cmos5l_fill_1
X_07457_ _07457_/X _11522_/Q _10797_/Q _07497_/A VPWR VGND sg13cmos5l_mux2_1
XFILLER_23_887 VPWR VGND sg13cmos5l_fill_1
X_06408_ _06408_/Y _10597_/A _06761_/A _06408_/C VPWR VGND sg13cmos5l_nand3_1
X_07388_ _07388_/Y _06322_/B _07400_/A2 _07387_/Y VPWR VGND sg13cmos5l_a21oi_1
XFILLER_10_548 VPWR VGND sg13cmos5l_decap_4
X_06339_ _06339_/Y _06144_/A _06144_/B _06272_/Y _11592_/Q _06338_/X VPWR VGND sg13cmos5l_a221oi_1
X_09127_ _09148_/A _09150_/A _09127_/B VPWR VGND sg13cmos5l_xnor2_1
XFILLER_41_58 VPWR VGND sg13cmos5l_decap_8
X_09058_ _09058_/Y _09069_/D _09058_/B VPWR VGND sg13cmos5l_xnor2_1
X_08009_ _08009_/Y _08009_/A _08031_/B VPWR VGND sg13cmos5l_nor2_1
XFILLER_2_703 VPWR VGND sg13cmos5l_fill_2
Xheichips26_RiMaX_1823 uio_oe[8] VPWR VGND sg13cmos5l_tiehi
X_10935__1047 _10935_/RESET_B VPWR VGND sg13cmos5l_tiehi
X_11020_ _11020_/Q _11352_/CLK _11020_/D _11020_/RESET_B VPWR VGND sg13cmos5l_dfrbpq_1
XFILLER_77_548 VPWR VGND sg13cmos5l_decap_4
XFILLER_77_526 VPWR VGND sg13cmos5l_fill_2
XFILLER_77_515 VPWR VGND sg13cmos5l_fill_1
XFILLER_106_84 VPWR VGND sg13cmos5l_decap_8
XFILLER_103_196 VPWR VGND sg13cmos5l_decap_8
XFILLER_77_559 VPWR VGND sg13cmos5l_fill_1
XFILLER_85_570 VPWR VGND sg13cmos5l_fill_2
XFILLER_66_77 VPWR VGND sg13cmos5l_fill_2
XFILLER_18_615 VPWR VGND sg13cmos5l_fill_1
XFILLER_73_754 VPWR VGND sg13cmos5l_decap_4
XFILLER_72_231 VPWR VGND sg13cmos5l_decap_4
XFILLER_17_125 VPWR VGND sg13cmos5l_fill_2
XFILLER_17_136 VPWR VGND sg13cmos5l_fill_2
XFILLER_72_264 VPWR VGND sg13cmos5l_decap_8
XFILLER_61_916 VPWR VGND sg13cmos5l_fill_1
XFILLER_61_905 VPWR VGND sg13cmos5l_decap_8
XFILLER_17_147 VPWR VGND sg13cmos5l_fill_2
XFILLER_17_169 VPWR VGND sg13cmos5l_fill_1
X_11224__1677 _11224_/RESET_B VPWR VGND sg13cmos5l_tiehi
X_10804_ _10804_/Q clkload15/A _10804_/D _10804_/RESET_B VPWR VGND sg13cmos5l_dfrbpq_1
XFILLER_13_331 VPWR VGND sg13cmos5l_decap_8
X_10735_ _11562_/D _10783_/B _10735_/B VPWR VGND sg13cmos5l_nand2_1
XFILLER_13_375 VPWR VGND sg13cmos5l_fill_1
XFILLER_15_81 VPWR VGND sg13cmos5l_fill_2
X_10666_ _10666_/Y _10639_/A _10652_/X _10665_/Y VPWR VGND sg13cmos5l_a21oi_1
XFILLER_12_1015 VPWR VGND sg13cmos5l_decap_8
X_10597_ _10622_/B _10597_/A _10597_/B VPWR VGND sg13cmos5l_xnor2_1
XFILLER_5_574 VPWR VGND sg13cmos5l_fill_1
X_11760__921 _11760_/RESET_B VPWR VGND sg13cmos5l_tiehi
X_11218_ _11218_/Q clkload9/A _11218_/D _11218_/RESET_B VPWR VGND sg13cmos5l_dfrbpq_1
X_11149_ _11149_/Q clkload10/A _11149_/D _11149_/RESET_B VPWR VGND sg13cmos5l_dfrbpq_1
XFILLER_48_294 VPWR VGND sg13cmos5l_decap_8
X_06690_ _06690_/Y _06690_/A _06690_/B VPWR VGND sg13cmos5l_xnor2_1
XFILLER_63_264 VPWR VGND sg13cmos5l_fill_1
X_08360_ _08360_/Y _08360_/A _08368_/B VPWR VGND sg13cmos5l_nand2_1
XFILLER_51_415 VPWR VGND sg13cmos5l_fill_1
X_07311_ _07311_/Y _07311_/A _07311_/B VPWR VGND sg13cmos5l_nor2_1
X_08291_ _08291_/Y _08291_/A _08301_/B VPWR VGND sg13cmos5l_nor2_1
X_11684__1280 _11684_/RESET_B VPWR VGND sg13cmos5l_tiehi
X_07242_ _10855_/D _07244_/A _07242_/B VPWR VGND sg13cmos5l_nand2_1
XFILLER_20_835 VPWR VGND sg13cmos5l_fill_2
XFILLER_20_868 VPWR VGND sg13cmos5l_decap_8
X_07173_ _07173_/Y _08774_/A _11634_/Q _07185_/B _11692_/Q _07182_/C1 VPWR VGND sg13cmos5l_a221oi_1
X_06124_ _06124_/X input19/X _06124_/B VPWR VGND sg13cmos5l_and2_1
X_11535__1503 _11535_/RESET_B VPWR VGND sg13cmos5l_tiehi
XFILLER_11_28 VPWR VGND sg13cmos5l_decap_8
X_06055_ _06524_/C _11371_/Q _11370_/Q VPWR VGND sg13cmos5l_or2_1
XFILLER_99_673 VPWR VGND sg13cmos5l_decap_4
Xfanout303 _07850_/B _07844_/B VPWR VGND sg13cmos5l_buf_1
Xfanout314 _08512_/A1 _08317_/A1 VPWR VGND sg13cmos5l_buf_1
XFILLER_98_161 VPWR VGND sg13cmos5l_decap_8
X_09814_ _09814_/X _11008_/Q _10976_/Q _09814_/S VPWR VGND sg13cmos5l_mux2_1
Xfanout347 _09902_/A _09933_/A VPWR VGND sg13cmos5l_buf_1
X_11302__1599 _11302_/RESET_B VPWR VGND sg13cmos5l_tiehi
Xfanout336 _09607_/A2 _06477_/Y VPWR VGND sg13cmos5l_buf_1
Xfanout325 _07062_/S _07059_/B1 VPWR VGND sg13cmos5l_buf_1
XFILLER_100_133 VPWR VGND sg13cmos5l_decap_8
Xfanout369 _10158_/A2 _10057_/Y VPWR VGND sg13cmos5l_buf_1
Xfanout358 _10548_/B _10675_/B VPWR VGND sg13cmos5l_buf_1
XFILLER_86_389 VPWR VGND sg13cmos5l_fill_2
XFILLER_55_710 VPWR VGND sg13cmos5l_fill_2
X_06957_ _06957_/X hold2620/X _06956_/Y _07389_/B VPWR VGND sg13cmos5l_mux2_1
X_09745_ _09751_/B _09745_/A _09745_/B VPWR VGND sg13cmos5l_nor2_1
XFILLER_28_913 VPWR VGND sg13cmos5l_decap_4
XFILLER_28_935 VPWR VGND sg13cmos5l_fill_1
X_06888_ _11694_/D _10180_/A _07178_/A _07098_/B VPWR VGND sg13cmos5l_mux2_1
XFILLER_55_743 VPWR VGND sg13cmos5l_fill_2
XFILLER_54_220 VPWR VGND sg13cmos5l_fill_1
X_09676_ _09676_/Y _09236_/C _09674_/Y _09675_/Y VPWR VGND sg13cmos5l_o21ai_1
X_05908_ _10423_/B _10479_/C VPWR VGND sg13cmos5l_inv_1
X_08627_ _08628_/C hold2463/X _11391_/Q _08627_/C VPWR VGND sg13cmos5l_nand3b_1
XFILLER_27_445 VPWR VGND sg13cmos5l_decap_8
XFILLER_54_297 VPWR VGND sg13cmos5l_fill_1
X_08558_ _11363_/D fanout61/X _08569_/B _08557_/Y VPWR VGND sg13cmos5l_a21oi_1
XFILLER_51_971 VPWR VGND sg13cmos5l_decap_8
X_08489_ _11329_/D fanout68/X _08488_/B _08488_/Y VPWR VGND sg13cmos5l_o21ai_1
XFILLER_11_824 VPWR VGND sg13cmos5l_fill_1
XFILLER_22_150 VPWR VGND sg13cmos5l_fill_2
XFILLER_23_673 VPWR VGND sg13cmos5l_decap_8
X_07509_ _07509_/Y _11402_/Q _07521_/D VPWR VGND sg13cmos5l_xnor2_1
XFILLER_52_68 VPWR VGND sg13cmos5l_decap_4
X_10520_ _10520_/Y _10570_/A _10535_/B VPWR VGND sg13cmos5l_nand2b_1
X_10451_ _10451_/Y _10449_/Y _10450_/Y _10445_/Y VPWR VGND sg13cmos5l_o21ai_1
XFILLER_6_305 VPWR VGND sg13cmos5l_fill_2
XFILLER_6_338 VPWR VGND sg13cmos5l_decap_8
X_10382_ _10382_/Y _11404_/Q _10841_/Q VPWR VGND sg13cmos5l_nand2_1
XFILLER_2_544 VPWR VGND sg13cmos5l_decap_8
XFILLER_105_995 VPWR VGND sg13cmos5l_decap_8
XFILLER_89_161 VPWR VGND sg13cmos5l_decap_4
X_11003_ _11003_/Q _11355_/CLK _11003_/D _11003_/RESET_B VPWR VGND sg13cmos5l_dfrbpq_1
X_10991__991 _10991_/RESET_B VPWR VGND sg13cmos5l_tiehi
XFILLER_2_599 VPWR VGND sg13cmos5l_fill_2
XFILLER_89_194 VPWR VGND sg13cmos5l_fill_1
XFILLER_77_87 VPWR VGND sg13cmos5l_fill_1
XFILLER_93_838 VPWR VGND sg13cmos5l_decap_4
XFILLER_93_42 VPWR VGND sg13cmos5l_decap_8
XFILLER_46_754 VPWR VGND sg13cmos5l_decap_8
XFILLER_61_713 VPWR VGND sg13cmos5l_decap_4
XFILLER_60_212 VPWR VGND sg13cmos5l_decap_8
XFILLER_45_275 VPWR VGND sg13cmos5l_fill_1
XFILLER_45_264 VPWR VGND sg13cmos5l_decap_8
XFILLER_33_415 VPWR VGND sg13cmos5l_fill_2
XFILLER_33_437 VPWR VGND sg13cmos5l_fill_2
XFILLER_60_267 VPWR VGND sg13cmos5l_decap_8
X_11767_ _11767_/Q _11767_/CLK _11767_/D _11767_/RESET_B VPWR VGND sg13cmos5l_dfrbpq_1
XFILLER_13_150 VPWR VGND sg13cmos5l_fill_2
X_10718_ _10730_/B _10731_/B _10731_/C VPWR VGND sg13cmos5l_nor2_1
XFILLER_9_143 VPWR VGND sg13cmos5l_decap_8
X_11698_ _11698_/Q clkload19/A _11698_/D _11698_/RESET_B VPWR VGND sg13cmos5l_dfrbpq_1
X_10649_ _10665_/A _11421_/Q _10858_/Q VPWR VGND sg13cmos5l_nand2_1
XFILLER_6_861 VPWR VGND sg13cmos5l_fill_1
XFILLER_54_4 VPWR VGND sg13cmos5l_fill_2
XFILLER_6_894 VPWR VGND sg13cmos5l_decap_8
XFILLER_96_621 VPWR VGND sg13cmos5l_decap_4
Xhold2719 _06051_/A _11758_/Q VPWR VGND sg13cmos5l_dlygate4sd3_1
Xhold2708 _10837_/D _07200_/Y VPWR VGND sg13cmos5l_dlygate4sd3_1
XFILLER_69_835 VPWR VGND sg13cmos5l_decap_8
X_07860_ _11020_/D _08512_/A1 _07877_/B _07859_/Y VPWR VGND sg13cmos5l_a21oi_1
X_07791_ _10987_/D _08053_/A1 _07846_/B _07790_/Y VPWR VGND sg13cmos5l_o21ai_1
XFILLER_96_698 VPWR VGND sg13cmos5l_decap_8
XFILLER_95_153 VPWR VGND sg13cmos5l_decap_8
X_06811_ _06811_/Y _06811_/A _10762_/S VPWR VGND sg13cmos5l_nand2_1
X_11564__1421 _11564_/RESET_B VPWR VGND sg13cmos5l_tiehi
XFILLER_37_743 VPWR VGND sg13cmos5l_decap_4
X_09530_ _09530_/Y _11285_/Q _09850_/A2 _09529_/Y VPWR VGND sg13cmos5l_o21ai_1
X_06742_ _06742_/Y _10252_/B _06628_/B _06425_/B VPWR VGND sg13cmos5l_o21ai_1
XFILLER_37_754 VPWR VGND sg13cmos5l_decap_8
X_09461_ _11464_/D _09348_/A _09460_/A _09455_/Y _09460_/Y VPWR VGND sg13cmos5l_a22oi_1
XFILLER_91_370 VPWR VGND sg13cmos5l_decap_4
XFILLER_52_735 VPWR VGND sg13cmos5l_fill_1
XFILLER_36_275 VPWR VGND sg13cmos5l_decap_8
X_06673_ _06673_/Y _06673_/A _06673_/B VPWR VGND sg13cmos5l_xnor2_1
X_08412_ _11291_/D fanout82/X _08431_/B _08411_/Y VPWR VGND sg13cmos5l_a21oi_1
X_09392_ _09392_/Y _09388_/Y _09389_/Y _09390_/Y _09391_/Y _09574_/A1 VPWR VGND sg13cmos5l_a221oi_1
X_08343_ _11257_/D fanout98/X _08358_/B _08342_/Y VPWR VGND sg13cmos5l_o21ai_1
X_08274_ _11223_/D _08339_/A1 _08273_/B _08273_/Y VPWR VGND sg13cmos5l_a21oi_1
XFILLER_20_621 VPWR VGND sg13cmos5l_decap_8
X_07225_ _07225_/Y _07225_/A1 _11388_/Q _07227_/B1 hold2678/X _07225_/C1 VPWR VGND
+ sg13cmos5l_a221oi_1
XFILLER_20_687 VPWR VGND sg13cmos5l_decap_8
X_07156_ _11743_/D _05878_/Y _07160_/A2 _07155_/Y VPWR VGND sg13cmos5l_a21oi_1
XFILLER_105_203 VPWR VGND sg13cmos5l_decap_8
X_07087_ _11697_/D hold2834/X _06820_/B _07088_/S VPWR VGND sg13cmos5l_mux2_1
X_06107_ _06108_/B _06132_/B _06134_/A _06107_/S VPWR VGND sg13cmos5l_mux2_1
X_06038_ _06041_/B _11593_/Q _11617_/Q _06038_/C VPWR VGND sg13cmos5l_nor3_1
Xfanout111 _10771_/B _08633_/S VPWR VGND sg13cmos5l_buf_1
Xfanout122 _08478_/B _08470_/B VPWR VGND sg13cmos5l_buf_1
Xfanout100 _08536_/A1 _08471_/A1 VPWR VGND sg13cmos5l_buf_1
Xfanout155 _08329_/A1 _07494_/Y VPWR VGND sg13cmos5l_buf_1
Xfanout144 _07942_/B _07948_/B VPWR VGND sg13cmos5l_buf_1
Xfanout133 _08228_/B _08216_/B VPWR VGND sg13cmos5l_buf_1
XFILLER_102_976 VPWR VGND sg13cmos5l_decap_8
XFILLER_101_475 VPWR VGND sg13cmos5l_decap_8
Xfanout177 _08559_/B _08565_/B VPWR VGND sg13cmos5l_buf_1
Xfanout188 _08429_/B _08435_/B VPWR VGND sg13cmos5l_buf_1
XFILLER_59_378 VPWR VGND sg13cmos5l_decap_8
XFILLER_59_367 VPWR VGND sg13cmos5l_fill_1
XFILLER_59_356 VPWR VGND sg13cmos5l_decap_8
Xfanout199 _08281_/B _08283_/B VPWR VGND sg13cmos5l_buf_1
XFILLER_47_529 VPWR VGND sg13cmos5l_decap_8
Xfanout166 _07317_/B _06955_/Y VPWR VGND sg13cmos5l_buf_1
XFILLER_101_486 VPWR VGND sg13cmos5l_fill_1
XFILLER_68_890 VPWR VGND sg13cmos5l_fill_1
X_09728_ _11474_/D _09613_/A _09751_/A _09706_/Y _09727_/Y VPWR VGND sg13cmos5l_a22oi_1
XFILLER_28_743 VPWR VGND sg13cmos5l_decap_8
X_07989_ _07989_/Y _07989_/A _08007_/B VPWR VGND sg13cmos5l_nor2_1
XFILLER_28_776 VPWR VGND sg13cmos5l_decap_8
XFILLER_103_63 VPWR VGND sg13cmos5l_decap_8
X_09659_ _09659_/X _11258_/Q _11226_/Q _11194_/Q _11162_/Q _09659_/S0 _09659_/S1 VPWR
+ VGND sg13cmos5l_mux4_1
XFILLER_70_554 VPWR VGND sg13cmos5l_fill_1
X_11524__1135 _11524_/RESET_B VPWR VGND sg13cmos5l_tiehi
X_10885__1097 _10885_/RESET_B VPWR VGND sg13cmos5l_tiehi
XFILLER_15_459 VPWR VGND sg13cmos5l_fill_1
X_11621_ _11621_/Q clkload30/A _11621_/D _11621_/RESET_B VPWR VGND sg13cmos5l_dfrbpq_1
XFILLER_63_89 VPWR VGND sg13cmos5l_decap_8
X_11141__1760 _11141_/RESET_B VPWR VGND sg13cmos5l_tiehi
XFILLER_42_256 VPWR VGND sg13cmos5l_fill_1
XFILLER_8_18 VPWR VGND sg13cmos5l_decap_4
XFILLER_11_610 VPWR VGND sg13cmos5l_fill_1
XFILLER_23_481 VPWR VGND sg13cmos5l_decap_8
X_11552_ _11552_/Q clkload23/A _11552_/D _11552_/RESET_B VPWR VGND sg13cmos5l_dfrbpq_1
XFILLER_11_654 VPWR VGND sg13cmos5l_decap_8
X_11483_ _11483_/Q _11715_/CLK _11483_/D _11483_/RESET_B VPWR VGND sg13cmos5l_dfrbpq_1
X_10503_ _11537_/D _10503_/A _10503_/B VPWR VGND sg13cmos5l_and2_1
XFILLER_7_647 VPWR VGND sg13cmos5l_decap_4
X_10434_ _10434_/X _10434_/A _10434_/B VPWR VGND sg13cmos5l_and2_1
X_10365_ _10366_/B _10365_/A _10365_/B VPWR VGND sg13cmos5l_nor2_1
XFILLER_3_820 VPWR VGND sg13cmos5l_fill_1
XFILLER_88_42 VPWR VGND sg13cmos5l_decap_8
XFILLER_105_781 VPWR VGND sg13cmos5l_decap_8
XFILLER_97_429 VPWR VGND sg13cmos5l_decap_8
XFILLER_78_621 VPWR VGND sg13cmos5l_fill_2
XFILLER_78_610 VPWR VGND sg13cmos5l_decap_8
X_10296_ _10296_/Y _11474_/Q _10296_/B _10296_/C VPWR VGND sg13cmos5l_nand3_1
XFILLER_77_142 VPWR VGND sg13cmos5l_decap_4
XFILLER_66_805 VPWR VGND sg13cmos5l_fill_1
XFILLER_65_326 VPWR VGND sg13cmos5l_decap_8
XFILLER_18_253 VPWR VGND sg13cmos5l_fill_1
XFILLER_33_212 VPWR VGND sg13cmos5l_fill_2
XFILLER_34_713 VPWR VGND sg13cmos5l_decap_8
XFILLER_61_532 VPWR VGND sg13cmos5l_fill_1
XFILLER_21_407 VPWR VGND sg13cmos5l_fill_1
XFILLER_21_418 VPWR VGND sg13cmos5l_fill_1
XFILLER_105_1002 VPWR VGND sg13cmos5l_decap_8
X_10930__1052 _10930_/RESET_B VPWR VGND sg13cmos5l_tiehi
X_07010_ _07010_/Y _07010_/A _07038_/B VPWR VGND sg13cmos5l_nand2_1
XFILLER_103_729 VPWR VGND sg13cmos5l_decap_4
XFILLER_102_217 VPWR VGND sg13cmos5l_decap_8
XFILLER_69_610 VPWR VGND sg13cmos5l_fill_2
X_08961_ _08962_/A _08961_/A _08961_/B _08964_/C VPWR VGND sg13cmos5l_and3_1
Xhold2527 _11639_/D _06926_/Y VPWR VGND sg13cmos5l_dlygate4sd3_1
X_07912_ _11046_/D fanout56/X _07911_/B _07911_/Y VPWR VGND sg13cmos5l_a21oi_1
X_11183__1718 _11183_/RESET_B VPWR VGND sg13cmos5l_tiehi
X_08892_ _08892_/Y _08897_/B _08889_/X _08891_/Y _10719_/B _10719_/C VPWR VGND sg13cmos5l_a221oi_1
Xhold2538 _07401_/A _10884_/Q VPWR VGND sg13cmos5l_dlygate4sd3_1
Xhold2505 hold2505/X _11662_/Q VPWR VGND sg13cmos5l_dlygate4sd3_1
Xhold2516 _11656_/D _06977_/X VPWR VGND sg13cmos5l_dlygate4sd3_1
Xhold2549 _08749_/A _08748_/Y VPWR VGND sg13cmos5l_dlygate4sd3_1
XFILLER_56_304 VPWR VGND sg13cmos5l_decap_8
X_07843_ _11013_/D fanout57/X _07844_/B _07842_/Y VPWR VGND sg13cmos5l_o21ai_1
Xhold1848 _07840_/A _11012_/Q VPWR VGND sg13cmos5l_dlygate4sd3_1
Xhold1837 _08444_/A _11307_/Q VPWR VGND sg13cmos5l_dlygate4sd3_1
XFILLER_68_175 VPWR VGND sg13cmos5l_fill_2
Xhold1859 _08218_/A _11196_/Q VPWR VGND sg13cmos5l_dlygate4sd3_1
X_07774_ _07774_/Y _07774_/A _07780_/B VPWR VGND sg13cmos5l_nor2_1
XFILLER_56_348 VPWR VGND sg13cmos5l_decap_8
XFILLER_71_329 VPWR VGND sg13cmos5l_decap_4
XFILLER_71_318 VPWR VGND sg13cmos5l_fill_2
XFILLER_52_510 VPWR VGND sg13cmos5l_decap_8
X_09513_ _09515_/B _09514_/B _09514_/C _09514_/A VPWR VGND sg13cmos5l_a21o_1
XFILLER_25_702 VPWR VGND sg13cmos5l_decap_4
X_06725_ _06738_/B _06370_/Y _06718_/B _06378_/Y VPWR VGND sg13cmos5l_a21oi_1
X_09444_ _09444_/Y _09440_/Y _09441_/Y _09572_/B1 VPWR VGND sg13cmos5l_a21oi_1
X_06656_ _06657_/B _06662_/A _06653_/Y _06655_/Y VPWR VGND sg13cmos5l_a21oi_1
XFILLER_52_587 VPWR VGND sg13cmos5l_fill_1
XFILLER_24_278 VPWR VGND sg13cmos5l_decap_8
X_11735__1210 _11735_/RESET_B VPWR VGND sg13cmos5l_tiehi
X_06587_ _10795_/D _06588_/B _06584_/Y _06586_/Y VPWR VGND sg13cmos5l_o21ai_1
X_09375_ _09375_/Y _09375_/A _09375_/B VPWR VGND sg13cmos5l_nor2_1
X_08326_ _08326_/Y _08326_/A _08348_/B VPWR VGND sg13cmos5l_nand2_1
X_08257_ _08257_/Y _08257_/A _08281_/B VPWR VGND sg13cmos5l_nor2_1
X_07208_ _07208_/Y _07208_/A _07208_/B VPWR VGND sg13cmos5l_nand2_1
X_08188_ _08188_/Y _08188_/A _08198_/B VPWR VGND sg13cmos5l_nand2_1
X_07139_ _07139_/Y hold2792/X _07142_/A2 _08627_/C VPWR VGND sg13cmos5l_o21ai_1
XFILLER_106_567 VPWR VGND sg13cmos5l_decap_8
XFILLER_79_407 VPWR VGND sg13cmos5l_decap_8
X_11630__1336 _11630_/RESET_B VPWR VGND sg13cmos5l_tiehi
X_10150_ _10150_/Y _10024_/B _10024_/C _10157_/A1 VPWR VGND sg13cmos5l_o21ai_1
XFILLER_0_801 VPWR VGND sg13cmos5l_decap_8
XFILLER_58_45 VPWR VGND sg13cmos5l_fill_1
XFILLER_58_34 VPWR VGND sg13cmos5l_decap_8
XFILLER_0_845 VPWR VGND sg13cmos5l_decap_8
X_10081_ _10081_/Y _10070_/A _09453_/X _10080_/Y VPWR VGND sg13cmos5l_a21oi_1
XFILLER_59_153 VPWR VGND sg13cmos5l_decap_8
X_11159__1742 _11159_/RESET_B VPWR VGND sg13cmos5l_tiehi
XFILLER_75_646 VPWR VGND sg13cmos5l_decap_8
XFILLER_75_624 VPWR VGND sg13cmos5l_fill_1
XFILLER_90_605 VPWR VGND sg13cmos5l_fill_1
XFILLER_63_808 VPWR VGND sg13cmos5l_fill_1
X_10983_ _10983_/Q _11364_/CLK _10983_/D _10983_/RESET_B VPWR VGND sg13cmos5l_dfrbpq_1
XFILLER_55_370 VPWR VGND sg13cmos5l_decap_8
XFILLER_90_21 VPWR VGND sg13cmos5l_decap_8
XFILLER_70_362 VPWR VGND sg13cmos5l_decap_8
XFILLER_43_587 VPWR VGND sg13cmos5l_decap_8
XFILLER_30_204 VPWR VGND sg13cmos5l_decap_8
XFILLER_12_930 VPWR VGND sg13cmos5l_decap_8
X_11604_ _11604_/Q clkload24/A _11604_/D _11604_/RESET_B VPWR VGND sg13cmos5l_dfrbpq_1
XFILLER_12_974 VPWR VGND sg13cmos5l_fill_2
X_11535_ _11535_/Q _11535_/CLK _11535_/D _11535_/RESET_B VPWR VGND sg13cmos5l_dfrbpq_1
XFILLER_8_956 VPWR VGND sg13cmos5l_decap_8
XFILLER_8_945 VPWR VGND sg13cmos5l_fill_1
XFILLER_7_411 VPWR VGND sg13cmos5l_decap_4
XFILLER_99_74 VPWR VGND sg13cmos5l_decap_8
XFILLER_7_477 VPWR VGND sg13cmos5l_fill_2
X_11466_ _11466_/Q clkload20/A _11466_/D _11466_/RESET_B VPWR VGND sg13cmos5l_dfrbpq_1
X_11397_ _11397_/Q _11528_/CLK _11397_/D _11397_/RESET_B VPWR VGND sg13cmos5l_dfrbpq_1
X_10417_ _10453_/C _11406_/Q _10843_/Q VPWR VGND sg13cmos5l_xnor2_1
X_10348_ _10351_/B _11402_/Q _10839_/Q VPWR VGND sg13cmos5l_nor2_1
XFILLER_3_672 VPWR VGND sg13cmos5l_decap_8
XFILLER_79_952 VPWR VGND sg13cmos5l_decap_4
X_10279_ _10290_/B _10279_/A _10279_/B VPWR VGND sg13cmos5l_xor2_1
XFILLER_94_933 VPWR VGND sg13cmos5l_fill_1
XFILLER_78_473 VPWR VGND sg13cmos5l_decap_8
XFILLER_66_624 VPWR VGND sg13cmos5l_fill_2
X_10815__952 _10815_/RESET_B VPWR VGND sg13cmos5l_tiehi
XFILLER_93_454 VPWR VGND sg13cmos5l_fill_2
XFILLER_54_808 VPWR VGND sg13cmos5l_decap_4
XFILLER_93_487 VPWR VGND sg13cmos5l_decap_8
X_10948__1034 _10948_/RESET_B VPWR VGND sg13cmos5l_tiehi
XFILLER_65_178 VPWR VGND sg13cmos5l_fill_2
XFILLER_53_329 VPWR VGND sg13cmos5l_decap_8
XFILLER_0_1027 VPWR VGND sg13cmos5l_fill_2
XFILLER_19_573 VPWR VGND sg13cmos5l_fill_1
XFILLER_74_690 VPWR VGND sg13cmos5l_fill_2
X_06510_ _06510_/X _11118_/Q _11086_/Q _11054_/Q _11022_/Q _09491_/S _09495_/A1 VPWR
+ VGND sg13cmos5l_mux4_1
X_07490_ _07490_/X _11527_/Q _10802_/Q _07497_/A VPWR VGND sg13cmos5l_mux2_1
XFILLER_34_543 VPWR VGND sg13cmos5l_decap_8
X_06441_ _06442_/B _06441_/A1 _06333_/Y _06432_/X _10672_/A VPWR VGND sg13cmos5l_a22oi_1
XFILLER_62_863 VPWR VGND sg13cmos5l_decap_8
X_09160_ _09837_/A _11479_/Q _10852_/Q VPWR VGND sg13cmos5l_xnor2_1
XFILLER_9_72 VPWR VGND sg13cmos5l_fill_1
X_06372_ _06373_/C _06709_/A _06709_/B VPWR VGND sg13cmos5l_and2_1
X_08111_ _11144_/D fanout52/X _08112_/B _08110_/Y VPWR VGND sg13cmos5l_o21ai_1
X_09091_ _09091_/Y _05939_/A _09102_/A _09106_/B1 VPWR VGND sg13cmos5l_o21ai_1
X_10851__1140 _10851_/RESET_B VPWR VGND sg13cmos5l_tiehi
X_08042_ _11110_/D fanout56/X _08041_/B _08041_/Y VPWR VGND sg13cmos5l_a21oi_1
X_11237__1664 _11237_/RESET_B VPWR VGND sg13cmos5l_tiehi
XFILLER_89_705 VPWR VGND sg13cmos5l_fill_1
X_09993_ _09993_/Y _11302_/Q _09903_/B _09992_/Y VPWR VGND sg13cmos5l_o21ai_1
X_11462__1348 _11462_/RESET_B VPWR VGND sg13cmos5l_tiehi
XFILLER_88_237 VPWR VGND sg13cmos5l_fill_2
X_08944_ _08944_/Y _08954_/A _08954_/C _08955_/A VPWR VGND sg13cmos5l_a21oi_1
Xhold2302 _08399_/A _11285_/Q VPWR VGND sg13cmos5l_dlygate4sd3_1
Xhold2313 _08047_/A _11113_/Q VPWR VGND sg13cmos5l_dlygate4sd3_1
Xhold2346 _06933_/A _11642_/Q VPWR VGND sg13cmos5l_dlygate4sd3_1
XFILLER_69_462 VPWR VGND sg13cmos5l_fill_2
Xhold2335 _08127_/A _11151_/Q VPWR VGND sg13cmos5l_dlygate4sd3_1
Xhold2324 _07887_/A _11034_/Q VPWR VGND sg13cmos5l_dlygate4sd3_1
XFILLER_85_955 VPWR VGND sg13cmos5l_decap_8
Xhold2379 _05948_/A _11570_/Q VPWR VGND sg13cmos5l_dlygate4sd3_1
Xhold2357 _08303_/A _11238_/Q VPWR VGND sg13cmos5l_dlygate4sd3_1
X_08875_ _08875_/Y _08907_/B _08875_/B VPWR VGND sg13cmos5l_xnor2_1
Xhold2368 _08123_/A _11149_/Q VPWR VGND sg13cmos5l_dlygate4sd3_1
XFILLER_28_15 VPWR VGND sg13cmos5l_decap_8
XFILLER_85_966 VPWR VGND sg13cmos5l_fill_1
XFILLER_84_432 VPWR VGND sg13cmos5l_decap_4
X_07826_ _07826_/Y _07826_/A _07826_/B VPWR VGND sg13cmos5l_nand2_1
XFILLER_29_359 VPWR VGND sg13cmos5l_fill_1
X_07757_ _10971_/D fanout82/X _07778_/B _07756_/Y VPWR VGND sg13cmos5l_a21oi_1
XFILLER_37_370 VPWR VGND sg13cmos5l_fill_1
XFILLER_25_532 VPWR VGND sg13cmos5l_decap_8
X_06708_ _10811_/D _06744_/A1 _06705_/Y _06707_/Y VPWR VGND sg13cmos5l_o21ai_1
XFILLER_53_863 VPWR VGND sg13cmos5l_fill_2
XFILLER_44_58 VPWR VGND sg13cmos5l_fill_1
XFILLER_44_47 VPWR VGND sg13cmos5l_decap_8
X_07688_ _07688_/Y _07688_/A _07694_/B VPWR VGND sg13cmos5l_nor2_1
X_09427_ _09427_/Y _09579_/B2 _09426_/Y _09422_/Y VPWR VGND sg13cmos5l_a21oi_1
X_06639_ _06640_/B _06639_/A _06639_/B VPWR VGND sg13cmos5l_nor2_1
XFILLER_100_42 VPWR VGND sg13cmos5l_decap_8
X_09358_ _09358_/Y _10991_/Q _09606_/B VPWR VGND sg13cmos5l_nand2_1
X_08309_ _08309_/Y _08309_/A _08309_/B VPWR VGND sg13cmos5l_nor2_1
XFILLER_60_46 VPWR VGND sg13cmos5l_fill_2
X_09289_ _09289_/Y _10046_/B1 _09285_/X _09288_/Y VPWR VGND sg13cmos5l_o21ai_1
X_11320_ _11320_/Q _11352_/CLK _11320_/D _11320_/RESET_B VPWR VGND sg13cmos5l_dfrbpq_1
X_11251_ _11251_/Q clkload10/A _11251_/D _11251_/RESET_B VPWR VGND sg13cmos5l_dfrbpq_1
XFILLER_106_364 VPWR VGND sg13cmos5l_decap_8
X_10202_ _10202_/Y _10202_/A _10202_/B VPWR VGND sg13cmos5l_nand2_1
X_11182_ _11182_/Q clkload10/A _11182_/D _11182_/RESET_B VPWR VGND sg13cmos5l_dfrbpq_1
XFILLER_69_88 VPWR VGND sg13cmos5l_fill_2
X_10133_ _10133_/Y _10614_/B2 _09881_/Y _10132_/Y VPWR VGND sg13cmos5l_a21oi_1
X_11566__1413 _11566_/RESET_B VPWR VGND sg13cmos5l_tiehi
XFILLER_0_664 VPWR VGND sg13cmos5l_decap_8
XFILLER_85_21 VPWR VGND sg13cmos5l_decap_8
X_10064_ _11489_/D _07016_/A _10073_/B _10063_/Y _06490_/A VPWR VGND sg13cmos5l_a22oi_1
Xhold2891 hold2891/X _11697_/Q VPWR VGND sg13cmos5l_dlygate4sd3_1
XFILLER_48_646 VPWR VGND sg13cmos5l_decap_4
XFILLER_36_819 VPWR VGND sg13cmos5l_decap_8
Xhold2880 _05902_/A _11510_/Q VPWR VGND sg13cmos5l_dlygate4sd3_1
XFILLER_91_925 VPWR VGND sg13cmos5l_decap_8
XFILLER_76_999 VPWR VGND sg13cmos5l_decap_8
XFILLER_75_476 VPWR VGND sg13cmos5l_decap_4
XFILLER_90_457 VPWR VGND sg13cmos5l_decap_8
XFILLER_90_424 VPWR VGND sg13cmos5l_decap_8
XFILLER_56_690 VPWR VGND sg13cmos5l_decap_4
X_11315__1586 _11315_/RESET_B VPWR VGND sg13cmos5l_tiehi
XFILLER_16_532 VPWR VGND sg13cmos5l_fill_1
XFILLER_28_370 VPWR VGND sg13cmos5l_fill_1
XFILLER_71_671 VPWR VGND sg13cmos5l_fill_2
X_10966_ _10966_/Q clkload33/A _10966_/D _10966_/RESET_B VPWR VGND sg13cmos5l_dfrbpq_1
XFILLER_16_565 VPWR VGND sg13cmos5l_fill_2
XFILLER_16_587 VPWR VGND sg13cmos5l_decap_4
X_10897_ _10897_/Q _11265_/CLK _10897_/D _10897_/RESET_B VPWR VGND sg13cmos5l_dfrbpq_1
XFILLER_31_535 VPWR VGND sg13cmos5l_decap_8
XFILLER_86_7 VPWR VGND sg13cmos5l_decap_8
XFILLER_7_230 VPWR VGND sg13cmos5l_fill_2
XFILLER_12_793 VPWR VGND sg13cmos5l_decap_8
X_11518_ _11518_/Q clkload45/A _11518_/D _11518_/RESET_B VPWR VGND sg13cmos5l_dfrbpq_1
XFILLER_7_274 VPWR VGND sg13cmos5l_fill_2
X_11449_ _11449_/Q clkload54/A _11449_/D _11449_/RESET_B VPWR VGND sg13cmos5l_dfrbpq_1
X_06990_ _06990_/Y _11499_/Q _07006_/A _06990_/B1 _11491_/Q VPWR VGND sg13cmos5l_a22oi_1
X_05941_ _05941_/Y _06924_/A VPWR VGND sg13cmos5l_inv_1
XFILLER_94_741 VPWR VGND sg13cmos5l_decap_4
X_08660_ _11395_/D _08660_/A VPWR VGND sg13cmos5l_inv_1
X_05872_ _10331_/A _11401_/Q VPWR VGND sg13cmos5l_inv_1
XFILLER_94_796 VPWR VGND sg13cmos5l_decap_4
XFILLER_67_988 VPWR VGND sg13cmos5l_fill_2
X_07611_ _07611_/Y _10591_/A _07617_/C _07610_/Y VPWR VGND sg13cmos5l_a21oi_1
X_08591_ _08591_/Y _11019_/Q _08588_/B _10015_/B1 VPWR VGND sg13cmos5l_a21oi_1
XFILLER_66_498 VPWR VGND sg13cmos5l_fill_1
XFILLER_53_148 VPWR VGND sg13cmos5l_decap_4
XFILLER_53_126 VPWR VGND sg13cmos5l_fill_2
X_07542_ _07562_/D _11407_/Q _11406_/Q _11405_/Q _07542_/D VPWR VGND sg13cmos5l_and4_1
X_07473_ _07473_/Y _07493_/A _07473_/B VPWR VGND sg13cmos5l_nor2_1
XFILLER_34_362 VPWR VGND sg13cmos5l_decap_8
XFILLER_34_373 VPWR VGND sg13cmos5l_fill_1
X_06424_ _06424_/Y _10658_/A _06424_/B VPWR VGND sg13cmos5l_xnor2_1
X_09212_ _09215_/B _09199_/A _09206_/X _09211_/Y VPWR VGND sg13cmos5l_o21ai_1
X_09143_ _09143_/Y _09147_/B _09137_/Y _09141_/Y _09142_/Y _05939_/Y VPWR VGND sg13cmos5l_a221oi_1
X_06355_ _06355_/Y _06355_/A _06358_/A VPWR VGND sg13cmos5l_nor2_1
X_09074_ _09075_/C _09074_/A _09073_/Y VPWR VGND sg13cmos5l_nor2b_1
X_06286_ _06625_/C _07032_/A _09429_/A VPWR VGND sg13cmos5l_nand2_1
X_08025_ _08025_/Y _08025_/A _08033_/B VPWR VGND sg13cmos5l_nor2_1
XFILLER_2_907 VPWR VGND sg13cmos5l_fill_2
XFILLER_89_513 VPWR VGND sg13cmos5l_decap_8
XFILLER_89_502 VPWR VGND sg13cmos5l_fill_1
X_09976_ _10005_/C _09976_/A _09976_/B VPWR VGND sg13cmos5l_nand2_1
Xhold2110 _07554_/A _10907_/Q VPWR VGND sg13cmos5l_dlygate4sd3_1
Xhold2121 _08013_/A _11096_/Q VPWR VGND sg13cmos5l_dlygate4sd3_1
Xhold2143 _07629_/A _10918_/Q VPWR VGND sg13cmos5l_dlygate4sd3_1
X_08927_ _08961_/B _08941_/A _08926_/Y VPWR VGND sg13cmos5l_nor2b_1
Xhold2132 _07865_/A _11023_/Q VPWR VGND sg13cmos5l_dlygate4sd3_1
Xhold2154 _07682_/A _10935_/Q VPWR VGND sg13cmos5l_dlygate4sd3_1
Xhold2165 _07588_/A _10912_/Q VPWR VGND sg13cmos5l_dlygate4sd3_1
XFILLER_97_590 VPWR VGND sg13cmos5l_decap_8
Xhold2176 _07718_/A _10953_/Q VPWR VGND sg13cmos5l_dlygate4sd3_1
Xhold2187 _10019_/A _11303_/Q VPWR VGND sg13cmos5l_dlygate4sd3_1
XFILLER_57_432 VPWR VGND sg13cmos5l_decap_4
X_08858_ _08858_/Y _08858_/A _08895_/B VPWR VGND sg13cmos5l_nand2_1
XFILLER_58_999 VPWR VGND sg13cmos5l_decap_4
XFILLER_55_13 VPWR VGND sg13cmos5l_decap_8
XFILLER_45_627 VPWR VGND sg13cmos5l_decap_4
X_07809_ _10996_/D _08071_/A1 _07814_/B _07808_/Y VPWR VGND sg13cmos5l_o21ai_1
Xhold2198 _08407_/A _11289_/Q VPWR VGND sg13cmos5l_dlygate4sd3_1
XFILLER_57_498 VPWR VGND sg13cmos5l_fill_2
X_08789_ _08789_/Y _08789_/A _08811_/B VPWR VGND sg13cmos5l_nand2_1
X_10820_ _10820_/Q clkload47/A _10820_/D _10820_/RESET_B VPWR VGND sg13cmos5l_dfrbpq_1
XFILLER_60_619 VPWR VGND sg13cmos5l_decap_8
X_10751_ _11569_/D _10751_/A _10751_/B VPWR VGND sg13cmos5l_and2_1
XFILLER_81_980 VPWR VGND sg13cmos5l_decap_4
XFILLER_13_535 VPWR VGND sg13cmos5l_fill_1
XFILLER_41_877 VPWR VGND sg13cmos5l_decap_4
XFILLER_13_568 VPWR VGND sg13cmos5l_fill_2
X_10682_ _10682_/Y _10682_/A _10682_/B VPWR VGND sg13cmos5l_nand2_1
X_11303_ _11303_/Q clkload49/A _11303_/D _11303_/RESET_B VPWR VGND sg13cmos5l_dfrbpq_1
XFILLER_4_211 VPWR VGND sg13cmos5l_fill_2
X_11234_ _11234_/Q clkload52/A _11234_/D _11234_/RESET_B VPWR VGND sg13cmos5l_dfrbpq_1
XFILLER_106_161 VPWR VGND sg13cmos5l_decap_8
XFILLER_96_42 VPWR VGND sg13cmos5l_decap_8
XFILLER_45_1028 VPWR VGND sg13cmos5l_fill_1
X_11165_ _11165_/Q clkload42/A _11165_/D _11165_/RESET_B VPWR VGND sg13cmos5l_dfrbpq_1
XFILLER_95_516 VPWR VGND sg13cmos5l_fill_1
XFILLER_67_207 VPWR VGND sg13cmos5l_fill_1
X_10116_ _10116_/Y _10267_/B _10135_/B VPWR VGND sg13cmos5l_nand2_1
X_11096_ _11096_/Q _11349_/CLK _11096_/D _11096_/RESET_B VPWR VGND sg13cmos5l_dfrbpq_1
XFILLER_1_995 VPWR VGND sg13cmos5l_decap_8
X_10047_ _10047_/Y _05986_/Y _10041_/B _10046_/Y VPWR VGND sg13cmos5l_a21oi_1
XFILLER_0_483 VPWR VGND sg13cmos5l_decap_8
XFILLER_63_402 VPWR VGND sg13cmos5l_fill_1
XFILLER_36_627 VPWR VGND sg13cmos5l_fill_2
XFILLER_36_616 VPWR VGND sg13cmos5l_decap_8
XFILLER_44_660 VPWR VGND sg13cmos5l_fill_2
XFILLER_32_800 VPWR VGND sg13cmos5l_fill_2
XFILLER_90_287 VPWR VGND sg13cmos5l_decap_4
X_10949_ _10949_/Q _11355_/CLK _10949_/D _10949_/RESET_B VPWR VGND sg13cmos5l_dfrbpq_1
XFILLER_32_822 VPWR VGND sg13cmos5l_decap_8
XFILLER_43_181 VPWR VGND sg13cmos5l_decap_8
Xclkbuf_leaf_70_clk clkload8/A clkbuf_4_0_0_clk/X VPWR VGND sg13cmos5l_buf_8
XFILLER_32_844 VPWR VGND sg13cmos5l_decap_8
XFILLER_32_855 VPWR VGND sg13cmos5l_fill_2
X_06140_ _06141_/D _11577_/Q _06140_/B _06140_/C _06140_/D VPWR VGND sg13cmos5l_nand4_1
X_10898__1084 _10898_/RESET_B VPWR VGND sg13cmos5l_tiehi
X_06071_ _10695_/A _06071_/A _06070_/Y VPWR VGND sg13cmos5l_nor2b_1
XFILLER_99_811 VPWR VGND sg13cmos5l_fill_1
XFILLER_99_877 VPWR VGND sg13cmos5l_decap_4
Xfanout518 fanout518/X _08649_/Y VPWR VGND sg13cmos5l_buf_1
Xfanout529 _07448_/A _07442_/Y VPWR VGND sg13cmos5l_buf_1
X_09830_ _09910_/B _09830_/A _09968_/B VPWR VGND sg13cmos5l_nand2_1
Xfanout507 _08846_/B _10704_/B VPWR VGND sg13cmos5l_buf_1
X_09761_ _09761_/Y _11102_/Q _09870_/B VPWR VGND sg13cmos5l_nand2_1
XFILLER_6_1011 VPWR VGND sg13cmos5l_decap_8
X_06973_ _06973_/Y _07036_/A _07038_/B _06972_/Y VPWR VGND sg13cmos5l_o21ai_1
X_08712_ _08713_/B _08721_/A _08712_/B VPWR VGND sg13cmos5l_nand2_1
XFILLER_39_443 VPWR VGND sg13cmos5l_fill_2
X_05924_ _06191_/B _09429_/A VPWR VGND sg13cmos5l_inv_1
X_09692_ _09692_/Y _09994_/A1 _09691_/Y _09687_/Y VPWR VGND sg13cmos5l_a21oi_1
XFILLER_39_476 VPWR VGND sg13cmos5l_decap_8
XFILLER_82_733 VPWR VGND sg13cmos5l_decap_4
X_08643_ _11388_/D _11702_/D hold2877/X _08645_/S VPWR VGND sg13cmos5l_mux2_1
X_08574_ _08574_/Y _08599_/S1 _08573_/X _10016_/C1 VPWR VGND sg13cmos5l_a21oi_1
X_07525_ _10902_/D _07566_/B _08075_/A1 _07519_/Y VPWR VGND sg13cmos5l_a21oi_1
XFILLER_23_822 VPWR VGND sg13cmos5l_fill_1
Xclkbuf_leaf_61_clk clkload35/A clkbuf_4_8_0_clk/X VPWR VGND sg13cmos5l_buf_8
XFILLER_22_365 VPWR VGND sg13cmos5l_fill_2
X_07456_ _10892_/D _07517_/B _08512_/A1 _07455_/Y VPWR VGND sg13cmos5l_a21oi_1
X_06407_ _06408_/C _10620_/A _06407_/B VPWR VGND sg13cmos5l_and2_1
X_07387_ _07387_/Y _07385_/Y _08742_/A _07400_/A2 VPWR VGND sg13cmos5l_a21oi_1
X_06338_ _06338_/X _11596_/Q _10828_/Q _06338_/S VPWR VGND sg13cmos5l_mux2_1
X_09126_ _09126_/Y _09126_/A VPWR VGND sg13cmos5l_inv_1
X_06269_ _10581_/B _06269_/A _06269_/B VPWR VGND sg13cmos5l_or2_1
X_09057_ _09058_/B _09069_/C _09047_/Y _09043_/Y VPWR VGND sg13cmos5l_o21ai_1
X_08008_ _11093_/D _08073_/A1 _08007_/B _08007_/Y VPWR VGND sg13cmos5l_a21oi_1
XFILLER_104_665 VPWR VGND sg13cmos5l_decap_4
Xheichips26_RiMaX_1824 uio_oe[9] VPWR VGND sg13cmos5l_tiehi
XFILLER_106_63 VPWR VGND sg13cmos5l_decap_8
XFILLER_103_175 VPWR VGND sg13cmos5l_decap_8
X_09959_ _09960_/C _09955_/Y _09956_/Y _09957_/Y _09958_/Y _06474_/A VPWR VGND sg13cmos5l_a221oi_1
XFILLER_58_752 VPWR VGND sg13cmos5l_fill_1
XFILLER_100_882 VPWR VGND sg13cmos5l_fill_1
XFILLER_72_210 VPWR VGND sg13cmos5l_decap_8
XFILLER_82_22 VPWR VGND sg13cmos5l_decap_8
XFILLER_82_11 VPWR VGND sg13cmos5l_decap_4
X_11196__1705 _11196_/RESET_B VPWR VGND sg13cmos5l_tiehi
XFILLER_73_799 VPWR VGND sg13cmos5l_fill_1
XFILLER_72_287 VPWR VGND sg13cmos5l_fill_1
X_10803_ _10803_/Q clkload15/A _10803_/D _10803_/RESET_B VPWR VGND sg13cmos5l_dfrbpq_1
XFILLER_26_682 VPWR VGND sg13cmos5l_decap_8
XFILLER_14_855 VPWR VGND sg13cmos5l_decap_8
Xclkbuf_leaf_52_clk clkload39/A clkbuf_4_10_0_clk/X VPWR VGND sg13cmos5l_buf_8
X_10734_ _10735_/B hold2600/X _10730_/Y _10731_/Y hold2573/X VPWR VGND sg13cmos5l_a22oi_1
XFILLER_41_663 VPWR VGND sg13cmos5l_decap_4
XFILLER_14_877 VPWR VGND sg13cmos5l_fill_2
X_10665_ _10665_/Y _10665_/A _10665_/B VPWR VGND sg13cmos5l_nand2_1
XFILLER_51_1010 VPWR VGND sg13cmos5l_decap_8
X_11431__1428 _11431_/RESET_B VPWR VGND sg13cmos5l_tiehi
X_11482__1219 _11482_/RESET_B VPWR VGND sg13cmos5l_tiehi
X_10596_ _10597_/B _10581_/A _06269_/B _06266_/Y VPWR VGND sg13cmos5l_o21ai_1
X_11217_ _11217_/Q clkload35/A _11217_/D _11217_/RESET_B VPWR VGND sg13cmos5l_dfrbpq_1
X_11148_ _11148_/Q clkload39/A _11148_/D _11148_/RESET_B VPWR VGND sg13cmos5l_dfrbpq_1
X_11079_ _11079_/Q _11364_/CLK _11079_/D _11079_/RESET_B VPWR VGND sg13cmos5l_dfrbpq_1
X_11643__1323 _11643_/RESET_B VPWR VGND sg13cmos5l_tiehi
XFILLER_49_785 VPWR VGND sg13cmos5l_fill_2
XFILLER_49_774 VPWR VGND sg13cmos5l_decap_8
XFILLER_48_262 VPWR VGND sg13cmos5l_decap_8
XFILLER_48_240 VPWR VGND sg13cmos5l_decap_8
XFILLER_91_552 VPWR VGND sg13cmos5l_fill_1
XFILLER_64_755 VPWR VGND sg13cmos5l_decap_8
XFILLER_52_917 VPWR VGND sg13cmos5l_fill_2
XFILLER_52_906 VPWR VGND sg13cmos5l_decap_8
XFILLER_51_427 VPWR VGND sg13cmos5l_decap_8
Xclkbuf_leaf_43_clk clkload55/A clkbuf_4_14_0_clk/X VPWR VGND sg13cmos5l_buf_8
XFILLER_51_449 VPWR VGND sg13cmos5l_decap_8
XFILLER_17_693 VPWR VGND sg13cmos5l_fill_2
X_07310_ _07310_/Y _09559_/A _07316_/A2 _07309_/Y VPWR VGND sg13cmos5l_a21oi_1
X_08290_ _11231_/D fanout74/X _08307_/B _08289_/Y VPWR VGND sg13cmos5l_a21oi_1
XFILLER_32_674 VPWR VGND sg13cmos5l_decap_4
XFILLER_32_685 VPWR VGND sg13cmos5l_fill_2
X_07241_ _07241_/Y _10855_/Q _07205_/B _07243_/B1 _07093_/A VPWR VGND sg13cmos5l_a22oi_1
XFILLER_31_162 VPWR VGND sg13cmos5l_decap_4
X_07172_ _07172_/Y _07172_/A _07185_/A VPWR VGND sg13cmos5l_nand2_1
X_06123_ _11762_/D _06107_/S _06122_/Y _06121_/Y VPWR VGND sg13cmos5l_o21ai_1
XFILLER_9_892 VPWR VGND sg13cmos5l_fill_2
X_06054_ _11757_/D _06092_/B _06054_/B VPWR VGND sg13cmos5l_nor2_1
XFILLER_28_1001 VPWR VGND sg13cmos5l_fill_1
XFILLER_98_140 VPWR VGND sg13cmos5l_decap_8
Xfanout304 _07836_/B _07844_/B VPWR VGND sg13cmos5l_buf_1
X_11274__1627 _11274_/RESET_B VPWR VGND sg13cmos5l_tiehi
X_11568__1405 _11568_/RESET_B VPWR VGND sg13cmos5l_tiehi
Xfanout348 _09933_/A _06474_/Y VPWR VGND sg13cmos5l_buf_1
Xfanout337 _09903_/B _10019_/B VPWR VGND sg13cmos5l_buf_1
X_09813_ _09813_/Y _09837_/C _09813_/B VPWR VGND sg13cmos5l_nand2_1
Xfanout315 _08317_/A1 _07454_/Y VPWR VGND sg13cmos5l_buf_1
X_11310__1591 _11310_/RESET_B VPWR VGND sg13cmos5l_tiehi
Xfanout326 _07059_/B1 _07060_/A2 VPWR VGND sg13cmos5l_buf_1
XFILLER_100_112 VPWR VGND sg13cmos5l_decap_8
Xfanout359 _10675_/B _10469_/Y VPWR VGND sg13cmos5l_buf_1
XFILLER_74_508 VPWR VGND sg13cmos5l_fill_2
XFILLER_67_571 VPWR VGND sg13cmos5l_decap_8
X_06956_ _06956_/Y _11554_/Q _06956_/B VPWR VGND sg13cmos5l_nor2_1
X_09744_ _09745_/B _09852_/A1 _09739_/X _09743_/Y VPWR VGND sg13cmos5l_o21ai_1
XFILLER_100_189 VPWR VGND sg13cmos5l_decap_8
X_06887_ _11628_/D _11693_/D hold2434/X _08642_/S VPWR VGND sg13cmos5l_mux2_1
X_05907_ _10293_/A _10267_/D VPWR VGND sg13cmos5l_inv_1
X_09675_ _09675_/Y _09236_/C _09674_/Y _09755_/A VPWR VGND sg13cmos5l_a21oi_1
XFILLER_36_15 VPWR VGND sg13cmos5l_decap_4
XFILLER_27_413 VPWR VGND sg13cmos5l_decap_8
XFILLER_27_424 VPWR VGND sg13cmos5l_fill_2
XFILLER_70_703 VPWR VGND sg13cmos5l_fill_2
X_08626_ _08626_/Y _08626_/A1 _08625_/Y hold2604/X VPWR VGND sg13cmos5l_a21oi_1
XFILLER_70_736 VPWR VGND sg13cmos5l_fill_2
XFILLER_36_991 VPWR VGND sg13cmos5l_fill_2
Xclkbuf_leaf_34_clk clkload46/A clkbuf_4_12_0_clk/X VPWR VGND sg13cmos5l_buf_8
X_08557_ _08557_/Y _08557_/A _08569_/B VPWR VGND sg13cmos5l_nor2_1
XFILLER_50_460 VPWR VGND sg13cmos5l_decap_4
XFILLER_35_1027 VPWR VGND sg13cmos5l_fill_2
XFILLER_35_1005 VPWR VGND sg13cmos5l_decap_4
X_08488_ _08488_/Y _08488_/A _08488_/B VPWR VGND sg13cmos5l_nand2_1
X_07508_ _07508_/Y _07530_/A _07508_/B VPWR VGND sg13cmos5l_nand2_1
X_07439_ _07721_/A _08376_/A _08376_/B VPWR VGND sg13cmos5l_nand2_1
XFILLER_22_162 VPWR VGND sg13cmos5l_decap_8
X_10450_ _10450_/Y _10453_/D _10450_/B VPWR VGND sg13cmos5l_xnor2_1
X_09109_ _09120_/B _09109_/A _09118_/A VPWR VGND sg13cmos5l_xor2_1
X_10381_ _10385_/A _10454_/A _10454_/B VPWR VGND sg13cmos5l_nand2_1
XFILLER_105_974 VPWR VGND sg13cmos5l_decap_8
XFILLER_104_440 VPWR VGND sg13cmos5l_decap_8
XFILLER_78_847 VPWR VGND sg13cmos5l_fill_2
XFILLER_77_44 VPWR VGND sg13cmos5l_decap_4
X_11002_ _11002_/Q clkload39/A _11002_/D _11002_/RESET_B VPWR VGND sg13cmos5l_dfrbpq_1
XFILLER_77_99 VPWR VGND sg13cmos5l_decap_8
XFILLER_19_925 VPWR VGND sg13cmos5l_fill_1
XFILLER_93_21 VPWR VGND sg13cmos5l_decap_8
XFILLER_46_722 VPWR VGND sg13cmos5l_decap_8
XFILLER_45_243 VPWR VGND sg13cmos5l_decap_8
XFILLER_18_446 VPWR VGND sg13cmos5l_fill_2
XFILLER_34_917 VPWR VGND sg13cmos5l_fill_2
Xclkbuf_leaf_25_clk clkload30/A clkbuf_4_6_0_clk/X VPWR VGND sg13cmos5l_buf_8
XFILLER_61_769 VPWR VGND sg13cmos5l_fill_1
XFILLER_61_758 VPWR VGND sg13cmos5l_decap_8
XFILLER_14_630 VPWR VGND sg13cmos5l_decap_4
X_11766_ _11766_/Q _11766_/CLK _11766_/D _11766_/RESET_B VPWR VGND sg13cmos5l_dfrbpq_1
XFILLER_9_100 VPWR VGND sg13cmos5l_fill_2
X_10717_ _10717_/Y _11643_/Q _10688_/A _10713_/B VPWR VGND sg13cmos5l_o21ai_1
XFILLER_13_173 VPWR VGND sg13cmos5l_decap_8
X_11352__1549 _11352_/RESET_B VPWR VGND sg13cmos5l_tiehi
X_11697_ _11697_/Q clkload19/A _11697_/D _11697_/RESET_B VPWR VGND sg13cmos5l_dfrbpq_1
X_10648_ _11547_/D _10685_/A _10648_/B _10648_/C VPWR VGND sg13cmos5l_nor3_1
XFILLER_10_880 VPWR VGND sg13cmos5l_fill_2
X_10579_ _10579_/Y _10578_/A _10578_/B _10640_/A VPWR VGND sg13cmos5l_a21oi_1
XFILLER_61_6 VPWR VGND sg13cmos5l_fill_1
XFILLER_6_851 VPWR VGND sg13cmos5l_fill_2
Xhold2709 hold2709/X _11556_/Q VPWR VGND sg13cmos5l_dlygate4sd3_1
XFILLER_69_814 VPWR VGND sg13cmos5l_fill_2
XFILLER_68_302 VPWR VGND sg13cmos5l_decap_8
XFILLER_95_132 VPWR VGND sg13cmos5l_decap_8
X_07790_ _07790_/Y _07790_/A _07846_/B VPWR VGND sg13cmos5l_nand2_1
X_06810_ _06810_/Y _06832_/A _06807_/Y _06809_/Y VPWR VGND sg13cmos5l_o21ai_1
XFILLER_68_379 VPWR VGND sg13cmos5l_decap_8
XFILLER_97_1010 VPWR VGND sg13cmos5l_decap_8
XFILLER_37_733 VPWR VGND sg13cmos5l_decap_4
XFILLER_3_1025 VPWR VGND sg13cmos5l_decap_4
X_06741_ _06741_/Y _06741_/A _06741_/B VPWR VGND sg13cmos5l_xnor2_1
X_09460_ _09460_/Y _09460_/A _09460_/B _09460_/C VPWR VGND sg13cmos5l_nor3_1
XFILLER_92_894 VPWR VGND sg13cmos5l_decap_4
XFILLER_64_585 VPWR VGND sg13cmos5l_decap_4
X_08411_ _08411_/Y _08411_/A _08431_/B VPWR VGND sg13cmos5l_nor2_1
X_06672_ _06673_/B _06679_/A _06669_/Y _06670_/X _06671_/Y VPWR VGND sg13cmos5l_a22oi_1
XFILLER_24_416 VPWR VGND sg13cmos5l_fill_2
Xclkbuf_leaf_16_clk clkload25/A clkload1/A VPWR VGND sg13cmos5l_buf_8
X_09391_ _09391_/Y _10896_/Q _09499_/B _09577_/B1 VPWR VGND sg13cmos5l_a21oi_1
XFILLER_51_268 VPWR VGND sg13cmos5l_fill_1
X_08342_ _08342_/Y _08342_/A _08358_/B VPWR VGND sg13cmos5l_nand2_1
X_08273_ _08273_/Y _08273_/A _08273_/B VPWR VGND sg13cmos5l_nor2_1
X_11328__1573 _11328_/RESET_B VPWR VGND sg13cmos5l_tiehi
X_07224_ _07224_/Y _05974_/Y _07239_/A2 _07226_/B1 _07223_/Y VPWR VGND sg13cmos5l_a22oi_1
XFILLER_20_666 VPWR VGND sg13cmos5l_fill_2
X_11767__928 _11767_/RESET_B VPWR VGND sg13cmos5l_tiehi
X_07155_ _07155_/Y hold2680/X _07160_/A2 _07155_/B1 VPWR VGND sg13cmos5l_o21ai_1
XFILLER_106_749 VPWR VGND sg13cmos5l_decap_8
X_07086_ _11696_/D hold2823/X _06820_/C _07088_/S VPWR VGND sg13cmos5l_mux2_1
X_06106_ _12765_/A _11681_/Q _11680_/Q _11682_/Q _11683_/Q VPWR VGND sg13cmos5l_or4_1
XFILLER_105_259 VPWR VGND sg13cmos5l_decap_8
X_06037_ _06041_/A _11595_/Q _11591_/Q _11625_/Q _11618_/Q VPWR VGND sg13cmos5l_nor4_1
Xfanout112 _08642_/S _08635_/S VPWR VGND sg13cmos5l_buf_1
Xfanout101 _08471_/A1 _07536_/Y VPWR VGND sg13cmos5l_buf_1
XFILLER_102_955 VPWR VGND sg13cmos5l_decap_8
XFILLER_102_933 VPWR VGND sg13cmos5l_decap_4
XFILLER_87_655 VPWR VGND sg13cmos5l_decap_8
XFILLER_86_121 VPWR VGND sg13cmos5l_fill_1
Xfanout123 _08470_/B _08441_/Y VPWR VGND sg13cmos5l_buf_1
Xfanout145 _07948_/B _07919_/Y VPWR VGND sg13cmos5l_buf_1
Xfanout156 _08524_/A1 _07494_/Y VPWR VGND sg13cmos5l_buf_1
Xfanout134 _08220_/B _08216_/B VPWR VGND sg13cmos5l_buf_1
X_07988_ _11083_/D _08053_/A1 _08043_/B _07987_/Y VPWR VGND sg13cmos5l_a21oi_1
Xfanout178 _08565_/B _08555_/B VPWR VGND sg13cmos5l_buf_1
Xfanout189 _08439_/B _08431_/B VPWR VGND sg13cmos5l_buf_1
XFILLER_74_305 VPWR VGND sg13cmos5l_fill_1
Xfanout167 _07389_/B _07407_/B VPWR VGND sg13cmos5l_buf_1
XFILLER_47_508 VPWR VGND sg13cmos5l_decap_8
X_06939_ _06939_/Y _06939_/A _10776_/B VPWR VGND sg13cmos5l_nand2_1
XFILLER_68_880 VPWR VGND sg13cmos5l_fill_1
X_09727_ _09727_/Y _09751_/A _09727_/B _09727_/C _09727_/D VPWR VGND sg13cmos5l_nor4_1
XFILLER_28_711 VPWR VGND sg13cmos5l_fill_2
XFILLER_103_42 VPWR VGND sg13cmos5l_decap_8
XFILLER_27_221 VPWR VGND sg13cmos5l_decap_8
XFILLER_27_232 VPWR VGND sg13cmos5l_fill_1
X_09658_ _09658_/Y _09738_/A1 _09657_/X _09633_/A VPWR VGND sg13cmos5l_a21oi_1
X_08609_ _08609_/Y _06060_/B _09858_/B2 _08606_/Y _08608_/Y VPWR VGND sg13cmos5l_a22oi_1
XFILLER_43_747 VPWR VGND sg13cmos5l_fill_2
XFILLER_27_287 VPWR VGND sg13cmos5l_decap_4
XFILLER_27_298 VPWR VGND sg13cmos5l_fill_1
X_09589_ _09590_/B _09565_/B _09225_/C _09225_/B VPWR VGND sg13cmos5l_a21oi_1
X_11620_ _11620_/Q _11622_/CLK _11620_/D _11620_/RESET_B VPWR VGND sg13cmos5l_dfrbpq_1
XFILLER_63_79 VPWR VGND sg13cmos5l_decap_4
XFILLER_42_279 VPWR VGND sg13cmos5l_decap_8
X_11551_ _11551_/Q clkload23/A _11551_/D _11551_/RESET_B VPWR VGND sg13cmos5l_dfrbpq_1
XFILLER_23_493 VPWR VGND sg13cmos5l_fill_1
XFILLER_50_290 VPWR VGND sg13cmos5l_decap_4
X_10502_ _10503_/B _10490_/Y _10495_/Y _10501_/Y VPWR VGND sg13cmos5l_o21ai_1
X_11482_ _11482_/Q clkload45/A _11482_/D _11482_/RESET_B VPWR VGND sg13cmos5l_dfrbpq_1
X_10433_ _10437_/B _10433_/A _10433_/B VPWR VGND sg13cmos5l_nand2_1
XFILLER_88_21 VPWR VGND sg13cmos5l_decap_8
X_10364_ _10366_/A _11403_/Q _10840_/Q VPWR VGND sg13cmos5l_xnor2_1
XFILLER_6_169 VPWR VGND sg13cmos5l_fill_2
XFILLER_98_909 VPWR VGND sg13cmos5l_fill_2
XFILLER_5_0 VPWR VGND sg13cmos5l_decap_8
XFILLER_3_854 VPWR VGND sg13cmos5l_fill_2
XFILLER_88_98 VPWR VGND sg13cmos5l_fill_1
X_10295_ _10300_/A _10295_/A _10296_/B _10296_/C VPWR VGND sg13cmos5l_and3_1
XFILLER_2_375 VPWR VGND sg13cmos5l_decap_4
X_11675__1289 _11675_/RESET_B VPWR VGND sg13cmos5l_tiehi
XFILLER_77_165 VPWR VGND sg13cmos5l_decap_8
XFILLER_66_817 VPWR VGND sg13cmos5l_decap_8
XFILLER_93_625 VPWR VGND sg13cmos5l_fill_2
XFILLER_92_113 VPWR VGND sg13cmos5l_decap_8
XFILLER_66_839 VPWR VGND sg13cmos5l_fill_2
Xfanout690 _06990_/B1 _06982_/B1 VPWR VGND sg13cmos5l_buf_1
XFILLER_92_157 VPWR VGND sg13cmos5l_fill_1
XFILLER_74_861 VPWR VGND sg13cmos5l_fill_2
XFILLER_65_349 VPWR VGND sg13cmos5l_decap_8
XFILLER_18_265 VPWR VGND sg13cmos5l_decap_4
XFILLER_34_725 VPWR VGND sg13cmos5l_fill_2
XFILLER_61_544 VPWR VGND sg13cmos5l_fill_2
XFILLER_34_769 VPWR VGND sg13cmos5l_fill_1
XFILLER_30_920 VPWR VGND sg13cmos5l_decap_8
X_11749_ _11749_/Q clkload24/A _11749_/D _11749_/RESET_B VPWR VGND sg13cmos5l_dfrbpq_1
XFILLER_88_419 VPWR VGND sg13cmos5l_fill_2
X_08960_ _08964_/C _08960_/A _08960_/B VPWR VGND sg13cmos5l_nor2_1
Xclkbuf_leaf_5_clk clkload13/A clkbuf_4_1_0_clk/X VPWR VGND sg13cmos5l_buf_8
X_07911_ _07911_/Y _07911_/A _07911_/B VPWR VGND sg13cmos5l_nor2_1
XFILLER_69_644 VPWR VGND sg13cmos5l_decap_8
X_08891_ _08891_/Y _08891_/A _08891_/B VPWR VGND sg13cmos5l_xnor2_1
X_11191__1710 _11191_/RESET_B VPWR VGND sg13cmos5l_tiehi
Xhold2506 _11662_/D _07001_/X VPWR VGND sg13cmos5l_dlygate4sd3_1
Xhold2517 hold2517/X _11660_/Q VPWR VGND sg13cmos5l_dlygate4sd3_1
Xhold2528 _07431_/A _10889_/Q VPWR VGND sg13cmos5l_dlygate4sd3_1
X_07842_ _07842_/Y _07842_/A _07844_/B VPWR VGND sg13cmos5l_nand2_1
Xhold2539 _07371_/A _10879_/Q VPWR VGND sg13cmos5l_dlygate4sd3_1
XFILLER_29_508 VPWR VGND sg13cmos5l_fill_1
Xhold1838 _08492_/A _11331_/Q VPWR VGND sg13cmos5l_dlygate4sd3_1
XFILLER_57_839 VPWR VGND sg13cmos5l_decap_8
XFILLER_56_316 VPWR VGND sg13cmos5l_decap_8
Xhold1849 _07952_/A _11066_/Q VPWR VGND sg13cmos5l_dlygate4sd3_1
X_07773_ _10979_/D fanout62/X _07784_/B _07772_/Y VPWR VGND sg13cmos5l_a21oi_1
XFILLER_84_669 VPWR VGND sg13cmos5l_decap_8
XFILLER_37_530 VPWR VGND sg13cmos5l_fill_1
XFILLER_17_17 VPWR VGND sg13cmos5l_fill_1
X_09512_ _11466_/D _09402_/A _09540_/A _09490_/Y _09511_/Y VPWR VGND sg13cmos5l_a22oi_1
XFILLER_65_872 VPWR VGND sg13cmos5l_decap_8
X_06724_ _10813_/D _06744_/A1 _06721_/Y _06723_/Y VPWR VGND sg13cmos5l_o21ai_1
XFILLER_92_691 VPWR VGND sg13cmos5l_decap_4
XFILLER_80_842 VPWR VGND sg13cmos5l_fill_1
X_09443_ _09443_/Y _05959_/Y _09440_/B _09442_/Y VPWR VGND sg13cmos5l_o21ai_1
X_06655_ _06655_/Y _06662_/A _06655_/B VPWR VGND sg13cmos5l_nor2_1
X_09374_ _09375_/B _09852_/A1 _09369_/X _09373_/Y VPWR VGND sg13cmos5l_o21ai_1
XFILLER_12_408 VPWR VGND sg13cmos5l_fill_1
X_06586_ _06586_/Y _06643_/B1 _06583_/Y _06585_/Y VPWR VGND sg13cmos5l_a21oi_1
X_08325_ _11248_/D _08520_/A1 _08328_/B _08324_/Y VPWR VGND sg13cmos5l_o21ai_1
XFILLER_21_931 VPWR VGND sg13cmos5l_fill_1
X_08256_ _11214_/D _08321_/A1 _08263_/B _08255_/Y VPWR VGND sg13cmos5l_a21oi_1
X_07207_ _07208_/B _10839_/Q _07205_/B _07185_/X _07205_/Y VPWR VGND sg13cmos5l_a22oi_1
X_08187_ _11180_/D _08317_/A1 _08228_/B _08186_/Y VPWR VGND sg13cmos5l_o21ai_1
X_07138_ _11734_/D _05888_/Y _07148_/A2 _07137_/Y VPWR VGND sg13cmos5l_a21oi_1
X_11527__1129 _11527_/RESET_B VPWR VGND sg13cmos5l_tiehi
XFILLER_106_546 VPWR VGND sg13cmos5l_decap_8
X_07069_ _07069_/Y _08616_/A _07068_/Y _07063_/Y VPWR VGND sg13cmos5l_a21oi_1
XFILLER_88_953 VPWR VGND sg13cmos5l_decap_8
XFILLER_88_931 VPWR VGND sg13cmos5l_decap_8
XFILLER_87_430 VPWR VGND sg13cmos5l_fill_1
XFILLER_0_824 VPWR VGND sg13cmos5l_decap_8
X_10080_ _10080_/Y _10070_/A _10837_/Q _10092_/B1 VPWR VGND sg13cmos5l_o21ai_1
XFILLER_87_441 VPWR VGND sg13cmos5l_fill_2
XFILLER_102_796 VPWR VGND sg13cmos5l_decap_4
XFILLER_88_997 VPWR VGND sg13cmos5l_fill_1
XFILLER_74_113 VPWR VGND sg13cmos5l_decap_8
XFILLER_59_176 VPWR VGND sg13cmos5l_fill_1
XFILLER_47_338 VPWR VGND sg13cmos5l_decap_4
XFILLER_74_135 VPWR VGND sg13cmos5l_decap_4
XFILLER_74_23 VPWR VGND sg13cmos5l_decap_8
XFILLER_56_850 VPWR VGND sg13cmos5l_fill_2
X_10980__1002 _10980_/RESET_B VPWR VGND sg13cmos5l_tiehi
X_10982_ _10982_/Q clkload54/A _10982_/D _10982_/RESET_B VPWR VGND sg13cmos5l_dfrbpq_1
XFILLER_62_308 VPWR VGND sg13cmos5l_decap_4
XFILLER_15_202 VPWR VGND sg13cmos5l_decap_8
XFILLER_28_596 VPWR VGND sg13cmos5l_fill_2
XFILLER_15_257 VPWR VGND sg13cmos5l_decap_4
X_11603_ _11603_/Q clkload27/A _11603_/D _11603_/RESET_B VPWR VGND sg13cmos5l_dfrbpq_1
XFILLER_30_227 VPWR VGND sg13cmos5l_fill_1
X_11534_ _11534_/Q _11535_/CLK _11534_/D _11534_/RESET_B VPWR VGND sg13cmos5l_dfrbpq_1
X_11465_ _11465_/Q clkload20/A _11465_/D _11465_/RESET_B VPWR VGND sg13cmos5l_dfrbpq_1
XFILLER_99_53 VPWR VGND sg13cmos5l_decap_8
X_10416_ _10416_/Y _10414_/Y _10415_/Y _10443_/B1 VPWR VGND sg13cmos5l_o21ai_1
XFILLER_98_706 VPWR VGND sg13cmos5l_fill_2
X_11396_ _11396_/Q clkload18/A _11396_/D _11396_/RESET_B VPWR VGND sg13cmos5l_dfrbpq_1
X_10347_ _10347_/Y _11402_/Q _10839_/Q VPWR VGND sg13cmos5l_nand2_1
X_10278_ _10290_/A _10277_/B _10277_/C _10261_/Y VPWR VGND sg13cmos5l_o21ai_1
XFILLER_78_496 VPWR VGND sg13cmos5l_decap_8
XFILLER_38_327 VPWR VGND sg13cmos5l_decap_4
XFILLER_94_989 VPWR VGND sg13cmos5l_fill_2
XFILLER_65_168 VPWR VGND sg13cmos5l_decap_4
XFILLER_0_42 VPWR VGND sg13cmos5l_fill_1
XFILLER_0_1006 VPWR VGND sg13cmos5l_decap_8
XFILLER_74_680 VPWR VGND sg13cmos5l_fill_2
XFILLER_62_831 VPWR VGND sg13cmos5l_decap_4
XFILLER_47_894 VPWR VGND sg13cmos5l_fill_2
XFILLER_46_371 VPWR VGND sg13cmos5l_decap_8
XFILLER_0_86 VPWR VGND sg13cmos5l_decap_8
X_06440_ _06442_/A _06244_/Y _06430_/Y _06439_/Y VPWR VGND sg13cmos5l_o21ai_1
XFILLER_55_1019 VPWR VGND sg13cmos5l_decap_8
XFILLER_22_706 VPWR VGND sg13cmos5l_decap_8
XFILLER_21_205 VPWR VGND sg13cmos5l_fill_2
XFILLER_22_728 VPWR VGND sg13cmos5l_decap_8
XFILLER_34_599 VPWR VGND sg13cmos5l_decap_8
X_06371_ _06374_/B _06732_/A _06371_/B VPWR VGND sg13cmos5l_nand2_1
X_08110_ _08110_/Y _08110_/A _08112_/B VPWR VGND sg13cmos5l_nand2_1
X_09090_ _09090_/Y _09104_/A _09087_/Y _09089_/Y VPWR VGND sg13cmos5l_a21oi_1
X_08041_ _08041_/Y _08041_/A _08041_/B VPWR VGND sg13cmos5l_nor2_1
X_09992_ _09992_/Y _05985_/Y _09981_/B _09991_/Y VPWR VGND sg13cmos5l_a21oi_1
X_11738__1204 _11738_/RESET_B VPWR VGND sg13cmos5l_tiehi
XFILLER_0_109 VPWR VGND sg13cmos5l_fill_2
Xhold2303 _08179_/A _11177_/Q VPWR VGND sg13cmos5l_dlygate4sd3_1
X_08943_ _08953_/B _08954_/C _08943_/B VPWR VGND sg13cmos5l_nand2b_1
X_11132__1769 _11132_/RESET_B VPWR VGND sg13cmos5l_tiehi
Xhold2325 _07899_/A _11040_/Q VPWR VGND sg13cmos5l_dlygate4sd3_1
Xhold2336 _07913_/A _11047_/Q VPWR VGND sg13cmos5l_dlygate4sd3_1
XFILLER_97_750 VPWR VGND sg13cmos5l_fill_2
Xclkbuf_4_15_0_clk clkload6/A clkbuf_0_clk/X VPWR VGND sg13cmos5l_buf_8
Xhold2314 _07660_/A _10924_/Q VPWR VGND sg13cmos5l_dlygate4sd3_1
XFILLER_85_934 VPWR VGND sg13cmos5l_decap_8
Xhold2347 _11642_/D _06934_/Y VPWR VGND sg13cmos5l_dlygate4sd3_1
XFILLER_69_496 VPWR VGND sg13cmos5l_fill_1
XFILLER_69_474 VPWR VGND sg13cmos5l_fill_2
XFILLER_57_636 VPWR VGND sg13cmos5l_decap_4
X_08874_ _08875_/B _11383_/Q _08876_/A _08886_/A VPWR VGND sg13cmos5l_a21oi_1
Xhold2358 _07995_/A _11087_/Q VPWR VGND sg13cmos5l_dlygate4sd3_1
XFILLER_29_305 VPWR VGND sg13cmos5l_decap_8
Xhold2369 _07335_/A _10873_/Q VPWR VGND sg13cmos5l_dlygate4sd3_1
XFILLER_84_444 VPWR VGND sg13cmos5l_fill_1
X_07825_ _11004_/D fanout80/X _07834_/B _07824_/Y VPWR VGND sg13cmos5l_o21ai_1
XFILLER_72_628 VPWR VGND sg13cmos5l_fill_2
XFILLER_72_617 VPWR VGND sg13cmos5l_decap_8
X_07756_ _07756_/Y _07756_/A _07778_/B VPWR VGND sg13cmos5l_nor2_1
XFILLER_56_168 VPWR VGND sg13cmos5l_decap_8
XFILLER_65_691 VPWR VGND sg13cmos5l_fill_1
XFILLER_44_26 VPWR VGND sg13cmos5l_decap_4
X_06707_ _06707_/Y _06234_/A _06665_/B _06706_/Y _06233_/X VPWR VGND sg13cmos5l_a22oi_1
X_09426_ _09426_/Y _11281_/Q _09578_/A2 _09425_/Y VPWR VGND sg13cmos5l_o21ai_1
X_07687_ _10937_/D fanout99/X _07694_/B _07686_/Y VPWR VGND sg13cmos5l_a21oi_1
XFILLER_100_21 VPWR VGND sg13cmos5l_decap_8
XFILLER_52_363 VPWR VGND sg13cmos5l_fill_1
X_06638_ _06639_/B _06636_/A _06352_/Y _06633_/A VPWR VGND sg13cmos5l_o21ai_1
X_06569_ _06569_/Y _06569_/A _06569_/B VPWR VGND sg13cmos5l_nand2_1
X_09357_ _09357_/Y _09177_/Y _09194_/Y _09356_/Y VPWR VGND sg13cmos5l_o21ai_1
XFILLER_100_98 VPWR VGND sg13cmos5l_decap_8
X_08308_ _11240_/D fanout52/X _08307_/B _08307_/Y VPWR VGND sg13cmos5l_a21oi_1
X_09288_ _09288_/Y _09286_/Y _09287_/Y _10043_/C1 VPWR VGND sg13cmos5l_a21oi_1
X_08239_ _11206_/D fanout55/X _08244_/B _08238_/Y VPWR VGND sg13cmos5l_o21ai_1
X_10797__934 _10797_/RESET_B VPWR VGND sg13cmos5l_tiehi
X_11250_ _11250_/Q _11668_/CLK _11250_/D _11250_/RESET_B VPWR VGND sg13cmos5l_dfrbpq_1
XFILLER_106_343 VPWR VGND sg13cmos5l_decap_8
XFILLER_69_34 VPWR VGND sg13cmos5l_fill_2
X_10201_ _10202_/B _10194_/A _10194_/B _10191_/Y VPWR VGND sg13cmos5l_o21ai_1
X_11181_ _11181_/Q clkload10/A _11181_/D _11181_/RESET_B VPWR VGND sg13cmos5l_dfrbpq_1
XFILLER_79_216 VPWR VGND sg13cmos5l_decap_8
X_10132_ _10132_/Y _10614_/B2 _10853_/Q _10123_/A VPWR VGND sg13cmos5l_o21ai_1
X_11108__1793 _11108_/RESET_B VPWR VGND sg13cmos5l_tiehi
XFILLER_88_750 VPWR VGND sg13cmos5l_decap_8
XFILLER_0_643 VPWR VGND sg13cmos5l_decap_8
XFILLER_75_422 VPWR VGND sg13cmos5l_decap_4
X_10063_ _10063_/Y _06523_/A hold2896/X _10073_/B VPWR VGND sg13cmos5l_a21oi_1
Xhold2892 hold2892/X _11481_/Q VPWR VGND sg13cmos5l_dlygate4sd3_1
Xhold2870 _05963_/A _10840_/Q VPWR VGND sg13cmos5l_dlygate4sd3_1
XFILLER_36_809 VPWR VGND sg13cmos5l_fill_2
Xhold2881 _11510_/D _10131_/Y VPWR VGND sg13cmos5l_dlygate4sd3_1
XFILLER_76_989 VPWR VGND sg13cmos5l_decap_4
X_11287__1614 _11287_/RESET_B VPWR VGND sg13cmos5l_tiehi
XFILLER_75_499 VPWR VGND sg13cmos5l_fill_1
XFILLER_62_127 VPWR VGND sg13cmos5l_decap_4
XFILLER_44_842 VPWR VGND sg13cmos5l_fill_1
XFILLER_28_382 VPWR VGND sg13cmos5l_decap_8
XFILLER_43_352 VPWR VGND sg13cmos5l_fill_2
X_10965_ _10965_/Q clkload40/A _10965_/D _10965_/RESET_B VPWR VGND sg13cmos5l_dfrbpq_1
X_10896_ _10896_/Q _11671_/CLK _10896_/D _10896_/RESET_B VPWR VGND sg13cmos5l_dfrbpq_1
XFILLER_31_503 VPWR VGND sg13cmos5l_fill_1
XFILLER_31_525 VPWR VGND sg13cmos5l_fill_2
XFILLER_43_396 VPWR VGND sg13cmos5l_decap_4
XFILLER_8_710 VPWR VGND sg13cmos5l_fill_1
XFILLER_12_772 VPWR VGND sg13cmos5l_decap_8
XFILLER_15_1014 VPWR VGND sg13cmos5l_decap_8
X_11517_ _11517_/Q clkload45/A _11517_/D _11517_/RESET_B VPWR VGND sg13cmos5l_dfrbpq_1
XFILLER_8_754 VPWR VGND sg13cmos5l_decap_8
XFILLER_11_293 VPWR VGND sg13cmos5l_decap_8
XFILLER_7_242 VPWR VGND sg13cmos5l_decap_8
X_11448_ _11448_/Q clkload55/A _11448_/D _11448_/RESET_B VPWR VGND sg13cmos5l_dfrbpq_1
X_11379_ _11379_/Q clkload28/A _11379_/D _11379_/RESET_B VPWR VGND sg13cmos5l_dfrbpq_1
XFILLER_98_525 VPWR VGND sg13cmos5l_fill_2
XFILLER_4_993 VPWR VGND sg13cmos5l_decap_8
X_10854__1134 _10854_/RESET_B VPWR VGND sg13cmos5l_tiehi
X_11440__1410 _11440_/RESET_B VPWR VGND sg13cmos5l_tiehi
XFILLER_85_208 VPWR VGND sg13cmos5l_fill_1
X_05940_ _09303_/C _10826_/Q VPWR VGND sg13cmos5l_inv_1
XFILLER_66_400 VPWR VGND sg13cmos5l_fill_2
XFILLER_39_625 VPWR VGND sg13cmos5l_fill_2
XFILLER_38_135 VPWR VGND sg13cmos5l_fill_2
X_05871_ _07521_/C _11402_/Q VPWR VGND sg13cmos5l_inv_1
X_11491__1201 _11491_/RESET_B VPWR VGND sg13cmos5l_tiehi
X_08590_ _08590_/Y _11051_/Q _10020_/B VPWR VGND sg13cmos5l_nand2_1
X_07610_ _07610_/Y _10591_/A _07617_/C _07650_/A VPWR VGND sg13cmos5l_o21ai_1
XFILLER_54_639 VPWR VGND sg13cmos5l_fill_1
X_07541_ _07541_/Y _07591_/A _07541_/B VPWR VGND sg13cmos5l_nand2_1
XFILLER_90_970 VPWR VGND sg13cmos5l_fill_1
XFILLER_62_661 VPWR VGND sg13cmos5l_fill_1
X_07472_ _07479_/B _11397_/Q _11396_/Q _10191_/A _07472_/D VPWR VGND sg13cmos5l_nand4_1
X_06423_ _06424_/B _06423_/A _06423_/B VPWR VGND sg13cmos5l_nand2_1
XFILLER_61_182 VPWR VGND sg13cmos5l_decap_8
XFILLER_22_536 VPWR VGND sg13cmos5l_fill_2
X_09211_ _09211_/Y _09211_/A _09211_/B VPWR VGND sg13cmos5l_nor2_1
X_09142_ _09142_/Y _09139_/Y _09140_/X _09153_/A1 VPWR VGND sg13cmos5l_a21oi_1
XFILLER_50_889 VPWR VGND sg13cmos5l_decap_8
X_06354_ _06358_/A _06173_/B _06633_/A _06171_/Y VPWR VGND sg13cmos5l_o21ai_1
X_09073_ _09073_/Y _08738_/Y _09068_/B _09056_/A VPWR VGND sg13cmos5l_o21ai_1
X_06285_ _06625_/B _06274_/Y _06284_/Y _06620_/A VPWR VGND sg13cmos5l_o21ai_1
X_08024_ _11101_/D fanout78/X _08023_/B _08023_/Y VPWR VGND sg13cmos5l_a21oi_1
X_11670__1294 _11670_/RESET_B VPWR VGND sg13cmos5l_tiehi
XFILLER_30_39 VPWR VGND sg13cmos5l_decap_8
X_11365__1536 _11365_/RESET_B VPWR VGND sg13cmos5l_tiehi
Xhold2100 _07915_/A _11048_/Q VPWR VGND sg13cmos5l_dlygate4sd3_1
X_09975_ _11483_/D _09856_/A _10055_/A _09949_/Y _09974_/Y VPWR VGND sg13cmos5l_a22oi_1
Xhold2111 _07991_/A _11085_/Q VPWR VGND sg13cmos5l_dlygate4sd3_1
XFILLER_103_379 VPWR VGND sg13cmos5l_decap_8
Xhold2133 _07450_/A _10891_/Q VPWR VGND sg13cmos5l_dlygate4sd3_1
X_08926_ _08926_/Y _11387_/Q _08931_/A VPWR VGND sg13cmos5l_nand2_1
Xhold2122 _07730_/A _10958_/Q VPWR VGND sg13cmos5l_dlygate4sd3_1
Xhold2144 _08279_/A _11226_/Q VPWR VGND sg13cmos5l_dlygate4sd3_1
Xhold2177 _07897_/A _11039_/Q VPWR VGND sg13cmos5l_dlygate4sd3_1
Xhold2155 _08289_/A _11231_/Q VPWR VGND sg13cmos5l_dlygate4sd3_1
XFILLER_85_742 VPWR VGND sg13cmos5l_fill_1
XFILLER_58_956 VPWR VGND sg13cmos5l_decap_4
X_08857_ _11431_/D _08855_/Y _08856_/Y _08846_/Y VPWR VGND sg13cmos5l_o21ai_1
Xhold2166 _07740_/A _10963_/Q VPWR VGND sg13cmos5l_dlygate4sd3_1
Xhold2188 _07859_/A _11020_/Q VPWR VGND sg13cmos5l_dlygate4sd3_1
Xhold2199 _07706_/A _10947_/Q VPWR VGND sg13cmos5l_dlygate4sd3_1
X_07808_ _07808_/Y _07808_/A _07808_/B VPWR VGND sg13cmos5l_nand2_1
XFILLER_29_146 VPWR VGND sg13cmos5l_fill_1
XFILLER_84_285 VPWR VGND sg13cmos5l_fill_2
XFILLER_84_274 VPWR VGND sg13cmos5l_decap_8
X_08788_ _11425_/D _08786_/Y _08787_/Y _08778_/Y VPWR VGND sg13cmos5l_o21ai_1
X_07739_ _10962_/D _08524_/A1 _07748_/B _07738_/Y VPWR VGND sg13cmos5l_a21oi_1
X_10750_ _10750_/Y _05858_/Y _10747_/B _10749_/A VPWR VGND sg13cmos5l_o21ai_1
XFILLER_53_672 VPWR VGND sg13cmos5l_decap_4
XFILLER_40_311 VPWR VGND sg13cmos5l_decap_8
XFILLER_25_363 VPWR VGND sg13cmos5l_fill_2
XFILLER_25_385 VPWR VGND sg13cmos5l_decap_8
X_10681_ _10682_/B hold2864/X _09278_/A _06242_/A _10681_/B2 VPWR VGND sg13cmos5l_a22oi_1
XFILLER_41_867 VPWR VGND sg13cmos5l_fill_1
X_09409_ _11462_/D _06191_/B _09460_/A _09386_/Y _09408_/Y VPWR VGND sg13cmos5l_a22oi_1
XFILLER_40_388 VPWR VGND sg13cmos5l_decap_4
X_11302_ _11302_/Q clkload53/A _11302_/D _11302_/RESET_B VPWR VGND sg13cmos5l_dfrbpq_1
XFILLER_5_735 VPWR VGND sg13cmos5l_decap_8
XFILLER_106_140 VPWR VGND sg13cmos5l_decap_8
XFILLER_105_0 VPWR VGND sg13cmos5l_decap_8
X_11233_ _11233_/Q _11265_/CLK _11233_/D _11233_/RESET_B VPWR VGND sg13cmos5l_dfrbpq_1
XFILLER_20_83 VPWR VGND sg13cmos5l_fill_2
XFILLER_96_21 VPWR VGND sg13cmos5l_decap_8
XFILLER_68_709 VPWR VGND sg13cmos5l_decap_8
XFILLER_0_440 VPWR VGND sg13cmos5l_decap_4
X_11164_ _11164_/Q _11265_/CLK _11164_/D _11164_/RESET_B VPWR VGND sg13cmos5l_dfrbpq_1
XFILLER_95_528 VPWR VGND sg13cmos5l_decap_8
XFILLER_95_539 VPWR VGND sg13cmos5l_fill_1
X_11095_ _11095_/Q clkload17/A _11095_/D _11095_/RESET_B VPWR VGND sg13cmos5l_dfrbpq_1
XFILLER_1_974 VPWR VGND sg13cmos5l_decap_8
X_10115_ _11506_/D _10434_/B _10115_/A2 _10114_/Y VPWR VGND sg13cmos5l_a21o_1
X_10046_ _10046_/Y _11368_/Q _09894_/B _10046_/B1 VPWR VGND sg13cmos5l_a21oi_1
XFILLER_75_230 VPWR VGND sg13cmos5l_fill_1
XFILLER_49_945 VPWR VGND sg13cmos5l_fill_2
XFILLER_76_775 VPWR VGND sg13cmos5l_fill_2
XFILLER_75_241 VPWR VGND sg13cmos5l_fill_2
XFILLER_91_734 VPWR VGND sg13cmos5l_decap_8
XFILLER_91_723 VPWR VGND sg13cmos5l_fill_2
XFILLER_75_296 VPWR VGND sg13cmos5l_decap_8
X_11722__1236 _11722_/RESET_B VPWR VGND sg13cmos5l_tiehi
XFILLER_63_436 VPWR VGND sg13cmos5l_fill_2
XFILLER_35_127 VPWR VGND sg13cmos5l_fill_1
XFILLER_35_138 VPWR VGND sg13cmos5l_fill_2
X_10948_ _10948_/Q _11594_/CLK _10948_/D _10948_/RESET_B VPWR VGND sg13cmos5l_dfrbpq_1
XFILLER_72_970 VPWR VGND sg13cmos5l_fill_2
X_11023__902 _11023_/RESET_B VPWR VGND sg13cmos5l_tiehi
XFILLER_44_672 VPWR VGND sg13cmos5l_decap_8
XFILLER_31_333 VPWR VGND sg13cmos5l_decap_8
XFILLER_31_344 VPWR VGND sg13cmos5l_fill_2
X_10879_ _10879_/Q clkload7/A _10879_/D _10879_/RESET_B VPWR VGND sg13cmos5l_dfrbpq_1
XFILLER_31_388 VPWR VGND sg13cmos5l_decap_8
XFILLER_61_90 VPWR VGND sg13cmos5l_fill_1
X_06070_ _06070_/Y _06790_/A _06064_/B _05934_/Y VPWR VGND sg13cmos5l_a21oi_1
XFILLER_8_595 VPWR VGND sg13cmos5l_decap_4
XANTENNA_1 _07346_/Y VPWR VGND sg13cmos5l_antennanp
XFILLER_99_823 VPWR VGND sg13cmos5l_fill_1
XFILLER_98_355 VPWR VGND sg13cmos5l_fill_1
XFILLER_98_333 VPWR VGND sg13cmos5l_decap_4
Xfanout508 _10704_/B fanout518/X VPWR VGND sg13cmos5l_buf_1
Xfanout519 _07515_/A _07652_/A1 VPWR VGND sg13cmos5l_buf_1
XFILLER_100_316 VPWR VGND sg13cmos5l_decap_8
XFILLER_98_388 VPWR VGND sg13cmos5l_fill_1
X_09760_ _09766_/B _09756_/Y _09757_/Y _09758_/Y _09759_/Y _10043_/C1 VPWR VGND sg13cmos5l_a221oi_1
X_11647__1318 _11647_/RESET_B VPWR VGND sg13cmos5l_tiehi
X_06972_ _06972_/Y _06972_/A _07038_/B VPWR VGND sg13cmos5l_nand2_1
X_09691_ _09691_/Y _11291_/Q _09903_/B _09690_/Y VPWR VGND sg13cmos5l_o21ai_1
X_08711_ _11408_/D _08711_/A VPWR VGND sg13cmos5l_inv_1
XFILLER_39_422 VPWR VGND sg13cmos5l_decap_8
XFILLER_20_0 VPWR VGND sg13cmos5l_fill_2
X_05923_ _07032_/A _05923_/A VPWR VGND sg13cmos5l_inv_1
X_08642_ _11387_/D _11698_/D hold2710/X _08642_/S VPWR VGND sg13cmos5l_mux2_1
XFILLER_82_745 VPWR VGND sg13cmos5l_decap_8
XFILLER_54_436 VPWR VGND sg13cmos5l_decap_8
XFILLER_26_127 VPWR VGND sg13cmos5l_decap_8
X_08573_ _08573_/X _10922_/Q _10890_/Q _08573_/S VPWR VGND sg13cmos5l_mux2_1
XFILLER_82_756 VPWR VGND sg13cmos5l_fill_1
XFILLER_70_929 VPWR VGND sg13cmos5l_decap_4
X_11404__1482 _11404_/RESET_B VPWR VGND sg13cmos5l_tiehi
X_11688__1276 _11688_/RESET_B VPWR VGND sg13cmos5l_tiehi
XFILLER_63_981 VPWR VGND sg13cmos5l_decap_8
X_11532__1523 _11532_/RESET_B VPWR VGND sg13cmos5l_tiehi
XFILLER_25_39 VPWR VGND sg13cmos5l_fill_1
X_07524_ _07524_/Y _07515_/A _08689_/B _07523_/Y VPWR VGND sg13cmos5l_o21ai_1
XFILLER_22_333 VPWR VGND sg13cmos5l_decap_8
X_07455_ _07455_/Y _07455_/A _07517_/B VPWR VGND sg13cmos5l_nor2_1
X_06406_ _10821_/D _06759_/A1 _06402_/Y _06405_/Y VPWR VGND sg13cmos5l_o21ai_1
XFILLER_10_517 VPWR VGND sg13cmos5l_fill_1
X_07386_ _08742_/A _09055_/A _07416_/B VPWR VGND sg13cmos5l_nand2_1
X_06337_ _06340_/S _06443_/A _06338_/S _06273_/Y VPWR VGND sg13cmos5l_a21oi_1
X_09125_ _09126_/A _09150_/A _09127_/B VPWR VGND sg13cmos5l_nand2_1
X_06268_ _06761_/A _06269_/A _06269_/B VPWR VGND sg13cmos5l_nor2_1
X_09056_ _09069_/D _09056_/A _09068_/B VPWR VGND sg13cmos5l_xnor2_1
X_08007_ _08007_/Y _08007_/A _08007_/B VPWR VGND sg13cmos5l_nor2_1
XFILLER_89_311 VPWR VGND sg13cmos5l_decap_4
X_06199_ _06618_/B _10069_/A _09405_/A VPWR VGND sg13cmos5l_and2_1
XFILLER_104_633 VPWR VGND sg13cmos5l_fill_2
XFILLER_89_333 VPWR VGND sg13cmos5l_fill_2
Xheichips26_RiMaX_1825 uio_oe[10] VPWR VGND sg13cmos5l_tiehi
XFILLER_106_42 VPWR VGND sg13cmos5l_decap_8
XFILLER_103_154 VPWR VGND sg13cmos5l_decap_8
X_09958_ _09958_/Y _11045_/Q _09955_/B _09982_/B1 VPWR VGND sg13cmos5l_a21oi_1
XFILLER_66_35 VPWR VGND sg13cmos5l_decap_8
XFILLER_58_731 VPWR VGND sg13cmos5l_decap_8
X_08909_ _08913_/A _08862_/A _08862_/B _08908_/Y VPWR VGND sg13cmos5l_o21ai_1
XFILLER_92_509 VPWR VGND sg13cmos5l_fill_1
XFILLER_85_550 VPWR VGND sg13cmos5l_decap_4
XFILLER_66_46 VPWR VGND sg13cmos5l_decap_8
X_09889_ _09889_/Y _09915_/A _09889_/B _09889_/C _09889_/D VPWR VGND sg13cmos5l_nor4_1
XFILLER_58_764 VPWR VGND sg13cmos5l_decap_8
XFILLER_85_583 VPWR VGND sg13cmos5l_decap_8
XFILLER_73_734 VPWR VGND sg13cmos5l_fill_2
XFILLER_57_296 VPWR VGND sg13cmos5l_decap_8
XFILLER_17_127 VPWR VGND sg13cmos5l_fill_1
XFILLER_33_609 VPWR VGND sg13cmos5l_decap_8
X_10802_ _10802_/Q clkload15/A _10802_/D _10802_/RESET_B VPWR VGND sg13cmos5l_dfrbpq_1
X_10733_ _11561_/D _10739_/A _10733_/B VPWR VGND sg13cmos5l_nor2_1
XFILLER_82_67 VPWR VGND sg13cmos5l_decap_8
XFILLER_41_642 VPWR VGND sg13cmos5l_decap_8
XFILLER_40_152 VPWR VGND sg13cmos5l_decap_4
XFILLER_40_141 VPWR VGND sg13cmos5l_fill_1
X_10664_ _11548_/D _10685_/A _10664_/B _10664_/C VPWR VGND sg13cmos5l_nor3_1
XFILLER_13_388 VPWR VGND sg13cmos5l_fill_2
XFILLER_13_399 VPWR VGND sg13cmos5l_decap_4
X_10595_ _10595_/Y _06321_/B _10656_/B _10614_/C1 VPWR VGND sg13cmos5l_a21oi_1
XFILLER_49_8 VPWR VGND sg13cmos5l_fill_2
XFILLER_5_587 VPWR VGND sg13cmos5l_decap_8
X_11216_ _11216_/Q _11668_/CLK _11216_/D _11216_/RESET_B VPWR VGND sg13cmos5l_dfrbpq_1
X_11147_ _11147_/Q _11339_/CLK _11147_/D _11147_/RESET_B VPWR VGND sg13cmos5l_dfrbpq_1
XFILLER_96_848 VPWR VGND sg13cmos5l_decap_8
XFILLER_95_303 VPWR VGND sg13cmos5l_fill_1
X_11078_ _11078_/Q _11362_/CLK _11078_/D _11078_/RESET_B VPWR VGND sg13cmos5l_dfrbpq_1
XFILLER_76_561 VPWR VGND sg13cmos5l_fill_1
XFILLER_76_550 VPWR VGND sg13cmos5l_decap_8
X_10029_ _10029_/Y _10055_/A _10029_/B _10029_/C VPWR VGND sg13cmos5l_nor3_1
XFILLER_63_200 VPWR VGND sg13cmos5l_decap_8
XFILLER_36_425 VPWR VGND sg13cmos5l_decap_4
XFILLER_91_542 VPWR VGND sg13cmos5l_decap_4
XFILLER_63_299 VPWR VGND sg13cmos5l_fill_1
XFILLER_60_940 VPWR VGND sg13cmos5l_fill_2
XFILLER_20_804 VPWR VGND sg13cmos5l_decap_8
X_07240_ _10854_/D _07244_/A _07240_/B VPWR VGND sg13cmos5l_nand2_1
XFILLER_20_848 VPWR VGND sg13cmos5l_decap_4
X_07171_ _10829_/D _07250_/A _07171_/B VPWR VGND sg13cmos5l_nand2_1
X_06122_ _06122_/Y _06134_/A _06122_/B VPWR VGND sg13cmos5l_nand2_1
XFILLER_105_419 VPWR VGND sg13cmos5l_decap_8
X_06053_ _06053_/Y _10161_/B _11641_/Q _06051_/B _06014_/B VPWR VGND sg13cmos5l_a22oi_1
XFILLER_99_631 VPWR VGND sg13cmos5l_decap_8
Xfanout305 _07844_/B _07813_/A2 VPWR VGND sg13cmos5l_buf_1
Xfanout316 _08053_/A1 _07449_/Y VPWR VGND sg13cmos5l_buf_1
Xfanout338 _10019_/B _06477_/Y VPWR VGND sg13cmos5l_buf_1
X_09812_ _09813_/B hold2935/X _09810_/Y _10032_/A VPWR VGND sg13cmos5l_a21oi_1
Xfanout327 _07060_/A2 _07044_/B1 VPWR VGND sg13cmos5l_buf_1
XFILLER_86_336 VPWR VGND sg13cmos5l_fill_1
Xfanout349 _09537_/A _10026_/A VPWR VGND sg13cmos5l_buf_1
XFILLER_100_168 VPWR VGND sg13cmos5l_decap_8
X_06955_ _06955_/Y _11391_/Q _06955_/B VPWR VGND sg13cmos5l_nor2_1
XFILLER_39_241 VPWR VGND sg13cmos5l_decap_8
X_09743_ _09743_/Y _09737_/Y _09738_/Y _09742_/Y _09851_/B2 VPWR VGND sg13cmos5l_a22oi_1
X_06886_ _06886_/X _11725_/Q hold2585/X _07088_/S VPWR VGND sg13cmos5l_mux2_1
X_05906_ _10423_/A _10305_/A VPWR VGND sg13cmos5l_inv_1
X_09674_ _09674_/Y _09696_/A _10845_/Q _09649_/Y VPWR VGND sg13cmos5l_a21oi_1
XFILLER_55_745 VPWR VGND sg13cmos5l_fill_1
X_08625_ _08625_/Y _08625_/A _08625_/B _08625_/C VPWR VGND sg13cmos5l_nor3_1
XFILLER_43_907 VPWR VGND sg13cmos5l_fill_1
XFILLER_39_296 VPWR VGND sg13cmos5l_decap_8
XFILLER_36_49 VPWR VGND sg13cmos5l_decap_4
X_08556_ _11362_/D fanout63/X _08563_/B _08555_/Y VPWR VGND sg13cmos5l_a21oi_1
XFILLER_82_597 VPWR VGND sg13cmos5l_fill_1
XFILLER_70_726 VPWR VGND sg13cmos5l_fill_1
XFILLER_36_981 VPWR VGND sg13cmos5l_fill_1
XFILLER_74_1022 VPWR VGND sg13cmos5l_decap_8
XFILLER_52_15 VPWR VGND sg13cmos5l_fill_1
XFILLER_42_439 VPWR VGND sg13cmos5l_decap_8
X_07507_ _07514_/B _07521_/C _07521_/D VPWR VGND sg13cmos5l_nor2_1
X_08487_ _11328_/D fanout72/X _08498_/B _08486_/Y VPWR VGND sg13cmos5l_o21ai_1
X_07438_ _08376_/C _11562_/Q _11561_/Q _07720_/C VPWR VGND sg13cmos5l_nand3_1
XFILLER_52_59 VPWR VGND sg13cmos5l_fill_1
X_07369_ _07369_/Y _07367_/Y _08731_/A _07375_/B1 VPWR VGND sg13cmos5l_a21oi_1
XFILLER_11_859 VPWR VGND sg13cmos5l_fill_2
X_09108_ _09108_/Y _09108_/A _09155_/B VPWR VGND sg13cmos5l_nand2_1
XFILLER_10_369 VPWR VGND sg13cmos5l_fill_1
X_10380_ _10454_/B _10351_/B _10362_/Y _10363_/Y VPWR VGND sg13cmos5l_a21oi_1
X_09039_ _09039_/Y _09051_/A1 _09035_/X _09038_/Y VPWR VGND sg13cmos5l_a21oi_1
XFILLER_2_502 VPWR VGND sg13cmos5l_decap_8
XFILLER_105_953 VPWR VGND sg13cmos5l_decap_8
XFILLER_104_430 VPWR VGND sg13cmos5l_decap_4
XFILLER_78_837 VPWR VGND sg13cmos5l_fill_1
XFILLER_78_826 VPWR VGND sg13cmos5l_decap_8
XFILLER_77_23 VPWR VGND sg13cmos5l_decap_8
X_11001_ _11001_/Q clkload40/A _11001_/D _11001_/RESET_B VPWR VGND sg13cmos5l_dfrbpq_1
XFILLER_18_403 VPWR VGND sg13cmos5l_fill_1
XFILLER_19_948 VPWR VGND sg13cmos5l_decap_8
X_11145__1756 _11145_/RESET_B VPWR VGND sg13cmos5l_tiehi
XFILLER_73_531 VPWR VGND sg13cmos5l_fill_2
XFILLER_93_77 VPWR VGND sg13cmos5l_decap_8
XFILLER_61_737 VPWR VGND sg13cmos5l_decap_8
XFILLER_33_428 VPWR VGND sg13cmos5l_decap_4
XFILLER_33_439 VPWR VGND sg13cmos5l_fill_1
X_11765_ _11765_/Q _11767_/CLK _11765_/D _11765_/RESET_B VPWR VGND sg13cmos5l_dfrbpq_1
XFILLER_13_130 VPWR VGND sg13cmos5l_fill_1
X_10716_ _11557_/D _10694_/A _10712_/B _10730_/A _05860_/Y _10739_/A VPWR VGND sg13cmos5l_a221oi_1
X_11696_ _11696_/Q clkload19/A _11696_/D _11696_/RESET_B VPWR VGND sg13cmos5l_dfrbpq_1
X_11020__905 _11020_/RESET_B VPWR VGND sg13cmos5l_tiehi
X_11360__1541 _11360_/RESET_B VPWR VGND sg13cmos5l_tiehi
X_10647_ _10648_/C hold2767/X _10675_/B fanout85/X VPWR VGND sg13cmos5l_a21oi_1
X_10578_ _10592_/B _10578_/A _10578_/B VPWR VGND sg13cmos5l_or2_1
XFILLER_6_841 VPWR VGND sg13cmos5l_decap_4
XFILLER_54_6 VPWR VGND sg13cmos5l_fill_1
XFILLER_5_362 VPWR VGND sg13cmos5l_decap_8
XFILLER_3_1004 VPWR VGND sg13cmos5l_decap_8
X_06740_ _06741_/B _06739_/A _06737_/Y _06739_/Y VPWR VGND sg13cmos5l_a21o_1
XFILLER_64_542 VPWR VGND sg13cmos5l_fill_2
X_06671_ _06671_/Y _11499_/Q _09214_/A _06679_/A VPWR VGND sg13cmos5l_a21oi_1
XFILLER_25_907 VPWR VGND sg13cmos5l_fill_2
XFILLER_52_726 VPWR VGND sg13cmos5l_decap_8
X_08410_ _11290_/D fanout96/X _08415_/B _08409_/Y VPWR VGND sg13cmos5l_a21oi_1
XFILLER_18_981 VPWR VGND sg13cmos5l_decap_4
X_11607__1374 _11607_/RESET_B VPWR VGND sg13cmos5l_tiehi
X_09390_ _09390_/Y _10928_/Q _09492_/B VPWR VGND sg13cmos5l_nand2_1
XFILLER_33_951 VPWR VGND sg13cmos5l_decap_8
X_08341_ _11256_/D _08471_/A1 _08340_/B _08340_/Y VPWR VGND sg13cmos5l_o21ai_1
X_08272_ _11222_/D _08337_/A1 _08273_/B _08271_/Y VPWR VGND sg13cmos5l_a21oi_1
X_10934__1048 _10934_/RESET_B VPWR VGND sg13cmos5l_tiehi
X_07223_ _07223_/Y _08955_/A _11632_/Q _07227_/B1 hold2685/X _07225_/C1 VPWR VGND
+ sg13cmos5l_a221oi_1
X_07154_ _11742_/D _05880_/Y _07154_/A2 _07153_/Y VPWR VGND sg13cmos5l_a21oi_1
XFILLER_106_728 VPWR VGND sg13cmos5l_decap_8
X_07085_ _11695_/D hold2613/X _07181_/A _07088_/S VPWR VGND sg13cmos5l_mux2_1
X_06105_ _06105_/Y _06107_/S VPWR VGND sg13cmos5l_inv_1
XFILLER_105_238 VPWR VGND sg13cmos5l_decap_8
X_06036_ _06046_/C _06828_/A _11609_/Q _06823_/A _06813_/A VPWR VGND sg13cmos5l_nor4_1
X_11223__1678 _11223_/RESET_B VPWR VGND sg13cmos5l_tiehi
XFILLER_102_901 VPWR VGND sg13cmos5l_fill_1
XFILLER_87_601 VPWR VGND sg13cmos5l_fill_2
Xfanout113 _08640_/A _08645_/S VPWR VGND sg13cmos5l_buf_1
Xfanout102 _08339_/A1 _07531_/Y VPWR VGND sg13cmos5l_buf_1
Xfanout146 _07976_/B _07982_/B VPWR VGND sg13cmos5l_buf_1
XFILLER_99_494 VPWR VGND sg13cmos5l_fill_1
Xfanout124 _08494_/B _08500_/B VPWR VGND sg13cmos5l_buf_1
Xfanout135 _08216_/B _08218_/B VPWR VGND sg13cmos5l_buf_1
X_07987_ _07987_/Y _07987_/A _08043_/B VPWR VGND sg13cmos5l_nor2_1
Xfanout179 _08569_/B _08563_/B VPWR VGND sg13cmos5l_buf_1
XFILLER_75_829 VPWR VGND sg13cmos5l_decap_4
Xfanout168 _07401_/B _07407_/B VPWR VGND sg13cmos5l_buf_1
Xfanout157 _08522_/A1 _08457_/A1 VPWR VGND sg13cmos5l_buf_1
X_06938_ _11643_/D _06931_/B _06936_/Y _06937_/Y VPWR VGND sg13cmos5l_o21ai_1
X_09726_ _09727_/D _09723_/Y _09724_/Y _09725_/Y VPWR VGND sg13cmos5l_o21ai_1
XFILLER_103_21 VPWR VGND sg13cmos5l_decap_8
XFILLER_70_512 VPWR VGND sg13cmos5l_decap_8
X_06869_ _06874_/B _07178_/A _11707_/Q _07181_/A _11708_/Q VPWR VGND sg13cmos5l_nor4_1
XFILLER_43_704 VPWR VGND sg13cmos5l_decap_8
XFILLER_42_203 VPWR VGND sg13cmos5l_fill_2
X_09657_ _09657_/X _11130_/Q _11098_/Q _11066_/Q _11034_/Q _09733_/S _06477_/B VPWR
+ VGND sg13cmos5l_mux4_1
XFILLER_103_98 VPWR VGND sg13cmos5l_decap_8
X_08608_ _08608_/Y _11634_/Q _10164_/B _08607_/Y _10162_/A _09858_/B2 VPWR VGND sg13cmos5l_a221oi_1
XFILLER_42_236 VPWR VGND sg13cmos5l_decap_8
XFILLER_15_428 VPWR VGND sg13cmos5l_decap_8
XFILLER_15_439 VPWR VGND sg13cmos5l_fill_2
X_09588_ _11469_/D _06289_/B _09672_/A _09587_/Y VPWR VGND sg13cmos5l_a21oi_1
X_08539_ _08539_/Y _08539_/A _08553_/B VPWR VGND sg13cmos5l_nor2_1
X_11750__911 _11750_/RESET_B VPWR VGND sg13cmos5l_tiehi
X_11550_ _11550_/Q clkload45/A _11550_/D _11550_/RESET_B VPWR VGND sg13cmos5l_dfrbpq_1
XFILLER_23_461 VPWR VGND sg13cmos5l_fill_2
X_10501_ _10501_/Y _10499_/Y _10501_/B VPWR VGND sg13cmos5l_nand2b_1
X_11481_ _11481_/Q clkload48/A _11481_/D _11481_/RESET_B VPWR VGND sg13cmos5l_dfrbpq_1
XFILLER_10_166 VPWR VGND sg13cmos5l_fill_2
X_10432_ _11533_/D _10488_/A _10432_/B VPWR VGND sg13cmos5l_nand2_1
X_10363_ _10363_/Y _11403_/Q _10840_/Q VPWR VGND sg13cmos5l_nor2_1
XFILLER_2_321 VPWR VGND sg13cmos5l_fill_1
XFILLER_2_332 VPWR VGND sg13cmos5l_fill_2
X_10294_ _10296_/C _10273_/A _10273_/C _10273_/B VPWR VGND sg13cmos5l_a21o_1
XFILLER_104_282 VPWR VGND sg13cmos5l_decap_8
XFILLER_77_122 VPWR VGND sg13cmos5l_fill_1
XFILLER_104_293 VPWR VGND sg13cmos5l_fill_2
XFILLER_78_678 VPWR VGND sg13cmos5l_fill_2
X_11683__1281 _11683_/RESET_B VPWR VGND sg13cmos5l_tiehi
XFILLER_93_648 VPWR VGND sg13cmos5l_decap_4
Xfanout680 _10681_/B2 _10157_/A1 VPWR VGND sg13cmos5l_buf_1
Xfanout691 _06982_/B1 _10171_/B VPWR VGND sg13cmos5l_buf_1
XFILLER_73_350 VPWR VGND sg13cmos5l_fill_2
XFILLER_18_244 VPWR VGND sg13cmos5l_decap_8
XFILLER_33_214 VPWR VGND sg13cmos5l_fill_1
XFILLER_33_225 VPWR VGND sg13cmos5l_fill_2
XFILLER_61_556 VPWR VGND sg13cmos5l_fill_2
XFILLER_18_1001 VPWR VGND sg13cmos5l_fill_1
X_11603__1380 _11603_/RESET_B VPWR VGND sg13cmos5l_tiehi
X_11748_ _11748_/Q clkload24/A _11748_/D _11748_/RESET_B VPWR VGND sg13cmos5l_dfrbpq_1
X_11679_ _11679_/Q clkload11/A _11679_/D _11679_/RESET_B VPWR VGND sg13cmos5l_dfrbpq_1
XFILLER_68_122 VPWR VGND sg13cmos5l_decap_4
X_07910_ _11045_/D fanout57/X _07909_/B _07909_/Y VPWR VGND sg13cmos5l_a21oi_1
X_08890_ _08930_/D _08890_/A _08890_/B _08891_/A _08890_/D VPWR VGND sg13cmos5l_nand4_1
Xhold2529 _07365_/A _10878_/Q VPWR VGND sg13cmos5l_dlygate4sd3_1
Xhold2507 hold2507/X _11661_/Q VPWR VGND sg13cmos5l_dlygate4sd3_1
Xhold2518 _11660_/D _06993_/X VPWR VGND sg13cmos5l_dlygate4sd3_1
X_07841_ _11012_/D fanout59/X _07846_/B _07840_/Y VPWR VGND sg13cmos5l_o21ai_1
XFILLER_57_818 VPWR VGND sg13cmos5l_decap_4
X_07772_ _07772_/Y _07772_/A _07784_/B VPWR VGND sg13cmos5l_nor2_1
XFILLER_83_114 VPWR VGND sg13cmos5l_decap_8
XFILLER_69_689 VPWR VGND sg13cmos5l_decap_8
Xhold1839 _08470_/A _11320_/Q VPWR VGND sg13cmos5l_dlygate4sd3_1
XFILLER_83_136 VPWR VGND sg13cmos5l_fill_2
XFILLER_83_125 VPWR VGND sg13cmos5l_decap_8
X_06723_ _06723_/Y _06377_/A _06758_/A2 _06732_/B _06721_/A _06722_/Y VPWR VGND sg13cmos5l_a221oi_1
X_09511_ _09511_/Y _09540_/A _09511_/B _09511_/C VPWR VGND sg13cmos5l_nor3_1
XFILLER_37_575 VPWR VGND sg13cmos5l_decap_8
XFILLER_80_821 VPWR VGND sg13cmos5l_fill_1
XFILLER_37_586 VPWR VGND sg13cmos5l_fill_2
X_09442_ _09442_/Y _10898_/Q _09576_/B _09577_/B1 VPWR VGND sg13cmos5l_a21oi_1
X_06654_ _06655_/B _06650_/A _06355_/Y _06166_/Y VPWR VGND sg13cmos5l_o21ai_1
X_06585_ _06585_/Y _06585_/A _06722_/B VPWR VGND sg13cmos5l_nor2_1
X_09373_ _09373_/Y _09370_/Y _09372_/Y _09851_/B2 VPWR VGND sg13cmos5l_o21ai_1
XFILLER_71_1014 VPWR VGND sg13cmos5l_decap_4
X_08324_ _08324_/Y _08324_/A _08328_/B VPWR VGND sg13cmos5l_nand2_1
XFILLER_33_781 VPWR VGND sg13cmos5l_decap_8
XFILLER_20_442 VPWR VGND sg13cmos5l_decap_8
X_11520__1143 _11520_/RESET_B VPWR VGND sg13cmos5l_tiehi
X_08255_ _08255_/Y _08255_/A _08263_/B VPWR VGND sg13cmos5l_nor2_1
X_07206_ _07208_/A _08774_/A _07206_/B _10783_/C VPWR VGND sg13cmos5l_nand3_1
XFILLER_20_486 VPWR VGND sg13cmos5l_fill_2
XFILLER_20_497 VPWR VGND sg13cmos5l_decap_8
X_08186_ _08186_/Y _08186_/A _08228_/B VPWR VGND sg13cmos5l_nand2_1
XFILLER_106_525 VPWR VGND sg13cmos5l_decap_8
X_07137_ _07137_/Y hold2799/X _07148_/A2 _07071_/A VPWR VGND sg13cmos5l_o21ai_1
XFILLER_4_608 VPWR VGND sg13cmos5l_fill_1
X_07068_ _07068_/Y _06955_/B _07067_/X _06952_/A VPWR VGND sg13cmos5l_o21ai_1
X_06019_ _06021_/B _06806_/A _06019_/B VPWR VGND sg13cmos5l_nand2_1
XFILLER_88_976 VPWR VGND sg13cmos5l_fill_1
XFILLER_102_775 VPWR VGND sg13cmos5l_decap_8
XFILLER_101_274 VPWR VGND sg13cmos5l_fill_2
XFILLER_101_252 VPWR VGND sg13cmos5l_decap_8
XFILLER_87_486 VPWR VGND sg13cmos5l_decap_8
XFILLER_75_615 VPWR VGND sg13cmos5l_decap_8
XFILLER_59_188 VPWR VGND sg13cmos5l_decap_4
XFILLER_74_158 VPWR VGND sg13cmos5l_decap_4
X_10981_ _10981_/Q _11355_/CLK _10981_/D _10981_/RESET_B VPWR VGND sg13cmos5l_dfrbpq_1
X_09709_ _09709_/Y _10940_/Q _09841_/B VPWR VGND sg13cmos5l_nand2_1
XFILLER_28_553 VPWR VGND sg13cmos5l_fill_1
XFILLER_43_512 VPWR VGND sg13cmos5l_fill_1
X_11602_ _11602_/Q clkload24/A _11602_/D _11602_/RESET_B VPWR VGND sg13cmos5l_dfrbpq_1
XFILLER_71_898 VPWR VGND sg13cmos5l_decap_8
XFILLER_90_56 VPWR VGND sg13cmos5l_decap_8
XFILLER_11_420 VPWR VGND sg13cmos5l_decap_4
X_11533_ _11533_/Q _11535_/CLK _11533_/D _11533_/RESET_B VPWR VGND sg13cmos5l_dfrbpq_1
X_11464_ _11464_/Q clkload15/A _11464_/D _11464_/RESET_B VPWR VGND sg13cmos5l_dfrbpq_1
XFILLER_99_32 VPWR VGND sg13cmos5l_decap_8
X_10415_ _10415_/Y _11730_/Q _10166_/B _10323_/Y VPWR VGND sg13cmos5l_o21ai_1
XFILLER_7_479 VPWR VGND sg13cmos5l_fill_1
X_11395_ _11395_/Q _11528_/CLK _11395_/D _11395_/RESET_B VPWR VGND sg13cmos5l_dfrbpq_1
X_10346_ _10365_/A _11402_/Q _10839_/Q VPWR VGND sg13cmos5l_and2_1
XFILLER_79_932 VPWR VGND sg13cmos5l_fill_2
XFILLER_79_921 VPWR VGND sg13cmos5l_decap_8
X_10277_ _10293_/B _10277_/A _10277_/B _10277_/C VPWR VGND sg13cmos5l_nor3_1
XFILLER_2_162 VPWR VGND sg13cmos5l_decap_8
XFILLER_31_8 VPWR VGND sg13cmos5l_fill_1
XFILLER_79_987 VPWR VGND sg13cmos5l_fill_2
XFILLER_66_604 VPWR VGND sg13cmos5l_decap_8
XFILLER_94_1003 VPWR VGND sg13cmos5l_fill_1
XFILLER_62_810 VPWR VGND sg13cmos5l_decap_8
XFILLER_0_21 VPWR VGND sg13cmos5l_decap_8
XFILLER_94_1025 VPWR VGND sg13cmos5l_decap_4
XFILLER_34_512 VPWR VGND sg13cmos5l_fill_1
XFILLER_61_342 VPWR VGND sg13cmos5l_fill_2
XFILLER_62_898 VPWR VGND sg13cmos5l_fill_2
XFILLER_62_887 VPWR VGND sg13cmos5l_decap_8
XFILLER_61_386 VPWR VGND sg13cmos5l_fill_2
XFILLER_15_781 VPWR VGND sg13cmos5l_fill_1
XFILLER_34_578 VPWR VGND sg13cmos5l_decap_8
X_06370_ _06370_/Y _06374_/A VPWR VGND sg13cmos5l_inv_1
XFILLER_30_751 VPWR VGND sg13cmos5l_decap_4
XFILLER_30_784 VPWR VGND sg13cmos5l_decap_8
X_08040_ _11109_/D fanout57/X _08041_/B _08039_/Y VPWR VGND sg13cmos5l_a21oi_1
XFILLER_50_0 VPWR VGND sg13cmos5l_fill_2
X_09991_ _09991_/Y _11366_/Q _09962_/B _09991_/B1 VPWR VGND sg13cmos5l_a21oi_1
XFILLER_88_239 VPWR VGND sg13cmos5l_fill_1
X_08942_ _08942_/X _08960_/A _08942_/B VPWR VGND sg13cmos5l_xor2_1
X_10884__1098 _10884_/RESET_B VPWR VGND sg13cmos5l_tiehi
X_11140__1761 _11140_/RESET_B VPWR VGND sg13cmos5l_tiehi
Xhold2304 _10785_/A _11592_/Q VPWR VGND sg13cmos5l_dlygate4sd3_1
Xhold2315 _08141_/A _11158_/Q VPWR VGND sg13cmos5l_dlygate4sd3_1
Xhold2337 _08021_/A _11100_/Q VPWR VGND sg13cmos5l_dlygate4sd3_1
Xhold2326 _07748_/A _10967_/Q VPWR VGND sg13cmos5l_dlygate4sd3_1
Xhold2359 _08117_/A _11146_/Q VPWR VGND sg13cmos5l_dlygate4sd3_1
X_08873_ _08907_/B _11384_/Q _08890_/B VPWR VGND sg13cmos5l_xor2_1
Xhold2348 _08261_/A _11217_/Q VPWR VGND sg13cmos5l_dlygate4sd3_1
X_07824_ _07824_/Y _07824_/A _07834_/B VPWR VGND sg13cmos5l_nand2_1
XFILLER_29_339 VPWR VGND sg13cmos5l_decap_4
X_07755_ _10970_/D fanout97/X _07760_/B _07754_/Y VPWR VGND sg13cmos5l_a21oi_1
X_07686_ _07686_/Y _07686_/A _07694_/B VPWR VGND sg13cmos5l_nor2_1
X_06706_ _06706_/Y _06234_/A _06628_/B _06733_/B VPWR VGND sg13cmos5l_o21ai_1
XFILLER_52_342 VPWR VGND sg13cmos5l_fill_1
X_09425_ _09425_/Y _05958_/Y _06512_/B _09553_/B1 _09424_/Y VPWR VGND sg13cmos5l_a22oi_1
X_06637_ _06640_/A _06294_/Y _06636_/Y _06631_/S VPWR VGND sg13cmos5l_a21oi_1
XFILLER_40_515 VPWR VGND sg13cmos5l_decap_4
XFILLER_40_548 VPWR VGND sg13cmos5l_decap_4
X_09356_ _09356_/Y _09177_/Y _09194_/Y _09345_/A VPWR VGND sg13cmos5l_a21oi_1
X_06568_ _06569_/B _06571_/A1 _11677_/Q _10871_/Q _06574_/B2 VPWR VGND sg13cmos5l_a22oi_1
XFILLER_100_77 VPWR VGND sg13cmos5l_decap_8
X_08307_ _08307_/Y _08307_/A _08307_/B VPWR VGND sg13cmos5l_nor2_1
X_09287_ _09287_/Y _10921_/Q _10034_/B _10042_/B1 VPWR VGND sg13cmos5l_a21oi_1
X_06499_ _06499_/Y _11341_/Q _09544_/S VPWR VGND sg13cmos5l_nand2_1
XFILLER_21_773 VPWR VGND sg13cmos5l_fill_1
X_08238_ _08238_/Y _08238_/A _08244_/B VPWR VGND sg13cmos5l_nand2_1
X_11377__1522 _11377_/RESET_B VPWR VGND sg13cmos5l_tiehi
XFILLER_4_416 VPWR VGND sg13cmos5l_fill_1
XFILLER_20_294 VPWR VGND sg13cmos5l_fill_2
XFILLER_106_322 VPWR VGND sg13cmos5l_decap_8
X_08169_ _08169_/Y _08169_/A _08169_/B VPWR VGND sg13cmos5l_nor2_1
X_10200_ _10202_/A _11396_/Q _10833_/Q VPWR VGND sg13cmos5l_xor2_1
X_11180_ _11180_/Q _11265_/CLK _11180_/D _11180_/RESET_B VPWR VGND sg13cmos5l_dfrbpq_1
XFILLER_106_399 VPWR VGND sg13cmos5l_decap_8
X_10131_ _10131_/Y _06209_/A _10131_/A2 _10130_/X VPWR VGND sg13cmos5l_o21ai_1
XFILLER_88_740 VPWR VGND sg13cmos5l_fill_1
X_10062_ _10062_/Y _07012_/A _10062_/A2 _10061_/Y _08606_/Y VPWR VGND sg13cmos5l_a22oi_1
XFILLER_94_209 VPWR VGND sg13cmos5l_decap_8
XFILLER_75_412 VPWR VGND sg13cmos5l_decap_4
XFILLER_87_294 VPWR VGND sg13cmos5l_decap_8
Xhold2893 hold2893/X _10830_/Q VPWR VGND sg13cmos5l_dlygate4sd3_1
Xhold2871 _06146_/A _11502_/Q VPWR VGND sg13cmos5l_dlygate4sd3_1
Xhold2860 hold2860/X _11498_/Q VPWR VGND sg13cmos5l_dlygate4sd3_1
Xhold2882 _06181_/A _11491_/Q VPWR VGND sg13cmos5l_dlygate4sd3_1
XFILLER_91_916 VPWR VGND sg13cmos5l_decap_4
XFILLER_75_489 VPWR VGND sg13cmos5l_fill_1
XFILLER_35_309 VPWR VGND sg13cmos5l_decap_8
XFILLER_44_821 VPWR VGND sg13cmos5l_decap_8
XFILLER_16_523 VPWR VGND sg13cmos5l_decap_8
X_10964_ _10964_/Q _11347_/CLK _10964_/D _10964_/RESET_B VPWR VGND sg13cmos5l_dfrbpq_1
XFILLER_16_545 VPWR VGND sg13cmos5l_decap_4
XFILLER_70_172 VPWR VGND sg13cmos5l_decap_4
X_10895_ _10895_/Q clkload44/A _10895_/D _10895_/RESET_B VPWR VGND sg13cmos5l_dfrbpq_1
XFILLER_70_194 VPWR VGND sg13cmos5l_decap_4
XFILLER_8_700 VPWR VGND sg13cmos5l_decap_4
X_11182__1719 _11182_/RESET_B VPWR VGND sg13cmos5l_tiehi
XFILLER_102_1018 VPWR VGND sg13cmos5l_decap_8
X_11516_ _11516_/Q clkload45/A _11516_/D _11516_/RESET_B VPWR VGND sg13cmos5l_dfrbpq_1
XFILLER_7_232 VPWR VGND sg13cmos5l_fill_1
XFILLER_11_272 VPWR VGND sg13cmos5l_fill_1
XFILLER_8_799 VPWR VGND sg13cmos5l_decap_8
X_11447_ _11447_/Q clkload55/A _11447_/D _11447_/RESET_B VPWR VGND sg13cmos5l_dfrbpq_1
XFILLER_50_81 VPWR VGND sg13cmos5l_fill_1
X_11378_ _11378_/Q clkload19/A _11378_/D _11378_/RESET_B VPWR VGND sg13cmos5l_dfrbpq_1
XFILLER_4_972 VPWR VGND sg13cmos5l_decap_8
X_10329_ _10329_/Y _10329_/A _10407_/A VPWR VGND sg13cmos5l_nor2_1
XFILLER_61_1013 VPWR VGND sg13cmos5l_decap_8
XFILLER_61_1002 VPWR VGND sg13cmos5l_fill_2
XFILLER_3_482 VPWR VGND sg13cmos5l_decap_8
XFILLER_67_924 VPWR VGND sg13cmos5l_fill_1
XFILLER_39_604 VPWR VGND sg13cmos5l_decap_8
XFILLER_67_946 VPWR VGND sg13cmos5l_fill_1
X_05870_ _07521_/B _11403_/Q VPWR VGND sg13cmos5l_inv_1
X_10869__1113 _10869_/RESET_B VPWR VGND sg13cmos5l_tiehi
X_07540_ _07541_/B _05860_/Y _11534_/Q _07539_/X VPWR VGND sg13cmos5l_a21oi_1
XFILLER_62_640 VPWR VGND sg13cmos5l_fill_2
XFILLER_46_191 VPWR VGND sg13cmos5l_fill_1
XFILLER_35_843 VPWR VGND sg13cmos5l_fill_2
XFILLER_34_320 VPWR VGND sg13cmos5l_decap_8
XFILLER_34_331 VPWR VGND sg13cmos5l_decap_8
XFILLER_62_684 VPWR VGND sg13cmos5l_fill_2
X_07471_ _07473_/B _11397_/Q _07471_/B VPWR VGND sg13cmos5l_nor2_1
XFILLER_98_0 VPWR VGND sg13cmos5l_decap_8
X_06422_ _06423_/B _06252_/A _06411_/Y _06421_/Y VPWR VGND sg13cmos5l_o21ai_1
X_09210_ _09211_/B _09431_/A _05963_/Y _09209_/Y VPWR VGND sg13cmos5l_a21oi_1
X_09141_ _09141_/Y _09140_/X _09148_/B VPWR VGND sg13cmos5l_nand2b_1
X_06353_ _06355_/A _06642_/A _06353_/B _06353_/C _06353_/D VPWR VGND sg13cmos5l_and4_1
X_09072_ _09075_/B _09021_/Y _09072_/B VPWR VGND sg13cmos5l_nand2b_1
X_11158__1743 _11158_/RESET_B VPWR VGND sg13cmos5l_tiehi
X_08023_ _08023_/Y _08023_/A _08023_/B VPWR VGND sg13cmos5l_nor2_1
X_06284_ _06284_/Y _11492_/Q _06274_/B _06282_/X _06283_/Y VPWR VGND sg13cmos5l_a22oi_1
XFILLER_104_804 VPWR VGND sg13cmos5l_decap_8
XFILLER_2_909 VPWR VGND sg13cmos5l_fill_1
XFILLER_104_859 VPWR VGND sg13cmos5l_decap_8
XFILLER_103_336 VPWR VGND sg13cmos5l_fill_2
Xhold2101 _08309_/A _11241_/Q VPWR VGND sg13cmos5l_dlygate4sd3_1
X_09974_ _09974_/Y _10055_/A _09974_/B _09974_/C VPWR VGND sg13cmos5l_nor3_1
XFILLER_58_902 VPWR VGND sg13cmos5l_decap_8
XFILLER_39_27 VPWR VGND sg13cmos5l_decap_8
Xhold2112 _07989_/A _11084_/Q VPWR VGND sg13cmos5l_dlygate4sd3_1
Xhold2134 _07987_/A _11083_/Q VPWR VGND sg13cmos5l_dlygate4sd3_1
XFILLER_57_412 VPWR VGND sg13cmos5l_fill_2
XFILLER_57_401 VPWR VGND sg13cmos5l_fill_1
X_08925_ _08941_/A _11387_/Q _08931_/A VPWR VGND sg13cmos5l_nor2_1
Xhold2123 _07670_/A _10929_/Q VPWR VGND sg13cmos5l_dlygate4sd3_1
Xhold2145 _06972_/A _11655_/Q VPWR VGND sg13cmos5l_dlygate4sd3_1
Xhold2156 _07708_/A _10948_/Q VPWR VGND sg13cmos5l_dlygate4sd3_1
X_08856_ _08856_/Y _08880_/A1 _08849_/B _08856_/B1 VPWR VGND sg13cmos5l_o21ai_1
Xhold2167 _08523_/A _11346_/Q VPWR VGND sg13cmos5l_dlygate4sd3_1
Xhold2178 _08529_/A _11349_/Q VPWR VGND sg13cmos5l_dlygate4sd3_1
XFILLER_55_26 VPWR VGND sg13cmos5l_decap_8
Xhold2189 _08263_/A _11218_/Q VPWR VGND sg13cmos5l_dlygate4sd3_1
X_07807_ _10995_/D _08526_/A1 _07808_/B _07806_/Y VPWR VGND sg13cmos5l_o21ai_1
X_05999_ _06943_/B _06066_/C VPWR VGND sg13cmos5l_inv_1
XFILLER_73_949 VPWR VGND sg13cmos5l_fill_2
X_08787_ _08787_/Y _08832_/A1 _08817_/A _08831_/B1 VPWR VGND sg13cmos5l_o21ai_1
X_07738_ _07738_/Y _07738_/A _07748_/B VPWR VGND sg13cmos5l_nor2_1
XFILLER_26_865 VPWR VGND sg13cmos5l_fill_2
XFILLER_13_515 VPWR VGND sg13cmos5l_fill_1
XFILLER_13_526 VPWR VGND sg13cmos5l_decap_8
X_07669_ _10928_/D _08063_/A1 _07676_/B _07668_/Y VPWR VGND sg13cmos5l_a21oi_1
XFILLER_25_375 VPWR VGND sg13cmos5l_fill_1
XFILLER_80_492 VPWR VGND sg13cmos5l_fill_2
X_10680_ _10680_/Y _10680_/A _10680_/B VPWR VGND sg13cmos5l_xnor2_1
XFILLER_41_846 VPWR VGND sg13cmos5l_decap_8
X_09408_ _09408_/Y _09460_/A _09408_/B _09408_/C _09408_/D VPWR VGND sg13cmos5l_nor4_1
X_09339_ _09339_/Y _10191_/A _09404_/B _09338_/Y VPWR VGND sg13cmos5l_a21oi_1
X_10805__942 _10805_/RESET_B VPWR VGND sg13cmos5l_tiehi
X_11301_ _11301_/Q _11355_/CLK _11301_/D _11301_/RESET_B VPWR VGND sg13cmos5l_dfrbpq_1
XFILLER_4_213 VPWR VGND sg13cmos5l_fill_1
X_11232_ _11232_/Q clkload56/A _11232_/D _11232_/RESET_B VPWR VGND sg13cmos5l_dfrbpq_1
X_10947__1035 _10947_/RESET_B VPWR VGND sg13cmos5l_tiehi
XFILLER_5_758 VPWR VGND sg13cmos5l_decap_8
X_11163_ _11163_/Q clkload44/A _11163_/D _11163_/RESET_B VPWR VGND sg13cmos5l_dfrbpq_1
XFILLER_20_95 VPWR VGND sg13cmos5l_fill_2
XFILLER_106_196 VPWR VGND sg13cmos5l_decap_8
XFILLER_45_1019 VPWR VGND sg13cmos5l_decap_8
XFILLER_1_953 VPWR VGND sg13cmos5l_decap_8
X_10114_ _10114_/Y _10114_/A1 _09745_/B _10113_/Y VPWR VGND sg13cmos5l_a21oi_1
XFILLER_103_870 VPWR VGND sg13cmos5l_decap_4
XFILLER_96_77 VPWR VGND sg13cmos5l_decap_8
XFILLER_49_902 VPWR VGND sg13cmos5l_decap_4
X_11094_ _11094_/Q clkload33/A _11094_/D _11094_/RESET_B VPWR VGND sg13cmos5l_dfrbpq_1
X_10045_ _10045_/X _11272_/Q _11240_/Q _11208_/Q _11176_/Q _10034_/B _10046_/B1 VPWR
+ VGND sg13cmos5l_mux4_1
XFILLER_76_754 VPWR VGND sg13cmos5l_fill_2
XFILLER_48_445 VPWR VGND sg13cmos5l_decap_8
Xhold2690 _07098_/A _11746_/Q VPWR VGND sg13cmos5l_dlygate4sd3_1
XFILLER_76_787 VPWR VGND sg13cmos5l_decap_4
XFILLER_75_264 VPWR VGND sg13cmos5l_fill_1
XFILLER_75_253 VPWR VGND sg13cmos5l_decap_8
X_11236__1665 _11236_/RESET_B VPWR VGND sg13cmos5l_tiehi
X_10947_ _10947_/Q clkload46/A _10947_/D _10947_/RESET_B VPWR VGND sg13cmos5l_dfrbpq_1
X_10857__1128 _10857_/RESET_B VPWR VGND sg13cmos5l_tiehi
X_11443__1404 _11443_/RESET_B VPWR VGND sg13cmos5l_tiehi
XFILLER_45_70 VPWR VGND sg13cmos5l_fill_1
XFILLER_44_662 VPWR VGND sg13cmos5l_fill_1
XFILLER_43_161 VPWR VGND sg13cmos5l_fill_2
XFILLER_43_150 VPWR VGND sg13cmos5l_decap_8
XFILLER_32_802 VPWR VGND sg13cmos5l_fill_1
XFILLER_91_7 VPWR VGND sg13cmos5l_decap_8
XFILLER_16_397 VPWR VGND sg13cmos5l_fill_2
XFILLER_31_312 VPWR VGND sg13cmos5l_decap_4
XFILLER_32_857 VPWR VGND sg13cmos5l_fill_1
X_10878_ _10878_/Q clkload7/A _10878_/D _10878_/RESET_B VPWR VGND sg13cmos5l_dfrbpq_1
XFILLER_31_367 VPWR VGND sg13cmos5l_decap_8
Xclkbuf_4_14_0_clk clkbuf_4_14_0_clk/X clkbuf_0_clk/X VPWR VGND sg13cmos5l_buf_8
XFILLER_12_592 VPWR VGND sg13cmos5l_decap_8
XANTENNA_2 _07406_/Y VPWR VGND sg13cmos5l_antennanp
XFILLER_6_42 VPWR VGND sg13cmos5l_decap_8
XFILLER_6_64 VPWR VGND sg13cmos5l_decap_8
Xfanout509 _08895_/B fanout518/X VPWR VGND sg13cmos5l_buf_1
XFILLER_100_306 VPWR VGND sg13cmos5l_fill_2
XFILLER_86_507 VPWR VGND sg13cmos5l_fill_2
XFILLER_39_401 VPWR VGND sg13cmos5l_decap_8
X_06971_ _06971_/Y _07032_/A _07034_/B _06970_/Y VPWR VGND sg13cmos5l_o21ai_1
X_09690_ _09690_/Y _05973_/Y _09957_/B _09982_/B1 _09689_/Y VPWR VGND sg13cmos5l_a22oi_1
X_08710_ _08711_/A _10477_/A _08948_/B _08950_/B _08957_/B1 VPWR VGND sg13cmos5l_a22oi_1
X_05922_ _06185_/B _09456_/A VPWR VGND sg13cmos5l_inv_1
X_08641_ _08641_/Y _08914_/A _08640_/A _08640_/Y VPWR VGND sg13cmos5l_a21oi_1
XFILLER_39_467 VPWR VGND sg13cmos5l_fill_1
XFILLER_54_415 VPWR VGND sg13cmos5l_fill_1
XFILLER_27_629 VPWR VGND sg13cmos5l_fill_1
X_08572_ _08572_/Y _10986_/Q _08573_/S _08571_/Y VPWR VGND sg13cmos5l_o21ai_1
XFILLER_82_768 VPWR VGND sg13cmos5l_fill_1
XFILLER_81_223 VPWR VGND sg13cmos5l_decap_4
XFILLER_35_651 VPWR VGND sg13cmos5l_decap_8
XFILLER_81_278 VPWR VGND sg13cmos5l_fill_2
XFILLER_35_662 VPWR VGND sg13cmos5l_fill_1
X_07523_ _07523_/Y _07542_/D _07522_/Y _07515_/A VPWR VGND sg13cmos5l_o21ai_1
XFILLER_50_643 VPWR VGND sg13cmos5l_decap_8
XFILLER_50_621 VPWR VGND sg13cmos5l_decap_8
X_07454_ _07454_/Y _07452_/B _07453_/X _07452_/Y VPWR VGND sg13cmos5l_a21oi_1
X_06405_ _06405_/Y _10620_/A _06758_/B1 _06404_/Y VPWR VGND sg13cmos5l_a21oi_1
X_07385_ _07385_/Y _11543_/Q _08750_/A VPWR VGND sg13cmos5l_nand2_1
XFILLER_41_28 VPWR VGND sg13cmos5l_fill_2
X_06336_ _06338_/S _05894_/Y _09270_/A _06272_/D _06389_/C _06335_/Y VPWR VGND sg13cmos5l_a221oi_1
X_09124_ _09124_/Y _09075_/X _09121_/X _09123_/X VPWR VGND sg13cmos5l_o21ai_1
X_06267_ _06269_/B _06267_/A _06322_/B VPWR VGND sg13cmos5l_nor2_1
X_09055_ _09055_/Y _09055_/A _09055_/B VPWR VGND sg13cmos5l_nand2_1
X_08006_ _11092_/D _08071_/A1 _08005_/B _08005_/Y VPWR VGND sg13cmos5l_a21oi_1
XFILLER_104_612 VPWR VGND sg13cmos5l_decap_8
X_06198_ _06590_/A _11489_/Q _09189_/A VPWR VGND sg13cmos5l_xnor2_1
XFILLER_2_739 VPWR VGND sg13cmos5l_fill_2
X_11314__1587 _11314_/RESET_B VPWR VGND sg13cmos5l_tiehi
XFILLER_103_133 VPWR VGND sg13cmos5l_decap_8
XFILLER_106_21 VPWR VGND sg13cmos5l_decap_8
XFILLER_89_378 VPWR VGND sg13cmos5l_decap_8
XFILLER_58_710 VPWR VGND sg13cmos5l_fill_1
Xheichips26_RiMaX_1826 uio_oe[11] VPWR VGND sg13cmos5l_tiehi
X_09957_ _09957_/Y _11077_/Q _09957_/B VPWR VGND sg13cmos5l_nand2_1
XFILLER_49_209 VPWR VGND sg13cmos5l_decap_4
X_08908_ _08908_/Y _08908_/A VPWR VGND sg13cmos5l_inv_1
XFILLER_106_98 VPWR VGND sg13cmos5l_decap_8
X_09888_ _09889_/D _09996_/A _09881_/Y _09887_/Y VPWR VGND sg13cmos5l_o21ai_1
XFILLER_58_776 VPWR VGND sg13cmos5l_decap_8
XFILLER_73_713 VPWR VGND sg13cmos5l_decap_8
XFILLER_57_286 VPWR VGND sg13cmos5l_fill_1
XFILLER_57_275 VPWR VGND sg13cmos5l_fill_1
XFILLER_57_264 VPWR VGND sg13cmos5l_decap_8
X_08839_ _08839_/X _08861_/B _08839_/B VPWR VGND sg13cmos5l_xor2_1
XFILLER_18_629 VPWR VGND sg13cmos5l_decap_4
XFILLER_25_150 VPWR VGND sg13cmos5l_decap_4
X_10801_ _10801_/Q clkload15/A _10801_/D _10801_/RESET_B VPWR VGND sg13cmos5l_dfrbpq_1
XFILLER_32_109 VPWR VGND sg13cmos5l_decap_8
X_10732_ _10732_/Y _11561_/Q _10730_/Y _10731_/Y hold2561/X VPWR VGND sg13cmos5l_a22oi_1
XFILLER_41_621 VPWR VGND sg13cmos5l_decap_8
XFILLER_41_676 VPWR VGND sg13cmos5l_fill_1
XFILLER_13_345 VPWR VGND sg13cmos5l_decap_4
X_10663_ _10664_/C hold2753/X _10675_/B fanout85/X VPWR VGND sg13cmos5l_a21oi_1
XFILLER_22_890 VPWR VGND sg13cmos5l_decap_8
X_10594_ _10594_/Y _10633_/B _10592_/Y _10593_/Y VPWR VGND sg13cmos5l_a21oi_1
XFILLER_5_522 VPWR VGND sg13cmos5l_fill_2
XFILLER_31_72 VPWR VGND sg13cmos5l_fill_2
XFILLER_99_109 VPWR VGND sg13cmos5l_decap_8
XFILLER_5_566 VPWR VGND sg13cmos5l_fill_2
X_11215_ _11215_/Q clkload43/A _11215_/D _11215_/RESET_B VPWR VGND sg13cmos5l_dfrbpq_1
X_11146_ _11146_/Q _11646_/CLK _11146_/D _11146_/RESET_B VPWR VGND sg13cmos5l_dfrbpq_1
XFILLER_95_315 VPWR VGND sg13cmos5l_decap_8
X_11077_ _11077_/Q _11355_/CLK _11077_/D _11077_/RESET_B VPWR VGND sg13cmos5l_dfrbpq_1
X_10028_ _10029_/C _09939_/B _09998_/Y _10027_/Y VPWR VGND sg13cmos5l_o21ai_1
XFILLER_76_573 VPWR VGND sg13cmos5l_decap_8
XFILLER_64_724 VPWR VGND sg13cmos5l_decap_8
XFILLER_64_713 VPWR VGND sg13cmos5l_decap_4
XFILLER_36_404 VPWR VGND sg13cmos5l_decap_4
XFILLER_36_459 VPWR VGND sg13cmos5l_fill_2
XFILLER_36_448 VPWR VGND sg13cmos5l_decap_8
XFILLER_44_481 VPWR VGND sg13cmos5l_fill_2
XFILLER_20_816 VPWR VGND sg13cmos5l_fill_2
XFILLER_32_643 VPWR VGND sg13cmos5l_decap_8
XFILLER_32_687 VPWR VGND sg13cmos5l_fill_1
X_07170_ _07171_/B _10679_/B _07205_/B _07249_/B1 _07210_/B VPWR VGND sg13cmos5l_a22oi_1
X_11407__1476 _11407_/RESET_B VPWR VGND sg13cmos5l_tiehi
XFILLER_9_861 VPWR VGND sg13cmos5l_decap_8
X_06121_ _06121_/Y _06132_/B _06121_/B VPWR VGND sg13cmos5l_nand2_1
XFILLER_8_382 VPWR VGND sg13cmos5l_decap_8
XFILLER_9_894 VPWR VGND sg13cmos5l_fill_1
X_06052_ _11758_/D _10696_/B _06051_/Y _06092_/B VPWR VGND sg13cmos5l_a21oi_1
Xfanout306 _07846_/B _07813_/A2 VPWR VGND sg13cmos5l_buf_1
Xfanout317 _08510_/A1 _07449_/Y VPWR VGND sg13cmos5l_buf_1
X_09811_ _09837_/C _09171_/B _09811_/B _09811_/C VPWR VGND sg13cmos5l_nand3b_1
Xfanout328 _07050_/B1 _07044_/B1 VPWR VGND sg13cmos5l_buf_1
Xfanout339 _09579_/B2 _09608_/B1 VPWR VGND sg13cmos5l_buf_1
X_09742_ _09742_/Y _11293_/Q _09850_/A2 _09741_/Y VPWR VGND sg13cmos5l_o21ai_1
XFILLER_100_147 VPWR VGND sg13cmos5l_decap_8
X_06954_ _06955_/B _07071_/A _07071_/B VPWR VGND sg13cmos5l_nand2_1
X_06885_ _06885_/X _06884_/X hold2573/X _08642_/S VPWR VGND sg13cmos5l_mux2_1
X_05905_ _10307_/A _10242_/B VPWR VGND sg13cmos5l_inv_1
XFILLER_39_275 VPWR VGND sg13cmos5l_decap_8
XFILLER_36_28 VPWR VGND sg13cmos5l_fill_1
X_09673_ _11472_/D _05911_/Y _09751_/A _09651_/Y _09672_/Y VPWR VGND sg13cmos5l_a22oi_1
XFILLER_55_757 VPWR VGND sg13cmos5l_decap_8
X_08624_ _08624_/Y _08624_/A _08624_/B VPWR VGND sg13cmos5l_nor2_1
X_08555_ _08555_/Y _08555_/A _08555_/B VPWR VGND sg13cmos5l_nor2_1
XFILLER_70_738 VPWR VGND sg13cmos5l_fill_1
XFILLER_54_289 VPWR VGND sg13cmos5l_fill_2
X_07506_ _07508_/B _05860_/Y _11529_/Q _07505_/X VPWR VGND sg13cmos5l_a21oi_1
X_08486_ _08486_/Y _08486_/A _08498_/B VPWR VGND sg13cmos5l_nand2_1
XFILLER_51_952 VPWR VGND sg13cmos5l_fill_1
X_07437_ _07655_/B _11562_/Q _07720_/C VPWR VGND sg13cmos5l_nand2_1
XFILLER_51_985 VPWR VGND sg13cmos5l_decap_8
XFILLER_23_687 VPWR VGND sg13cmos5l_fill_2
X_07368_ _08731_/A _09015_/A _07380_/B VPWR VGND sg13cmos5l_nand2_1
XFILLER_10_337 VPWR VGND sg13cmos5l_decap_8
XFILLER_10_348 VPWR VGND sg13cmos5l_fill_2
X_09107_ _11450_/D _09105_/Y _09106_/Y _09093_/Y VPWR VGND sg13cmos5l_o21ai_1
X_06319_ _06319_/Y _06209_/A _11479_/Q _06224_/C _06307_/Y _06318_/Y VPWR VGND sg13cmos5l_a221oi_1
X_07299_ _07299_/Y _07299_/A _07311_/B VPWR VGND sg13cmos5l_nor2_1
X_09038_ _09038_/Y _09068_/D _09037_/Y _09052_/A VPWR VGND sg13cmos5l_o21ai_1
XFILLER_105_932 VPWR VGND sg13cmos5l_decap_8
XFILLER_2_525 VPWR VGND sg13cmos5l_decap_4
X_11000_ _11000_/Q _11349_/CLK _11000_/D _11000_/RESET_B VPWR VGND sg13cmos5l_dfrbpq_1
XFILLER_77_348 VPWR VGND sg13cmos5l_fill_2
XFILLER_73_510 VPWR VGND sg13cmos5l_fill_2
XFILLER_58_562 VPWR VGND sg13cmos5l_fill_1
XFILLER_93_56 VPWR VGND sg13cmos5l_decap_8
X_10897__1085 _10897_/RESET_B VPWR VGND sg13cmos5l_tiehi
XFILLER_34_919 VPWR VGND sg13cmos5l_fill_1
XFILLER_26_470 VPWR VGND sg13cmos5l_fill_1
X_11764_ _11764_/Q _11767_/CLK _11764_/D _11764_/RESET_B VPWR VGND sg13cmos5l_dfrbpq_1
XFILLER_42_974 VPWR VGND sg13cmos5l_fill_2
XFILLER_13_120 VPWR VGND sg13cmos5l_decap_4
X_10715_ _11556_/D _10709_/X _10713_/Y _10714_/Y VPWR VGND sg13cmos5l_o21ai_1
X_11695_ _11695_/Q clkload19/A _11695_/D _11695_/RESET_B VPWR VGND sg13cmos5l_dfrbpq_1
XFILLER_9_102 VPWR VGND sg13cmos5l_fill_1
XFILLER_14_698 VPWR VGND sg13cmos5l_fill_2
X_10646_ _10648_/B _06330_/B _10656_/B _10638_/Y _10640_/Y _10645_/Y VPWR VGND sg13cmos5l_a221oi_1
XFILLER_6_820 VPWR VGND sg13cmos5l_decap_8
X_10577_ _10577_/Y _10578_/A _10578_/B VPWR VGND sg13cmos5l_nor2_1
XFILLER_10_882 VPWR VGND sg13cmos5l_fill_1
XFILLER_5_374 VPWR VGND sg13cmos5l_fill_2
XFILLER_69_827 VPWR VGND sg13cmos5l_decap_4
XFILLER_69_816 VPWR VGND sg13cmos5l_fill_1
XFILLER_3_21 VPWR VGND sg13cmos5l_decap_8
XFILLER_69_849 VPWR VGND sg13cmos5l_decap_8
XFILLER_3_87 VPWR VGND sg13cmos5l_fill_1
X_11129_ _11129_/Q clkload40/A _11129_/D _11129_/RESET_B VPWR VGND sg13cmos5l_dfrbpq_1
XFILLER_95_178 VPWR VGND sg13cmos5l_decap_4
XFILLER_37_713 VPWR VGND sg13cmos5l_fill_2
XFILLER_36_201 VPWR VGND sg13cmos5l_fill_1
XFILLER_76_392 VPWR VGND sg13cmos5l_decap_4
XFILLER_36_234 VPWR VGND sg13cmos5l_decap_4
X_06670_ _06670_/X _06670_/A _06670_/B VPWR VGND sg13cmos5l_or2_1
XFILLER_17_492 VPWR VGND sg13cmos5l_decap_8
X_08340_ _08340_/Y _08340_/A _08340_/B VPWR VGND sg13cmos5l_nand2_1
X_10942__1040 _10942_/RESET_B VPWR VGND sg13cmos5l_tiehi
X_08271_ _08271_/Y _08271_/A _08273_/B VPWR VGND sg13cmos5l_nor2_1
XFILLER_32_484 VPWR VGND sg13cmos5l_decap_8
X_07222_ _07222_/Y _05972_/Y _07237_/A2 _07226_/B1 _07221_/Y VPWR VGND sg13cmos5l_a22oi_1
X_07153_ _07153_/Y _05879_/A _07154_/A2 _06091_/A VPWR VGND sg13cmos5l_o21ai_1
XFILLER_20_668 VPWR VGND sg13cmos5l_fill_1
XFILLER_106_707 VPWR VGND sg13cmos5l_decap_8
X_06104_ _06107_/S _07401_/A _07407_/A _06104_/C _06104_/D VPWR VGND sg13cmos5l_nor4_1
XFILLER_105_217 VPWR VGND sg13cmos5l_decap_8
X_07084_ _07084_/Y _08616_/A _07082_/Y _07083_/Y VPWR VGND sg13cmos5l_a21oi_1
X_06035_ _06046_/B _11596_/Q _08774_/A _11613_/Q _06035_/D VPWR VGND sg13cmos5l_nor4_1
X_11195__1706 _11195_/RESET_B VPWR VGND sg13cmos5l_tiehi
X_11231__1670 _11231_/RESET_B VPWR VGND sg13cmos5l_tiehi
Xfanout103 _08534_/A1 _07531_/Y VPWR VGND sg13cmos5l_buf_1
Xfanout147 _07982_/B _07974_/B VPWR VGND sg13cmos5l_buf_1
Xfanout125 _08504_/B _08496_/B VPWR VGND sg13cmos5l_buf_1
Xfanout114 _08645_/S _08635_/S VPWR VGND sg13cmos5l_buf_1
Xfanout136 _08218_/B _08181_/Y VPWR VGND sg13cmos5l_buf_1
X_07986_ _11082_/D _08508_/A1 _08043_/B _07985_/Y VPWR VGND sg13cmos5l_a21oi_1
XFILLER_75_808 VPWR VGND sg13cmos5l_decap_8
XFILLER_68_860 VPWR VGND sg13cmos5l_fill_1
Xfanout169 _07407_/B _07311_/B VPWR VGND sg13cmos5l_buf_1
Xfanout158 _08457_/A1 _07487_/Y VPWR VGND sg13cmos5l_buf_1
X_06937_ _06937_/Y _10691_/B _10751_/A _10771_/B VPWR VGND sg13cmos5l_nand3_1
X_09725_ _09725_/Y _11410_/Q _09725_/B VPWR VGND sg13cmos5l_nand2_1
X_09656_ _09656_/Y _09659_/S1 _09652_/X _09655_/Y VPWR VGND sg13cmos5l_o21ai_1
X_06868_ _06875_/C _06868_/A _11688_/Q _11689_/Q _11690_/Q VPWR VGND sg13cmos5l_nand4_1
X_08607_ _08607_/Y _11373_/Q _08607_/B VPWR VGND sg13cmos5l_xnor2_1
XFILLER_16_919 VPWR VGND sg13cmos5l_decap_8
XFILLER_103_77 VPWR VGND sg13cmos5l_decap_8
X_06799_ _06799_/Y _06790_/Y _06798_/Y _06796_/Y VPWR VGND sg13cmos5l_o21ai_1
XFILLER_55_587 VPWR VGND sg13cmos5l_decap_4
X_09587_ _09587_/Y _09672_/A _09587_/B _09587_/C _09587_/D VPWR VGND sg13cmos5l_nor4_1
XFILLER_70_568 VPWR VGND sg13cmos5l_fill_2
XFILLER_63_59 VPWR VGND sg13cmos5l_decap_8
X_08538_ _11353_/D fanout98/X _08553_/B _08537_/Y VPWR VGND sg13cmos5l_a21oi_1
X_08469_ _11319_/D _08534_/A1 _08468_/B _08468_/Y VPWR VGND sg13cmos5l_o21ai_1
X_10500_ _10501_/B _10568_/A _10499_/B _10640_/A VPWR VGND sg13cmos5l_a21oi_1
X_11480_ _11480_/Q clkload36/A _11480_/D _11480_/RESET_B VPWR VGND sg13cmos5l_dfrbpq_1
XFILLER_7_639 VPWR VGND sg13cmos5l_decap_4
XFILLER_11_668 VPWR VGND sg13cmos5l_decap_8
X_11642__1324 _11642_/RESET_B VPWR VGND sg13cmos5l_tiehi
X_10431_ _10432_/B _10429_/Y _10430_/Y _10416_/Y VPWR VGND sg13cmos5l_o21ai_1
XFILLER_6_127 VPWR VGND sg13cmos5l_fill_2
X_10362_ _10362_/Y _11403_/Q _10840_/Q VPWR VGND sg13cmos5l_nand2_1
XFILLER_3_812 VPWR VGND sg13cmos5l_fill_2
XFILLER_3_801 VPWR VGND sg13cmos5l_decap_4
X_10293_ _10303_/A _10293_/A _10293_/B _10293_/C VPWR VGND sg13cmos5l_nor3_1
XFILLER_105_751 VPWR VGND sg13cmos5l_decap_8
XFILLER_2_344 VPWR VGND sg13cmos5l_decap_8
XFILLER_105_795 VPWR VGND sg13cmos5l_decap_8
XFILLER_2_388 VPWR VGND sg13cmos5l_fill_2
XFILLER_93_627 VPWR VGND sg13cmos5l_fill_1
Xfanout692 _10171_/B hold2633/X VPWR VGND sg13cmos5l_buf_1
Xfanout681 _10157_/A1 fanout682/X VPWR VGND sg13cmos5l_buf_1
XFILLER_77_189 VPWR VGND sg13cmos5l_decap_8
XFILLER_77_178 VPWR VGND sg13cmos5l_fill_1
Xfanout670 _10114_/A1 _10408_/A VPWR VGND sg13cmos5l_buf_1
XFILLER_92_148 VPWR VGND sg13cmos5l_decap_8
XFILLER_74_874 VPWR VGND sg13cmos5l_decap_4
XFILLER_74_863 VPWR VGND sg13cmos5l_fill_1
XFILLER_61_502 VPWR VGND sg13cmos5l_fill_2
X_11534__1505 _11534_/RESET_B VPWR VGND sg13cmos5l_tiehi
XFILLER_74_896 VPWR VGND sg13cmos5l_decap_8
XFILLER_61_513 VPWR VGND sg13cmos5l_fill_2
XFILLER_46_598 VPWR VGND sg13cmos5l_decap_8
XFILLER_15_930 VPWR VGND sg13cmos5l_decap_4
X_11273__1628 _11273_/RESET_B VPWR VGND sg13cmos5l_tiehi
X_11747_ _11747_/Q clkload26/A _11747_/D _11747_/RESET_B VPWR VGND sg13cmos5l_dfrbpq_1
XFILLER_42_771 VPWR VGND sg13cmos5l_decap_8
XFILLER_105_1027 VPWR VGND sg13cmos5l_fill_2
XFILLER_105_1016 VPWR VGND sg13cmos5l_decap_8
XFILLER_41_270 VPWR VGND sg13cmos5l_fill_2
XFILLER_30_955 VPWR VGND sg13cmos5l_fill_2
X_11678_ _11678_/Q clkload7/A _11678_/D _11678_/RESET_B VPWR VGND sg13cmos5l_dfrbpq_1
X_10629_ _10630_/D _10628_/A _10628_/B _10632_/B VPWR VGND sg13cmos5l_a21o_1
XFILLER_52_4 VPWR VGND sg13cmos5l_fill_2
XFILLER_97_922 VPWR VGND sg13cmos5l_decap_4
Xhold2508 _11661_/D _06997_/X VPWR VGND sg13cmos5l_dlygate4sd3_1
Xhold2519 hold2519/X _11676_/Q VPWR VGND sg13cmos5l_dlygate4sd3_1
X_07840_ _07840_/Y _07840_/A _07846_/B VPWR VGND sg13cmos5l_nand2_1
XFILLER_69_657 VPWR VGND sg13cmos5l_fill_1
XFILLER_97_999 VPWR VGND sg13cmos5l_fill_2
XFILLER_96_476 VPWR VGND sg13cmos5l_fill_1
X_07771_ _10978_/D fanout64/X _07770_/B _07770_/Y VPWR VGND sg13cmos5l_a21oi_1
XFILLER_37_543 VPWR VGND sg13cmos5l_fill_1
X_06722_ _06722_/Y _10427_/A _06722_/B VPWR VGND sg13cmos5l_nor2_1
X_09510_ _09511_/C _09430_/B _09506_/Y _09509_/Y VPWR VGND sg13cmos5l_o21ai_1
XFILLER_64_362 VPWR VGND sg13cmos5l_fill_1
XFILLER_64_351 VPWR VGND sg13cmos5l_decap_8
XFILLER_91_181 VPWR VGND sg13cmos5l_fill_2
X_09441_ _09441_/Y _10994_/Q _09492_/B _09575_/S1 VPWR VGND sg13cmos5l_a21oi_1
X_06653_ _06653_/Y _06649_/A _06647_/B _06297_/B VPWR VGND sg13cmos5l_o21ai_1
XFILLER_25_727 VPWR VGND sg13cmos5l_decap_4
XFILLER_25_749 VPWR VGND sg13cmos5l_decap_8
X_06584_ _06584_/Y _06585_/A _06400_/D _06614_/A VPWR VGND sg13cmos5l_a21oi_1
X_09372_ _09372_/Y _11279_/Q _09850_/A2 _09371_/Y VPWR VGND sg13cmos5l_o21ai_1
XFILLER_24_259 VPWR VGND sg13cmos5l_fill_2
XFILLER_71_1004 VPWR VGND sg13cmos5l_fill_1
X_08323_ _11247_/D _08453_/A1 _08340_/B _08322_/Y VPWR VGND sg13cmos5l_o21ai_1
XFILLER_21_900 VPWR VGND sg13cmos5l_decap_8
XFILLER_21_922 VPWR VGND sg13cmos5l_decap_4
XFILLER_33_29 VPWR VGND sg13cmos5l_fill_1
X_11249__1652 _11249_/RESET_B VPWR VGND sg13cmos5l_tiehi
XFILLER_20_410 VPWR VGND sg13cmos5l_decap_4
XFILLER_20_432 VPWR VGND sg13cmos5l_fill_1
X_08254_ _11213_/D _08319_/A1 _08263_/B _08253_/Y VPWR VGND sg13cmos5l_a21oi_1
XFILLER_21_988 VPWR VGND sg13cmos5l_decap_8
X_08185_ _11179_/D _08510_/A1 _08234_/B _08184_/Y VPWR VGND sg13cmos5l_o21ai_1
X_07205_ _07205_/Y _07205_/A _07205_/B VPWR VGND sg13cmos5l_nor2_1
XFILLER_106_504 VPWR VGND sg13cmos5l_decap_8
X_07136_ _11733_/D _05889_/Y _07148_/A2 _07135_/Y VPWR VGND sg13cmos5l_a21oi_1
X_07067_ _07067_/X _07067_/A _07067_/B VPWR VGND sg13cmos5l_or2_1
X_06018_ _06021_/A _10171_/B _06022_/B VPWR VGND sg13cmos5l_nand2_1
XFILLER_102_754 VPWR VGND sg13cmos5l_decap_8
XFILLER_99_292 VPWR VGND sg13cmos5l_decap_8
XFILLER_87_443 VPWR VGND sg13cmos5l_fill_1
XFILLER_59_145 VPWR VGND sg13cmos5l_fill_2
XFILLER_0_859 VPWR VGND sg13cmos5l_decap_8
XFILLER_88_988 VPWR VGND sg13cmos5l_fill_2
XFILLER_59_167 VPWR VGND sg13cmos5l_decap_8
X_07969_ _11074_/D fanout64/X _07976_/B _07968_/Y VPWR VGND sg13cmos5l_o21ai_1
X_09708_ _09708_/X _11004_/Q _10972_/Q _09708_/S VPWR VGND sg13cmos5l_mux2_1
XFILLER_28_510 VPWR VGND sg13cmos5l_decap_8
X_10980_ _10980_/Q _11594_/CLK _10980_/D _10980_/RESET_B VPWR VGND sg13cmos5l_dfrbpq_1
XFILLER_83_660 VPWR VGND sg13cmos5l_decap_8
XFILLER_74_58 VPWR VGND sg13cmos5l_decap_8
XFILLER_83_682 VPWR VGND sg13cmos5l_fill_2
XFILLER_83_671 VPWR VGND sg13cmos5l_fill_2
XFILLER_71_822 VPWR VGND sg13cmos5l_fill_2
XFILLER_55_384 VPWR VGND sg13cmos5l_fill_1
XFILLER_55_362 VPWR VGND sg13cmos5l_decap_4
XFILLER_16_749 VPWR VGND sg13cmos5l_fill_2
X_09639_ _09640_/B _09852_/A1 _09634_/X _09638_/Y VPWR VGND sg13cmos5l_o21ai_1
XFILLER_28_587 VPWR VGND sg13cmos5l_fill_2
XFILLER_71_855 VPWR VGND sg13cmos5l_fill_2
XFILLER_70_343 VPWR VGND sg13cmos5l_decap_8
XFILLER_43_557 VPWR VGND sg13cmos5l_fill_2
XFILLER_90_35 VPWR VGND sg13cmos5l_decap_8
X_11601_ _11601_/Q clkload27/A _11601_/D _11601_/RESET_B VPWR VGND sg13cmos5l_dfrbpq_1
XFILLER_70_376 VPWR VGND sg13cmos5l_decap_4
XFILLER_43_579 VPWR VGND sg13cmos5l_fill_2
XFILLER_12_911 VPWR VGND sg13cmos5l_fill_1
XFILLER_30_218 VPWR VGND sg13cmos5l_decap_8
XFILLER_23_281 VPWR VGND sg13cmos5l_decap_4
X_11532_ _11532_/Q clkload20/A _11532_/D _11532_/RESET_B VPWR VGND sg13cmos5l_dfrbpq_1
XFILLER_99_11 VPWR VGND sg13cmos5l_decap_8
X_11463_ _11463_/Q clkload15/A _11463_/D _11463_/RESET_B VPWR VGND sg13cmos5l_dfrbpq_1
X_10414_ _10414_/Y _11746_/Q _10414_/A2 _07067_/B VPWR VGND sg13cmos5l_a21oi_1
XFILLER_99_88 VPWR VGND sg13cmos5l_decap_8
X_11394_ _11394_/Q clkload18/A _11394_/D _11394_/RESET_B VPWR VGND sg13cmos5l_dfrbpq_1
XFILLER_3_620 VPWR VGND sg13cmos5l_decap_4
XFILLER_98_708 VPWR VGND sg13cmos5l_fill_1
XFILLER_79_900 VPWR VGND sg13cmos5l_decap_8
X_10345_ _10345_/Y _10422_/A _10328_/B _10344_/Y VPWR VGND sg13cmos5l_a21oi_1
XFILLER_2_130 VPWR VGND sg13cmos5l_fill_1
X_10276_ _10276_/X _10261_/A _10261_/C _10261_/B VPWR VGND sg13cmos5l_a21o_1
XFILLER_94_958 VPWR VGND sg13cmos5l_fill_2
X_11327__1574 _11327_/RESET_B VPWR VGND sg13cmos5l_tiehi
XFILLER_59_690 VPWR VGND sg13cmos5l_decap_8
XFILLER_19_532 VPWR VGND sg13cmos5l_decap_8
XFILLER_93_468 VPWR VGND sg13cmos5l_fill_2
XFILLER_81_619 VPWR VGND sg13cmos5l_decap_8
X_11757__918 _11757_/RESET_B VPWR VGND sg13cmos5l_tiehi
XFILLER_47_874 VPWR VGND sg13cmos5l_fill_2
XFILLER_47_896 VPWR VGND sg13cmos5l_fill_1
XFILLER_34_557 VPWR VGND sg13cmos5l_decap_8
XFILLER_14_270 VPWR VGND sg13cmos5l_fill_1
X_10822__959 _10822_/RESET_B VPWR VGND sg13cmos5l_tiehi
XFILLER_31_1021 VPWR VGND sg13cmos5l_decap_8
X_09990_ _09990_/X _11270_/Q _11238_/Q _11206_/Q _11174_/Q _09984_/B _09990_/S1 VPWR
+ VGND sg13cmos5l_mux4_1
XFILLER_103_529 VPWR VGND sg13cmos5l_decap_8
X_11523__1137 _11523_/RESET_B VPWR VGND sg13cmos5l_tiehi
X_08941_ _08942_/B _08941_/A _08941_/B VPWR VGND sg13cmos5l_or2_1
X_10892__1090 _10892_/RESET_B VPWR VGND sg13cmos5l_tiehi
Xhold2316 _07770_/A _10978_/Q VPWR VGND sg13cmos5l_dlygate4sd3_1
Xhold2305 _11592_/D _10786_/Y VPWR VGND sg13cmos5l_dlygate4sd3_1
Xhold2327 _07704_/A _10946_/Q VPWR VGND sg13cmos5l_dlygate4sd3_1
X_08872_ _08910_/A _11384_/Q _08890_/B VPWR VGND sg13cmos5l_nor2_1
XFILLER_97_774 VPWR VGND sg13cmos5l_decap_8
Xhold2338 _07905_/A _11043_/Q VPWR VGND sg13cmos5l_dlygate4sd3_1
Xhold2349 _08041_/A _11110_/Q VPWR VGND sg13cmos5l_dlygate4sd3_1
XFILLER_69_487 VPWR VGND sg13cmos5l_decap_8
XFILLER_69_476 VPWR VGND sg13cmos5l_fill_1
X_07823_ _11003_/D fanout82/X _07844_/B _07822_/Y VPWR VGND sg13cmos5l_o21ai_1
XFILLER_57_616 VPWR VGND sg13cmos5l_decap_4
XFILLER_29_318 VPWR VGND sg13cmos5l_fill_2
X_07754_ _07754_/Y _07754_/A _07760_/B VPWR VGND sg13cmos5l_nor2_1
XFILLER_71_129 VPWR VGND sg13cmos5l_fill_2
XFILLER_71_107 VPWR VGND sg13cmos5l_decap_8
XFILLER_65_682 VPWR VGND sg13cmos5l_decap_8
X_07685_ _10936_/D _08536_/A1 _07684_/B _07684_/Y VPWR VGND sg13cmos5l_a21oi_1
X_06705_ _06705_/Y _06709_/A _06705_/B VPWR VGND sg13cmos5l_xnor2_1
XFILLER_80_652 VPWR VGND sg13cmos5l_decap_8
XFILLER_64_181 VPWR VGND sg13cmos5l_fill_1
XFILLER_52_321 VPWR VGND sg13cmos5l_decap_8
X_09424_ _09424_/Y _11345_/Q _09552_/B VPWR VGND sg13cmos5l_nand2_1
X_06636_ _06636_/Y _06636_/A _06645_/B VPWR VGND sg13cmos5l_nand2_1
XFILLER_25_546 VPWR VGND sg13cmos5l_decap_8
XFILLER_80_696 VPWR VGND sg13cmos5l_fill_1
XFILLER_53_899 VPWR VGND sg13cmos5l_fill_2
XFILLER_52_387 VPWR VGND sg13cmos5l_fill_2
XFILLER_52_376 VPWR VGND sg13cmos5l_decap_8
X_06567_ _06569_/A _06531_/A _11661_/Q _10887_/Q _06132_/B VPWR VGND sg13cmos5l_a22oi_1
X_09355_ _11460_/D _09354_/B _09353_/Y _09354_/Y VPWR VGND sg13cmos5l_o21ai_1
XFILLER_100_56 VPWR VGND sg13cmos5l_decap_8
X_08306_ _11239_/D fanout54/X _08307_/B _08305_/Y VPWR VGND sg13cmos5l_a21oi_1
X_09286_ _09286_/Y _10953_/Q _10039_/B VPWR VGND sg13cmos5l_nand2_1
X_06498_ _06498_/X _11245_/Q _11213_/Q _11181_/Q _11149_/Q _09551_/S0 _09551_/S1 VPWR
+ VGND sg13cmos5l_mux4_1
XFILLER_20_251 VPWR VGND sg13cmos5l_decap_4
X_08237_ _11205_/D fanout58/X _08236_/B _08236_/Y VPWR VGND sg13cmos5l_o21ai_1
XFILLER_106_301 VPWR VGND sg13cmos5l_decap_8
X_08168_ _11171_/D fanout61/X _08177_/B _08167_/Y VPWR VGND sg13cmos5l_a21oi_1
X_08099_ _11138_/D fanout64/X _08106_/B _08098_/Y VPWR VGND sg13cmos5l_o21ai_1
X_07119_ _07119_/Y hold2724/X _07120_/A2 _06091_/A VPWR VGND sg13cmos5l_o21ai_1
XFILLER_106_378 VPWR VGND sg13cmos5l_decap_8
X_10130_ _10130_/X _10584_/A _09853_/B _10129_/Y VPWR VGND sg13cmos5l_a21o_1
XFILLER_0_601 VPWR VGND sg13cmos5l_decap_8
X_10061_ _10061_/Y _06523_/A hold2893/X _10062_/A2 VPWR VGND sg13cmos5l_a21oi_1
XFILLER_0_623 VPWR VGND sg13cmos5l_fill_2
XFILLER_102_573 VPWR VGND sg13cmos5l_fill_2
Xhold2850 _11516_/D _10152_/Y VPWR VGND sg13cmos5l_dlygate4sd3_1
XFILLER_76_925 VPWR VGND sg13cmos5l_decap_4
XFILLER_47_104 VPWR VGND sg13cmos5l_decap_4
XFILLER_0_678 VPWR VGND sg13cmos5l_decap_8
XFILLER_102_584 VPWR VGND sg13cmos5l_decap_8
XFILLER_87_273 VPWR VGND sg13cmos5l_decap_4
XFILLER_85_68 VPWR VGND sg13cmos5l_decap_4
Xhold2872 _06265_/A _11511_/Q VPWR VGND sg13cmos5l_dlygate4sd3_1
Xhold2883 hold2883/X _10832_/Q VPWR VGND sg13cmos5l_dlygate4sd3_1
Xhold2861 _11498_/D _10091_/X VPWR VGND sg13cmos5l_dlygate4sd3_1
Xhold2894 _11488_/D _10062_/Y VPWR VGND sg13cmos5l_dlygate4sd3_1
XFILLER_18_62 VPWR VGND sg13cmos5l_fill_2
XFILLER_91_939 VPWR VGND sg13cmos5l_decap_4
XFILLER_90_438 VPWR VGND sg13cmos5l_decap_8
X_10963_ _10963_/Q clkload17/A _10963_/D _10963_/RESET_B VPWR VGND sg13cmos5l_dfrbpq_1
XFILLER_18_73 VPWR VGND sg13cmos5l_decap_8
XFILLER_83_490 VPWR VGND sg13cmos5l_fill_1
XFILLER_70_140 VPWR VGND sg13cmos5l_fill_1
XFILLER_43_354 VPWR VGND sg13cmos5l_fill_1
X_10894_ _10894_/Q clkload35/A _10894_/D _10894_/RESET_B VPWR VGND sg13cmos5l_dfrbpq_1
X_11190__1711 _11190_/RESET_B VPWR VGND sg13cmos5l_tiehi
X_11515_ _11515_/Q clkload45/A _11515_/D _11515_/RESET_B VPWR VGND sg13cmos5l_dfrbpq_1
XFILLER_7_211 VPWR VGND sg13cmos5l_fill_2
XFILLER_11_251 VPWR VGND sg13cmos5l_decap_8
XFILLER_8_778 VPWR VGND sg13cmos5l_fill_2
X_11446_ _11446_/Q clkload55/A _11446_/D _11446_/RESET_B VPWR VGND sg13cmos5l_dfrbpq_1
XFILLER_98_505 VPWR VGND sg13cmos5l_decap_4
X_11377_ _12766_/A _11766_/CLK _11377_/D _11377_/RESET_B VPWR VGND sg13cmos5l_dfrbpq_1
XFILLER_98_527 VPWR VGND sg13cmos5l_fill_1
X_10328_ _10330_/C _10407_/A _10328_/B VPWR VGND sg13cmos5l_nand2_1
XFILLER_79_741 VPWR VGND sg13cmos5l_decap_8
XFILLER_79_785 VPWR VGND sg13cmos5l_decap_8
XFILLER_67_936 VPWR VGND sg13cmos5l_fill_1
XFILLER_67_903 VPWR VGND sg13cmos5l_decap_8
X_11734__1212 _11734_/RESET_B VPWR VGND sg13cmos5l_tiehi
X_10259_ _10261_/C _10255_/B _10251_/Y _10247_/B VPWR VGND sg13cmos5l_o21ai_1
XFILLER_39_627 VPWR VGND sg13cmos5l_fill_1
XFILLER_66_413 VPWR VGND sg13cmos5l_fill_2
XFILLER_38_137 VPWR VGND sg13cmos5l_fill_1
XFILLER_82_917 VPWR VGND sg13cmos5l_fill_1
XFILLER_82_906 VPWR VGND sg13cmos5l_fill_2
XFILLER_54_619 VPWR VGND sg13cmos5l_fill_1
XFILLER_47_671 VPWR VGND sg13cmos5l_decap_8
XFILLER_19_373 VPWR VGND sg13cmos5l_decap_4
XFILLER_34_310 VPWR VGND sg13cmos5l_decap_4
XFILLER_90_983 VPWR VGND sg13cmos5l_fill_2
XFILLER_61_140 VPWR VGND sg13cmos5l_decap_8
XFILLER_50_814 VPWR VGND sg13cmos5l_decap_8
X_07470_ _07470_/X _11524_/Q _10799_/Q _07497_/A VPWR VGND sg13cmos5l_mux2_1
X_06421_ _06421_/Y _06772_/S _06421_/B VPWR VGND sg13cmos5l_nor2_1
XFILLER_22_538 VPWR VGND sg13cmos5l_fill_1
X_09140_ _09140_/X _09124_/Y _09128_/Y _09126_/Y VPWR VGND sg13cmos5l_a21o_1
X_06352_ _06352_/Y _06353_/C _06353_/D VPWR VGND sg13cmos5l_nand2_1
X_09071_ _09075_/A _08967_/A _08967_/B _09070_/Y VPWR VGND sg13cmos5l_o21ai_1
XFILLER_30_560 VPWR VGND sg13cmos5l_decap_8
X_06283_ _06283_/Y _07024_/A _09354_/A VPWR VGND sg13cmos5l_nand2_1
X_08022_ _11100_/D fanout80/X _08031_/B _08021_/Y VPWR VGND sg13cmos5l_a21oi_1
XFILLER_30_593 VPWR VGND sg13cmos5l_decap_8
X_11659__1305 _11659_/RESET_B VPWR VGND sg13cmos5l_tiehi
XFILLER_103_304 VPWR VGND sg13cmos5l_decap_8
X_09973_ _09974_/C _10026_/A _09969_/Y _09972_/Y VPWR VGND sg13cmos5l_o21ai_1
XFILLER_103_348 VPWR VGND sg13cmos5l_decap_4
Xhold2102 _08509_/A _11339_/Q VPWR VGND sg13cmos5l_dlygate4sd3_1
X_08924_ _08924_/Y _08924_/A _08936_/B VPWR VGND sg13cmos5l_nand2_1
XFILLER_97_560 VPWR VGND sg13cmos5l_fill_2
Xhold2113 _09032_/A _11445_/Q VPWR VGND sg13cmos5l_dlygate4sd3_1
Xhold2135 _08011_/A _11095_/Q VPWR VGND sg13cmos5l_dlygate4sd3_1
Xhold2124 _07572_/A _10909_/Q VPWR VGND sg13cmos5l_dlygate4sd3_1
Xhold2168 _08159_/A _11167_/Q VPWR VGND sg13cmos5l_dlygate4sd3_1
XFILLER_58_969 VPWR VGND sg13cmos5l_fill_1
X_08855_ _08855_/Y _08867_/A _08851_/Y _08854_/Y VPWR VGND sg13cmos5l_a21oi_1
Xhold2179 _07519_/A _10902_/Q VPWR VGND sg13cmos5l_dlygate4sd3_1
Xhold2157 _08023_/A _11101_/Q VPWR VGND sg13cmos5l_dlygate4sd3_1
Xhold2146 _11655_/D _06973_/Y VPWR VGND sg13cmos5l_dlygate4sd3_1
XFILLER_73_928 VPWR VGND sg13cmos5l_decap_8
X_08786_ _08786_/Y _08784_/X _08785_/Y _08780_/A VPWR VGND sg13cmos5l_a21oi_1
X_07806_ _07806_/Y _07806_/A _07808_/B VPWR VGND sg13cmos5l_nand2_1
XFILLER_84_287 VPWR VGND sg13cmos5l_fill_1
X_05998_ _06066_/C _10687_/B _06091_/A VPWR VGND sg13cmos5l_nand2b_1
XFILLER_38_682 VPWR VGND sg13cmos5l_fill_2
X_07737_ _10961_/D _08522_/A1 _07768_/B _07736_/Y VPWR VGND sg13cmos5l_a21oi_1
XFILLER_26_833 VPWR VGND sg13cmos5l_decap_8
XFILLER_77_1021 VPWR VGND sg13cmos5l_decap_8
XFILLER_53_652 VPWR VGND sg13cmos5l_decap_8
Xclkbuf_leaf_64_clk clkload20/A clkload0/A VPWR VGND sg13cmos5l_buf_8
X_11449__1392 _11449_/RESET_B VPWR VGND sg13cmos5l_tiehi
X_11009__973 _11009_/RESET_B VPWR VGND sg13cmos5l_tiehi
X_07668_ _07668_/Y _07668_/A _07676_/B VPWR VGND sg13cmos5l_nor2_1
X_07599_ _07599_/Y _07599_/A _07599_/B VPWR VGND sg13cmos5l_nor2_1
XFILLER_53_696 VPWR VGND sg13cmos5l_fill_1
XFILLER_52_195 VPWR VGND sg13cmos5l_fill_2
XFILLER_41_836 VPWR VGND sg13cmos5l_fill_2
XFILLER_13_549 VPWR VGND sg13cmos5l_fill_1
X_06619_ _06620_/B _06619_/A _06619_/B VPWR VGND sg13cmos5l_and2_1
X_09407_ _09408_/D _09481_/B _09406_/Y _09403_/Y VPWR VGND sg13cmos5l_o21ai_1
XFILLER_71_59 VPWR VGND sg13cmos5l_decap_8
X_09338_ _09338_/Y _09537_/A _09335_/Y _09337_/Y _09301_/S VPWR VGND sg13cmos5l_a22oi_1
XFILLER_21_582 VPWR VGND sg13cmos5l_fill_1
X_11300_ _11300_/Q _11594_/CLK _11300_/D _11300_/RESET_B VPWR VGND sg13cmos5l_dfrbpq_1
X_09269_ _10033_/A _10031_/A _10031_/B _10031_/C VPWR VGND sg13cmos5l_o21ai_1
XFILLER_5_715 VPWR VGND sg13cmos5l_decap_4
X_11231_ _11231_/Q _11364_/CLK _11231_/D _11231_/RESET_B VPWR VGND sg13cmos5l_dfrbpq_1
XFILLER_106_175 VPWR VGND sg13cmos5l_decap_8
XFILLER_4_269 VPWR VGND sg13cmos5l_fill_1
X_11162_ _11162_/Q _11361_/CLK _11162_/D _11162_/RESET_B VPWR VGND sg13cmos5l_dfrbpq_1
XFILLER_20_85 VPWR VGND sg13cmos5l_fill_1
X_11016__966 _11016_/RESET_B VPWR VGND sg13cmos5l_tiehi
XFILLER_1_932 VPWR VGND sg13cmos5l_decap_8
X_10113_ _10113_/Y _10114_/A1 _05978_/A _10131_/A2 VPWR VGND sg13cmos5l_o21ai_1
XFILLER_96_56 VPWR VGND sg13cmos5l_decap_8
XFILLER_76_711 VPWR VGND sg13cmos5l_decap_8
XFILLER_0_464 VPWR VGND sg13cmos5l_fill_2
X_11093_ _11093_/Q _11349_/CLK _11093_/D _11093_/RESET_B VPWR VGND sg13cmos5l_dfrbpq_1
XFILLER_103_893 VPWR VGND sg13cmos5l_fill_1
X_10044_ _10044_/Y _10044_/A _10044_/B _10044_/C VPWR VGND sg13cmos5l_nor3_1
XFILLER_75_221 VPWR VGND sg13cmos5l_decap_8
XFILLER_48_435 VPWR VGND sg13cmos5l_decap_4
XFILLER_0_497 VPWR VGND sg13cmos5l_decap_8
XFILLER_29_61 VPWR VGND sg13cmos5l_fill_2
XFILLER_76_777 VPWR VGND sg13cmos5l_fill_1
XFILLER_75_243 VPWR VGND sg13cmos5l_fill_1
Xhold2680 hold2680/X _11743_/Q VPWR VGND sg13cmos5l_dlygate4sd3_1
X_10850__1142 _10850_/RESET_B VPWR VGND sg13cmos5l_tiehi
Xhold2691 _05944_/A _11691_/Q VPWR VGND sg13cmos5l_dlygate4sd3_1
XFILLER_29_94 VPWR VGND sg13cmos5l_fill_2
Xhold1990 _08364_/A _11268_/Q VPWR VGND sg13cmos5l_dlygate4sd3_1
XFILLER_75_276 VPWR VGND sg13cmos5l_decap_8
XFILLER_90_246 VPWR VGND sg13cmos5l_fill_2
XFILLER_63_438 VPWR VGND sg13cmos5l_fill_1
XFILLER_44_641 VPWR VGND sg13cmos5l_fill_1
Xclkbuf_leaf_55_clk clkload42/A clkbuf_4_10_0_clk/X VPWR VGND sg13cmos5l_buf_8
X_10946_ _10946_/Q _11362_/CLK _10946_/D _10946_/RESET_B VPWR VGND sg13cmos5l_dfrbpq_1
XFILLER_71_460 VPWR VGND sg13cmos5l_fill_1
XFILLER_43_195 VPWR VGND sg13cmos5l_decap_8
X_10877_ _10877_/Q _11668_/CLK _10877_/D _10877_/RESET_B VPWR VGND sg13cmos5l_dfrbpq_1
XFILLER_31_302 VPWR VGND sg13cmos5l_decap_4
XFILLER_84_7 VPWR VGND sg13cmos5l_decap_8
XFILLER_6_21 VPWR VGND sg13cmos5l_decap_8
XANTENNA_3 _07412_/Y VPWR VGND sg13cmos5l_antennanp
X_11429_ _11429_/Q _11528_/CLK _11429_/D _11429_/RESET_B VPWR VGND sg13cmos5l_dfrbpq_1
XFILLER_98_379 VPWR VGND sg13cmos5l_fill_2
X_06970_ _06970_/Y _06970_/A _07034_/B VPWR VGND sg13cmos5l_nand2_1
XFILLER_6_1025 VPWR VGND sg13cmos5l_decap_4
X_05921_ _07036_/A _06184_/A VPWR VGND sg13cmos5l_inv_1
XFILLER_94_530 VPWR VGND sg13cmos5l_decap_4
XFILLER_55_917 VPWR VGND sg13cmos5l_fill_1
XFILLER_55_906 VPWR VGND sg13cmos5l_decap_8
X_08640_ _08640_/Y _08640_/A _11697_/D VPWR VGND sg13cmos5l_nor2_1
XFILLER_48_980 VPWR VGND sg13cmos5l_fill_1
XFILLER_26_107 VPWR VGND sg13cmos5l_fill_2
X_08571_ _08571_/Y _05951_/Y _08573_/S _08599_/S1 VPWR VGND sg13cmos5l_a21oi_1
XFILLER_70_909 VPWR VGND sg13cmos5l_fill_2
Xclkbuf_leaf_46_clk clkload36/A clkload3/A VPWR VGND sg13cmos5l_buf_8
X_07522_ _07522_/Y _11403_/Q _07514_/B _11404_/Q VPWR VGND sg13cmos5l_a21oi_1
XFILLER_34_151 VPWR VGND sg13cmos5l_decap_8
X_07453_ _07453_/X _11521_/Q _10796_/Q _07497_/A VPWR VGND sg13cmos5l_mux2_1
XFILLER_23_836 VPWR VGND sg13cmos5l_fill_2
X_06404_ _06404_/Y _06255_/Y _06425_/B _06403_/Y VPWR VGND sg13cmos5l_o21ai_1
XFILLER_34_195 VPWR VGND sg13cmos5l_decap_8
X_11107__1794 _11107_/RESET_B VPWR VGND sg13cmos5l_tiehi
X_09123_ _09123_/X _09123_/A _09123_/B VPWR VGND sg13cmos5l_and2_1
X_07384_ _10881_/D _07383_/B _07382_/Y _07383_/Y VPWR VGND sg13cmos5l_a21oi_1
X_06335_ _06335_/Y _06242_/A _06334_/Y _06328_/Y VPWR VGND sg13cmos5l_o21ai_1
X_06266_ _06266_/Y _11511_/Q _09909_/A VPWR VGND sg13cmos5l_nand2_1
X_09054_ _11446_/D _09052_/Y _09053_/Y _09042_/Y VPWR VGND sg13cmos5l_o21ai_1
X_08005_ _08005_/Y _08005_/A _08005_/B VPWR VGND sg13cmos5l_nor2_1
X_11286__1615 _11286_/RESET_B VPWR VGND sg13cmos5l_tiehi
X_06197_ _06346_/B _06197_/A _09189_/A VPWR VGND sg13cmos5l_nor2_1
XFILLER_104_646 VPWR VGND sg13cmos5l_fill_2
XFILLER_103_112 VPWR VGND sg13cmos5l_decap_8
XFILLER_104_679 VPWR VGND sg13cmos5l_fill_1
XFILLER_77_519 VPWR VGND sg13cmos5l_decap_8
X_09956_ _09956_/Y _11141_/Q _09957_/B _09991_/B1 VPWR VGND sg13cmos5l_a21oi_1
Xheichips26_RiMaX_1827 uio_oe[12] VPWR VGND sg13cmos5l_tiehi
XFILLER_106_77 VPWR VGND sg13cmos5l_decap_8
XFILLER_103_189 VPWR VGND sg13cmos5l_decap_8
X_09887_ _09887_/Y hold2768/X _09911_/B _09885_/Y _09886_/Y VPWR VGND sg13cmos5l_a22oi_1
X_08907_ _08908_/A _08864_/A _08907_/B _08907_/C VPWR VGND sg13cmos5l_nand3b_1
X_08838_ _08839_/B _08861_/A _08861_/C VPWR VGND sg13cmos5l_or2_1
XFILLER_100_874 VPWR VGND sg13cmos5l_decap_4
XFILLER_45_416 VPWR VGND sg13cmos5l_fill_2
Xclkbuf_leaf_37_clk clkload58/A clkload6/A VPWR VGND sg13cmos5l_buf_8
X_08769_ _11422_/D _08769_/A VPWR VGND sg13cmos5l_inv_1
XFILLER_73_769 VPWR VGND sg13cmos5l_decap_4
XFILLER_73_747 VPWR VGND sg13cmos5l_decap_8
XFILLER_72_235 VPWR VGND sg13cmos5l_fill_2
XFILLER_72_224 VPWR VGND sg13cmos5l_decap_8
XFILLER_82_36 VPWR VGND sg13cmos5l_decap_4
XFILLER_54_961 VPWR VGND sg13cmos5l_decap_8
X_10800_ _10800_/Q clkload11/A _10800_/D _10800_/RESET_B VPWR VGND sg13cmos5l_dfrbpq_1
XFILLER_81_791 VPWR VGND sg13cmos5l_decap_8
X_10731_ _10731_/Y _10731_/A _10731_/B _10731_/C VPWR VGND sg13cmos5l_nor3_1
XFILLER_13_324 VPWR VGND sg13cmos5l_decap_8
XFILLER_26_696 VPWR VGND sg13cmos5l_fill_2
XFILLER_14_869 VPWR VGND sg13cmos5l_fill_2
XFILLER_15_52 VPWR VGND sg13cmos5l_fill_2
X_10662_ _10664_/B _10662_/A _10662_/B _10662_/C _10662_/D VPWR VGND sg13cmos5l_nor4_1
XFILLER_51_1024 VPWR VGND sg13cmos5l_decap_4
XFILLER_41_688 VPWR VGND sg13cmos5l_decap_4
XFILLER_9_317 VPWR VGND sg13cmos5l_fill_2
X_10593_ _10593_/Y _10633_/B _10592_/Y _10654_/A VPWR VGND sg13cmos5l_o21ai_1
XFILLER_12_1008 VPWR VGND sg13cmos5l_decap_8
X_11214_ _11214_/Q clkload10/A _11214_/D _11214_/RESET_B VPWR VGND sg13cmos5l_dfrbpq_1
Xoutput40 uo_out[1] _06533_/Y VPWR VGND sg13cmos5l_buf_1
X_11145_ _11145_/Q clkload50/A _11145_/D _11145_/RESET_B VPWR VGND sg13cmos5l_dfrbpq_1
XFILLER_49_700 VPWR VGND sg13cmos5l_fill_2
XFILLER_1_751 VPWR VGND sg13cmos5l_decap_8
XFILLER_1_762 VPWR VGND sg13cmos5l_fill_1
X_11076_ _11076_/Q _11339_/CLK _11076_/D _11076_/RESET_B VPWR VGND sg13cmos5l_dfrbpq_1
XFILLER_0_250 VPWR VGND sg13cmos5l_decap_4
XFILLER_103_690 VPWR VGND sg13cmos5l_fill_1
X_10027_ _10027_/Y hold2804/X _10053_/A2 _10026_/Y VPWR VGND sg13cmos5l_a21oi_1
XFILLER_48_276 VPWR VGND sg13cmos5l_fill_1
Xclkbuf_leaf_28_clk _11715_/CLK clkbuf_4_12_0_clk/X VPWR VGND sg13cmos5l_buf_8
XFILLER_64_769 VPWR VGND sg13cmos5l_fill_2
XFILLER_63_224 VPWR VGND sg13cmos5l_decap_4
XFILLER_17_630 VPWR VGND sg13cmos5l_decap_8
XFILLER_17_652 VPWR VGND sg13cmos5l_fill_1
XFILLER_32_600 VPWR VGND sg13cmos5l_decap_8
X_11364__1537 _11364_/RESET_B VPWR VGND sg13cmos5l_tiehi
XFILLER_60_920 VPWR VGND sg13cmos5l_fill_2
XFILLER_44_471 VPWR VGND sg13cmos5l_fill_1
XFILLER_16_162 VPWR VGND sg13cmos5l_decap_8
XFILLER_16_184 VPWR VGND sg13cmos5l_fill_1
X_10929_ _10929_/Q clkload38/A _10929_/D _10929_/RESET_B VPWR VGND sg13cmos5l_dfrbpq_1
XFILLER_60_975 VPWR VGND sg13cmos5l_decap_4
X_11400__1490 _11400_/RESET_B VPWR VGND sg13cmos5l_tiehi
XFILLER_82_4 VPWR VGND sg13cmos5l_decap_8
XFILLER_20_828 VPWR VGND sg13cmos5l_decap_8
XFILLER_9_840 VPWR VGND sg13cmos5l_decap_8
X_06120_ _11763_/D _06120_/A VPWR VGND sg13cmos5l_inv_1
X_06051_ _06051_/Y _06051_/A _06051_/B VPWR VGND sg13cmos5l_nand2_1
XFILLER_67_1020 VPWR VGND sg13cmos5l_decap_8
XFILLER_99_655 VPWR VGND sg13cmos5l_decap_4
XFILLER_99_677 VPWR VGND sg13cmos5l_fill_1
XFILLER_98_154 VPWR VGND sg13cmos5l_decap_8
Xfanout318 _08313_/A1 _08508_/A1 VPWR VGND sg13cmos5l_buf_1
Xfanout307 _07813_/A2 _07787_/Y VPWR VGND sg13cmos5l_buf_1
X_09810_ _09810_/Y _09811_/B _09811_/C VPWR VGND sg13cmos5l_nand2_1
Xfanout329 _08626_/A1 _07044_/B1 VPWR VGND sg13cmos5l_buf_1
XFILLER_101_649 VPWR VGND sg13cmos5l_fill_2
X_06953_ _08612_/B _06953_/A _11391_/Q VPWR VGND sg13cmos5l_nor2_1
X_09741_ _09741_/Y _05977_/Y _09734_/B _09740_/Y VPWR VGND sg13cmos5l_a21oi_1
XFILLER_100_126 VPWR VGND sg13cmos5l_decap_8
X_05904_ _10287_/A _10250_/A VPWR VGND sg13cmos5l_inv_1
XFILLER_28_906 VPWR VGND sg13cmos5l_fill_2
XFILLER_67_585 VPWR VGND sg13cmos5l_decap_4
X_06884_ _06884_/X _11724_/Q hold2720/X _07088_/S VPWR VGND sg13cmos5l_mux2_1
X_09672_ _09672_/Y _09672_/A _09672_/B _09672_/C VPWR VGND sg13cmos5l_nor3_1
XFILLER_28_917 VPWR VGND sg13cmos5l_fill_2
Xclkbuf_leaf_19_clk clkload27/A clkload1/A VPWR VGND sg13cmos5l_buf_8
XFILLER_82_533 VPWR VGND sg13cmos5l_fill_2
X_08623_ _08623_/Y _08611_/C _08622_/Y hold2566/X VPWR VGND sg13cmos5l_a21oi_1
XFILLER_54_213 VPWR VGND sg13cmos5l_decap_8
XFILLER_27_438 VPWR VGND sg13cmos5l_decap_8
XFILLER_42_408 VPWR VGND sg13cmos5l_fill_1
XFILLER_36_950 VPWR VGND sg13cmos5l_decap_8
X_08554_ _11361_/D fanout68/X _08553_/B _08553_/Y VPWR VGND sg13cmos5l_a21oi_1
X_07505_ _07505_/X _07527_/S _10804_/Q VPWR VGND sg13cmos5l_and2_1
X_08485_ _11327_/D fanout74/X _08494_/B _08484_/Y VPWR VGND sg13cmos5l_o21ai_1
XFILLER_51_964 VPWR VGND sg13cmos5l_decap_8
XFILLER_22_110 VPWR VGND sg13cmos5l_decap_4
XFILLER_23_644 VPWR VGND sg13cmos5l_fill_2
X_11006__976 _11006_/RESET_B VPWR VGND sg13cmos5l_tiehi
X_07436_ _07720_/C _07786_/A _07786_/D VPWR VGND sg13cmos5l_nor2_1
XFILLER_51_997 VPWR VGND sg13cmos5l_fill_2
X_07367_ _07367_/Y _11540_/Q _08721_/A VPWR VGND sg13cmos5l_nand2_1
X_09106_ _09106_/Y _05939_/A _09102_/B _09106_/B1 VPWR VGND sg13cmos5l_o21ai_1
X_06318_ _06318_/Y _06224_/Y _06317_/Y _06309_/Y VPWR VGND sg13cmos5l_o21ai_1
X_09037_ _09037_/Y _09036_/C _09027_/Y _09061_/A VPWR VGND sg13cmos5l_o21ai_1
X_07298_ _07298_/Y _09507_/A _07304_/A2 _07297_/Y VPWR VGND sg13cmos5l_a21oi_1
XFILLER_105_911 VPWR VGND sg13cmos5l_decap_8
X_06249_ _06252_/A _11515_/Q _09264_/A VPWR VGND sg13cmos5l_and2_1
XFILLER_105_988 VPWR VGND sg13cmos5l_decap_8
XFILLER_104_454 VPWR VGND sg13cmos5l_decap_4
XFILLER_89_154 VPWR VGND sg13cmos5l_decap_8
Xfanout830 _10691_/C _10326_/A VPWR VGND sg13cmos5l_buf_1
XFILLER_77_69 VPWR VGND sg13cmos5l_fill_2
Xclkbuf_4_13_0_clk clkload5/A clkbuf_0_clk/X VPWR VGND sg13cmos5l_buf_8
X_09939_ _09939_/Y _10026_/A _09939_/B VPWR VGND sg13cmos5l_nor2_1
XFILLER_58_530 VPWR VGND sg13cmos5l_fill_2
X_11013__969 _11013_/RESET_B VPWR VGND sg13cmos5l_tiehi
XFILLER_46_714 VPWR VGND sg13cmos5l_decap_4
XFILLER_93_35 VPWR VGND sg13cmos5l_decap_8
XFILLER_85_393 VPWR VGND sg13cmos5l_fill_1
XFILLER_73_533 VPWR VGND sg13cmos5l_fill_1
XFILLER_46_747 VPWR VGND sg13cmos5l_decap_8
XFILLER_46_736 VPWR VGND sg13cmos5l_fill_2
XFILLER_73_555 VPWR VGND sg13cmos5l_decap_8
XFILLER_45_257 VPWR VGND sg13cmos5l_decap_8
XFILLER_26_51 VPWR VGND sg13cmos5l_decap_4
XFILLER_33_408 VPWR VGND sg13cmos5l_decap_8
XFILLER_60_238 VPWR VGND sg13cmos5l_fill_2
XFILLER_60_205 VPWR VGND sg13cmos5l_decap_8
XFILLER_42_931 VPWR VGND sg13cmos5l_fill_2
X_11763_ _11763_/Q _11767_/CLK _11763_/D _11763_/RESET_B VPWR VGND sg13cmos5l_dfrbpq_1
XFILLER_14_644 VPWR VGND sg13cmos5l_fill_2
X_11646__1319 _11646_/RESET_B VPWR VGND sg13cmos5l_tiehi
X_10714_ _10714_/Y hold2709/X _10709_/X _10739_/A VPWR VGND sg13cmos5l_a21oi_1
X_11694_ _11694_/Q _11713_/CLK _11694_/D _11694_/RESET_B VPWR VGND sg13cmos5l_dfrbpq_1
XFILLER_41_485 VPWR VGND sg13cmos5l_fill_2
XFILLER_41_452 VPWR VGND sg13cmos5l_fill_2
X_10645_ _10645_/Y _10659_/A _10644_/X _10682_/A VPWR VGND sg13cmos5l_o21ai_1
X_11654__1310 _11654_/RESET_B VPWR VGND sg13cmos5l_tiehi
X_10576_ _10578_/B _11416_/Q _10853_/Q VPWR VGND sg13cmos5l_xnor2_1
X_11687__1277 _11687_/RESET_B VPWR VGND sg13cmos5l_tiehi
XFILLER_95_102 VPWR VGND sg13cmos5l_fill_1
X_11128_ _11128_/Q _11349_/CLK _11128_/D _11128_/RESET_B VPWR VGND sg13cmos5l_dfrbpq_1
XFILLER_95_146 VPWR VGND sg13cmos5l_decap_8
XFILLER_64_500 VPWR VGND sg13cmos5l_decap_8
XFILLER_49_563 VPWR VGND sg13cmos5l_fill_2
XFILLER_49_552 VPWR VGND sg13cmos5l_decap_8
X_11059_ _11059_/Q clkload9/A _11059_/D _11059_/RESET_B VPWR VGND sg13cmos5l_dfrbpq_1
XFILLER_97_1024 VPWR VGND sg13cmos5l_decap_4
XFILLER_92_831 VPWR VGND sg13cmos5l_decap_8
XFILLER_37_747 VPWR VGND sg13cmos5l_fill_1
XFILLER_58_1008 VPWR VGND sg13cmos5l_fill_1
XFILLER_52_706 VPWR VGND sg13cmos5l_decap_4
XFILLER_36_268 VPWR VGND sg13cmos5l_decap_8
XFILLER_25_909 VPWR VGND sg13cmos5l_fill_1
XFILLER_51_205 VPWR VGND sg13cmos5l_fill_2
XFILLER_17_471 VPWR VGND sg13cmos5l_decap_4
XFILLER_33_931 VPWR VGND sg13cmos5l_decap_4
XFILLER_20_614 VPWR VGND sg13cmos5l_fill_2
X_08270_ _11221_/D _08530_/A1 _08293_/B _08269_/Y VPWR VGND sg13cmos5l_a21oi_1
X_10827__1530 _10827_/RESET_B VPWR VGND sg13cmos5l_tiehi
X_07221_ _07221_/Y _07225_/A1 _11631_/Q _07227_/B1 hold2663/X _07225_/C1 VPWR VGND
+ sg13cmos5l_a221oi_1
XFILLER_73_0 VPWR VGND sg13cmos5l_fill_2
X_07152_ _11741_/D _05881_/Y _07154_/A2 _07151_/Y VPWR VGND sg13cmos5l_a21oi_1
XFILLER_9_681 VPWR VGND sg13cmos5l_fill_2
X_06103_ _06103_/Y _06103_/A _06103_/B _06103_/C VPWR VGND sg13cmos5l_nand3_1
Xclkbuf_leaf_8_clk clkload19/A clkload0/A VPWR VGND sg13cmos5l_buf_8
X_07083_ _07083_/Y _07083_/A _07389_/B VPWR VGND sg13cmos5l_nor2_1
X_06034_ _06046_/A _11612_/Q _11603_/Q _11590_/Q VPWR VGND sg13cmos5l_nor3_1
Xfanout104 _08075_/A1 _08532_/A1 VPWR VGND sg13cmos5l_buf_1
Xfanout137 _08242_/B _08244_/B VPWR VGND sg13cmos5l_buf_1
Xfanout126 _08498_/B _08496_/B VPWR VGND sg13cmos5l_buf_1
Xfanout115 _08635_/S _08633_/S VPWR VGND sg13cmos5l_buf_1
Xfanout148 _07974_/B _07919_/Y VPWR VGND sg13cmos5l_buf_1
XFILLER_102_969 VPWR VGND sg13cmos5l_decap_8
X_07985_ _07985_/Y _07985_/A _08043_/B VPWR VGND sg13cmos5l_nor2_1
XFILLER_59_349 VPWR VGND sg13cmos5l_decap_8
Xfanout159 _07359_/B _07365_/B VPWR VGND sg13cmos5l_buf_1
X_06936_ _06936_/Y _10777_/C VPWR VGND sg13cmos5l_inv_1
X_09724_ _09724_/Y _09775_/A _09724_/B VPWR VGND sg13cmos5l_nand2_1
X_06867_ _06875_/B _11684_/Q _06879_/B VPWR VGND sg13cmos5l_nand2_1
XFILLER_55_533 VPWR VGND sg13cmos5l_decap_8
X_09655_ _09655_/Y _09653_/Y _09654_/Y _09738_/A1 VPWR VGND sg13cmos5l_a21oi_1
XFILLER_103_56 VPWR VGND sg13cmos5l_decap_8
X_08606_ _08606_/Y _10161_/B _09316_/A VPWR VGND sg13cmos5l_nand2_1
XFILLER_15_408 VPWR VGND sg13cmos5l_fill_2
X_06798_ _06798_/Y _06825_/A _06825_/B VPWR VGND sg13cmos5l_nand2b_1
XFILLER_82_385 VPWR VGND sg13cmos5l_fill_2
XFILLER_36_791 VPWR VGND sg13cmos5l_decap_8
X_09586_ _09587_/D _09508_/B _09582_/Y _09585_/Y VPWR VGND sg13cmos5l_o21ai_1
XFILLER_42_249 VPWR VGND sg13cmos5l_fill_1
X_08537_ _08537_/Y _08537_/A _08553_/B VPWR VGND sg13cmos5l_nor2_1
X_08468_ _08468_/Y _08468_/A _08468_/B VPWR VGND sg13cmos5l_nand2_1
XFILLER_23_463 VPWR VGND sg13cmos5l_fill_1
XFILLER_24_975 VPWR VGND sg13cmos5l_fill_1
XFILLER_10_102 VPWR VGND sg13cmos5l_decap_8
XFILLER_11_647 VPWR VGND sg13cmos5l_fill_2
X_07419_ _07419_/Y _07419_/A _07425_/B VPWR VGND sg13cmos5l_nor2_1
X_10430_ _10430_/Y _10418_/Y _10420_/Y _10421_/Y VPWR VGND sg13cmos5l_o21ai_1
XFILLER_10_157 VPWR VGND sg13cmos5l_decap_4
XFILLER_7_618 VPWR VGND sg13cmos5l_fill_2
X_08399_ _08399_/Y _08399_/A _08405_/B VPWR VGND sg13cmos5l_nor2_1
X_10361_ _11529_/D _10361_/A _10361_/B VPWR VGND sg13cmos5l_nor2_1
XFILLER_88_35 VPWR VGND sg13cmos5l_decap_8
X_10292_ _10293_/C _10273_/B _10273_/C _10276_/X _10261_/Y _10264_/Y VPWR VGND sg13cmos5l_a221oi_1
XFILLER_78_603 VPWR VGND sg13cmos5l_decap_8
XFILLER_105_774 VPWR VGND sg13cmos5l_decap_8
XFILLER_104_273 VPWR VGND sg13cmos5l_decap_4
XFILLER_2_367 VPWR VGND sg13cmos5l_decap_4
XFILLER_104_295 VPWR VGND sg13cmos5l_fill_1
XFILLER_78_658 VPWR VGND sg13cmos5l_decap_4
Xfanout660 _09278_/A fanout661/X VPWR VGND sg13cmos5l_buf_1
Xfanout682 fanout682/X _11754_/Q VPWR VGND sg13cmos5l_buf_1
Xfanout693 _07210_/B hold2532/X VPWR VGND sg13cmos5l_buf_1
XFILLER_58_360 VPWR VGND sg13cmos5l_decap_4
Xfanout671 _10330_/B _10526_/A VPWR VGND sg13cmos5l_buf_1
XFILLER_92_127 VPWR VGND sg13cmos5l_decap_4
XFILLER_74_831 VPWR VGND sg13cmos5l_fill_2
XFILLER_58_393 VPWR VGND sg13cmos5l_decap_4
XFILLER_73_352 VPWR VGND sg13cmos5l_fill_1
XFILLER_73_396 VPWR VGND sg13cmos5l_decap_4
XFILLER_27_791 VPWR VGND sg13cmos5l_decap_4
XFILLER_33_227 VPWR VGND sg13cmos5l_fill_1
XFILLER_61_558 VPWR VGND sg13cmos5l_fill_1
X_11746_ _11746_/Q clkload23/A _11746_/D _11746_/RESET_B VPWR VGND sg13cmos5l_dfrbpq_1
X_11281__1620 _11281_/RESET_B VPWR VGND sg13cmos5l_tiehi
XFILLER_42_794 VPWR VGND sg13cmos5l_decap_8
X_11677_ _11677_/Q clkload12/A _11677_/D _11677_/RESET_B VPWR VGND sg13cmos5l_dfrbpq_1
X_10628_ _10630_/C _10628_/A _10628_/B _10632_/B VPWR VGND sg13cmos5l_nand3_1
X_10559_ _10560_/C hold2806/X _10548_/B fanout84/X VPWR VGND sg13cmos5l_a21oi_1
XFILLER_45_4 VPWR VGND sg13cmos5l_decap_8
Xhold2509 hold2509/X _11677_/Q VPWR VGND sg13cmos5l_dlygate4sd3_1
XFILLER_96_433 VPWR VGND sg13cmos5l_fill_2
X_07770_ _07770_/Y _07770_/A _07770_/B VPWR VGND sg13cmos5l_nor2_1
XFILLER_68_168 VPWR VGND sg13cmos5l_decap_8
XFILLER_65_842 VPWR VGND sg13cmos5l_decap_8
XFILLER_49_382 VPWR VGND sg13cmos5l_decap_4
X_06721_ _06721_/Y _06721_/A _06721_/B VPWR VGND sg13cmos5l_xnor2_1
XFILLER_83_149 VPWR VGND sg13cmos5l_fill_1
X_09440_ _09440_/Y _10962_/Q _09440_/B VPWR VGND sg13cmos5l_nand2_1
XFILLER_65_897 VPWR VGND sg13cmos5l_decap_4
XFILLER_52_503 VPWR VGND sg13cmos5l_decap_8
X_06652_ _10804_/D _06668_/A1 _06649_/Y _06651_/Y VPWR VGND sg13cmos5l_o21ai_1
X_06583_ _06583_/Y _06583_/A _06583_/B VPWR VGND sg13cmos5l_xnor2_1
X_09371_ _09371_/Y _11311_/Q _09600_/B VPWR VGND sg13cmos5l_nand2b_1
XFILLER_24_249 VPWR VGND sg13cmos5l_decap_4
X_08322_ _08322_/Y _08322_/A _08340_/B VPWR VGND sg13cmos5l_nand2_1
X_08253_ _08253_/Y _08253_/A _08263_/B VPWR VGND sg13cmos5l_nor2_1
X_07204_ _07204_/Y _07204_/A _07204_/B VPWR VGND sg13cmos5l_nand2_1
X_08184_ _08184_/Y _08184_/A _08234_/B VPWR VGND sg13cmos5l_nand2_1
X_11003__979 _11003_/RESET_B VPWR VGND sg13cmos5l_tiehi
X_07135_ _07135_/Y hold2819/X _07148_/A2 _07145_/B1 VPWR VGND sg13cmos5l_o21ai_1
X_11144__1757 _11144_/RESET_B VPWR VGND sg13cmos5l_tiehi
X_07066_ _07066_/Y _07067_/A _10469_/C VPWR VGND sg13cmos5l_nand2b_1
X_06017_ _06017_/Y _06017_/A _06017_/B VPWR VGND sg13cmos5l_nand2_1
XFILLER_99_271 VPWR VGND sg13cmos5l_fill_2
XFILLER_88_945 VPWR VGND sg13cmos5l_fill_2
XFILLER_58_27 VPWR VGND sg13cmos5l_decap_8
XFILLER_0_838 VPWR VGND sg13cmos5l_decap_8
XFILLER_101_221 VPWR VGND sg13cmos5l_fill_2
XFILLER_101_210 VPWR VGND sg13cmos5l_decap_8
XFILLER_88_967 VPWR VGND sg13cmos5l_decap_4
X_07968_ _07968_/Y _07968_/A _07976_/B VPWR VGND sg13cmos5l_nand2_1
X_06919_ _11690_/D _06943_/C VPWR VGND sg13cmos5l_inv_1
XFILLER_75_639 VPWR VGND sg13cmos5l_decap_8
X_09707_ _09707_/X _11132_/Q _11100_/Q _11068_/Q _11036_/Q _09708_/S _09707_/S1 VPWR
+ VGND sg13cmos5l_mux4_1
X_07899_ _07899_/Y _07899_/A _07899_/B VPWR VGND sg13cmos5l_nor2_1
XFILLER_56_897 VPWR VGND sg13cmos5l_fill_1
X_09638_ _09638_/Y _09851_/B2 _09637_/Y _09633_/Y VPWR VGND sg13cmos5l_a21oi_1
X_09569_ _09569_/X _10999_/Q _10967_/Q _09576_/B VPWR VGND sg13cmos5l_mux2_1
XFILLER_31_709 VPWR VGND sg13cmos5l_decap_4
X_11600_ _11600_/Q _11646_/CLK _11600_/D _11600_/RESET_B VPWR VGND sg13cmos5l_dfrbpq_1
XFILLER_90_14 VPWR VGND sg13cmos5l_decap_8
XFILLER_70_355 VPWR VGND sg13cmos5l_decap_8
XFILLER_12_923 VPWR VGND sg13cmos5l_decap_8
X_11531_ _11531_/Q clkload20/A _11531_/D _11531_/RESET_B VPWR VGND sg13cmos5l_dfrbpq_1
XFILLER_8_938 VPWR VGND sg13cmos5l_fill_2
XFILLER_7_415 VPWR VGND sg13cmos5l_fill_1
XFILLER_7_404 VPWR VGND sg13cmos5l_decap_8
XFILLER_11_477 VPWR VGND sg13cmos5l_decap_4
X_11462_ _11462_/Q clkload18/A _11462_/D _11462_/RESET_B VPWR VGND sg13cmos5l_dfrbpq_1
X_11393_ _11393_/Q clkload28/A _11393_/D _11393_/RESET_B VPWR VGND sg13cmos5l_dfrbpq_1
X_10413_ _10413_/Y _10408_/Y _10409_/Y _10412_/Y _10443_/B1 _10560_/A VPWR VGND sg13cmos5l_a221oi_1
XFILLER_99_67 VPWR VGND sg13cmos5l_decap_8
X_10344_ _10344_/Y _10422_/A _10343_/Y VPWR VGND sg13cmos5l_nor2b_1
XFILLER_3_0 VPWR VGND sg13cmos5l_decap_8
XFILLER_79_934 VPWR VGND sg13cmos5l_fill_1
X_10275_ _10277_/C _10261_/A _10261_/C _10261_/B VPWR VGND sg13cmos5l_a21oi_1
XFILLER_105_593 VPWR VGND sg13cmos5l_decap_8
XFILLER_79_978 VPWR VGND sg13cmos5l_decap_4
XFILLER_79_967 VPWR VGND sg13cmos5l_decap_4
XFILLER_79_956 VPWR VGND sg13cmos5l_fill_2
X_11299__1602 _11299_/RESET_B VPWR VGND sg13cmos5l_tiehi
XFILLER_79_989 VPWR VGND sg13cmos5l_fill_1
XFILLER_65_105 VPWR VGND sg13cmos5l_fill_2
X_10933__1049 _10933_/RESET_B VPWR VGND sg13cmos5l_tiehi
XFILLER_93_447 VPWR VGND sg13cmos5l_decap_8
Xfanout490 _10062_/A2 _10058_/Y VPWR VGND sg13cmos5l_buf_1
XFILLER_17_8 VPWR VGND sg13cmos5l_decap_8
XFILLER_47_864 VPWR VGND sg13cmos5l_decap_4
XFILLER_19_566 VPWR VGND sg13cmos5l_decap_8
XFILLER_47_886 VPWR VGND sg13cmos5l_fill_2
XFILLER_61_344 VPWR VGND sg13cmos5l_fill_1
X_11222__1679 _11222_/RESET_B VPWR VGND sg13cmos5l_tiehi
XFILLER_15_761 VPWR VGND sg13cmos5l_fill_2
XFILLER_14_282 VPWR VGND sg13cmos5l_fill_2
XFILLER_30_731 VPWR VGND sg13cmos5l_fill_1
X_11729_ _11729_/Q clkload22/A _11729_/D _11729_/RESET_B VPWR VGND sg13cmos5l_dfrbpq_1
XFILLER_7_960 VPWR VGND sg13cmos5l_fill_1
XFILLER_7_993 VPWR VGND sg13cmos5l_decap_8
X_08940_ _08941_/B _08940_/A _08964_/B VPWR VGND sg13cmos5l_nor2_1
XFILLER_9_1012 VPWR VGND sg13cmos5l_decap_8
Xhold2328 _08025_/A _11102_/Q VPWR VGND sg13cmos5l_dlygate4sd3_1
XFILLER_69_444 VPWR VGND sg13cmos5l_fill_2
XFILLER_69_433 VPWR VGND sg13cmos5l_fill_1
Xhold2306 _08561_/A _11365_/Q VPWR VGND sg13cmos5l_dlygate4sd3_1
X_08871_ _08871_/Y _08871_/A _08895_/B VPWR VGND sg13cmos5l_nand2_1
Xhold2317 _07997_/A _11088_/Q VPWR VGND sg13cmos5l_dlygate4sd3_1
XFILLER_97_764 VPWR VGND sg13cmos5l_decap_4
Xhold2339 _08167_/A _11171_/Q VPWR VGND sg13cmos5l_dlygate4sd3_1
XFILLER_69_455 VPWR VGND sg13cmos5l_decap_8
X_07822_ _07822_/Y _07822_/A _07844_/B VPWR VGND sg13cmos5l_nand2_1
X_10909__1073 _10909_/RESET_B VPWR VGND sg13cmos5l_tiehi
XFILLER_85_948 VPWR VGND sg13cmos5l_decap_8
X_07753_ _10969_/D fanout99/X _07760_/B _07752_/Y VPWR VGND sg13cmos5l_a21oi_1
XFILLER_53_812 VPWR VGND sg13cmos5l_fill_2
X_07684_ _07684_/Y _07684_/A _07684_/B VPWR VGND sg13cmos5l_nor2_1
XFILLER_25_514 VPWR VGND sg13cmos5l_decap_8
XFILLER_25_525 VPWR VGND sg13cmos5l_decap_8
X_06704_ _06705_/B _06700_/Y _06701_/Y _06703_/Y VPWR VGND sg13cmos5l_o21ai_1
XFILLER_53_856 VPWR VGND sg13cmos5l_decap_8
XFILLER_53_845 VPWR VGND sg13cmos5l_fill_1
X_09423_ _09423_/X _11249_/Q _11217_/Q _11185_/Q _11153_/Q _09552_/B _09707_/S1 VPWR
+ VGND sg13cmos5l_mux4_1
X_06635_ _10802_/D _06668_/A1 _06632_/Y _06634_/Y VPWR VGND sg13cmos5l_o21ai_1
XFILLER_12_208 VPWR VGND sg13cmos5l_fill_1
X_09354_ _09354_/Y _09354_/A _09354_/B VPWR VGND sg13cmos5l_nand2_1
XFILLER_100_35 VPWR VGND sg13cmos5l_decap_8
X_08305_ _08305_/Y _08305_/A _08307_/B VPWR VGND sg13cmos5l_nor2_1
XFILLER_52_399 VPWR VGND sg13cmos5l_decap_8
X_06566_ _06566_/Y _06566_/A _06566_/B VPWR VGND sg13cmos5l_nand2_1
X_09285_ _09285_/X _11017_/Q _10985_/Q _10034_/B VPWR VGND sg13cmos5l_mux2_1
X_11682__1282 _11682_/RESET_B VPWR VGND sg13cmos5l_tiehi
X_06497_ _06497_/Y _09574_/A1 _06496_/X _09574_/B1 VPWR VGND sg13cmos5l_a21oi_1
X_08236_ _08236_/Y _08236_/A _08236_/B VPWR VGND sg13cmos5l_nand2_1
XFILLER_60_39 VPWR VGND sg13cmos5l_decap_8
X_08167_ _08167_/Y _08167_/A _08177_/B VPWR VGND sg13cmos5l_nor2_1
X_07118_ _11724_/D _05882_/Y _07120_/A2 _07117_/Y VPWR VGND sg13cmos5l_a21oi_1
XFILLER_106_357 VPWR VGND sg13cmos5l_decap_8
X_08098_ _08098_/Y _08098_/A _08106_/B VPWR VGND sg13cmos5l_nand2_1
X_07049_ _07049_/Y _11514_/Q _10165_/B VPWR VGND sg13cmos5l_nand2_1
X_10060_ _11487_/D _07008_/A _10062_/A2 _10059_/Y _08585_/Y VPWR VGND sg13cmos5l_a22oi_1
XFILLER_102_541 VPWR VGND sg13cmos5l_fill_1
XFILLER_85_14 VPWR VGND sg13cmos5l_decap_8
Xhold2840 hold2840/X _11409_/Q VPWR VGND sg13cmos5l_dlygate4sd3_1
XFILLER_0_657 VPWR VGND sg13cmos5l_decap_8
X_11602__1381 _11602_/RESET_B VPWR VGND sg13cmos5l_tiehi
XFILLER_76_948 VPWR VGND sg13cmos5l_fill_1
Xhold2873 _11511_/D _10134_/X VPWR VGND sg13cmos5l_dlygate4sd3_1
XFILLER_48_639 VPWR VGND sg13cmos5l_decap_8
Xhold2862 hold2862/X _11497_/Q VPWR VGND sg13cmos5l_dlygate4sd3_1
Xhold2851 hold2851/X _11468_/Q VPWR VGND sg13cmos5l_dlygate4sd3_1
Xhold2884 hold2884/X _11466_/Q VPWR VGND sg13cmos5l_dlygate4sd3_1
XFILLER_75_469 VPWR VGND sg13cmos5l_decap_8
Xhold2895 hold2895/X _11741_/Q VPWR VGND sg13cmos5l_dlygate4sd3_1
XFILLER_90_417 VPWR VGND sg13cmos5l_decap_8
XFILLER_84_970 VPWR VGND sg13cmos5l_fill_1
XFILLER_56_683 VPWR VGND sg13cmos5l_decap_8
XFILLER_44_812 VPWR VGND sg13cmos5l_decap_4
X_10962_ _10962_/Q clkload8/A _10962_/D _10962_/RESET_B VPWR VGND sg13cmos5l_dfrbpq_1
XFILLER_18_85 VPWR VGND sg13cmos5l_fill_2
XFILLER_56_694 VPWR VGND sg13cmos5l_fill_1
XFILLER_43_311 VPWR VGND sg13cmos5l_fill_1
XFILLER_16_558 VPWR VGND sg13cmos5l_fill_2
XFILLER_70_152 VPWR VGND sg13cmos5l_decap_8
X_10893_ _10893_/Q clkload33/A _10893_/D _10893_/RESET_B VPWR VGND sg13cmos5l_dfrbpq_1
XFILLER_12_742 VPWR VGND sg13cmos5l_decap_4
XFILLER_15_1028 VPWR VGND sg13cmos5l_fill_1
X_11514_ _11514_/Q _11715_/CLK _11514_/D _11514_/RESET_B VPWR VGND sg13cmos5l_dfrbpq_1
XFILLER_12_786 VPWR VGND sg13cmos5l_decap_8
X_11445_ _11445_/Q clkload55/A _11445_/D _11445_/RESET_B VPWR VGND sg13cmos5l_dfrbpq_1
XFILLER_8_768 VPWR VGND sg13cmos5l_decap_4
XFILLER_7_267 VPWR VGND sg13cmos5l_decap_8
X_11376_ _11376_/Q _11766_/CLK _11376_/D _11376_/RESET_B VPWR VGND sg13cmos5l_dfrbpq_1
X_10327_ _10328_/B _09721_/A _06236_/A _09696_/A _10424_/B VPWR VGND sg13cmos5l_a22oi_1
XFILLER_3_462 VPWR VGND sg13cmos5l_fill_2
XFILLER_61_1004 VPWR VGND sg13cmos5l_fill_1
XFILLER_59_70 VPWR VGND sg13cmos5l_fill_1
X_10258_ _10261_/B _10285_/A _10267_/C VPWR VGND sg13cmos5l_and2_1
XFILLER_78_241 VPWR VGND sg13cmos5l_decap_8
XFILLER_94_745 VPWR VGND sg13cmos5l_fill_2
XFILLER_94_734 VPWR VGND sg13cmos5l_decap_8
X_10189_ _10189_/Y _09189_/A _09335_/B _10187_/Y _10188_/Y VPWR VGND sg13cmos5l_a22oi_1
XFILLER_39_639 VPWR VGND sg13cmos5l_fill_1
XFILLER_66_458 VPWR VGND sg13cmos5l_decap_4
XFILLER_81_428 VPWR VGND sg13cmos5l_fill_2
XFILLER_75_91 VPWR VGND sg13cmos5l_fill_2
XFILLER_19_352 VPWR VGND sg13cmos5l_decap_8
XFILLER_62_642 VPWR VGND sg13cmos5l_fill_1
XFILLER_62_620 VPWR VGND sg13cmos5l_fill_1
XFILLER_46_182 VPWR VGND sg13cmos5l_decap_4
XFILLER_35_845 VPWR VGND sg13cmos5l_fill_1
X_06420_ _06423_/A _06772_/S _06420_/B _06420_/C VPWR VGND sg13cmos5l_nand3_1
XFILLER_61_130 VPWR VGND sg13cmos5l_fill_1
XFILLER_22_506 VPWR VGND sg13cmos5l_fill_1
XFILLER_34_355 VPWR VGND sg13cmos5l_decap_8
XFILLER_34_377 VPWR VGND sg13cmos5l_fill_2
XFILLER_50_859 VPWR VGND sg13cmos5l_fill_2
X_06351_ _06353_/D _06351_/A _06351_/B _06351_/C VPWR VGND sg13cmos5l_nand3_1
X_09070_ _09070_/Y _09070_/A _09072_/B VPWR VGND sg13cmos5l_nor2b_1
X_06282_ _06282_/X _06605_/A _06602_/B _06602_/C VPWR VGND sg13cmos5l_or3_1
X_08021_ _08021_/Y _08021_/A _08031_/B VPWR VGND sg13cmos5l_nor2_1
XFILLER_103_316 VPWR VGND sg13cmos5l_fill_2
X_09972_ _09972_/Y hold2762/X _09911_/B _09885_/Y _09971_/X VPWR VGND sg13cmos5l_a22oi_1
XFILLER_103_338 VPWR VGND sg13cmos5l_fill_1
X_08923_ _11436_/D _08921_/Y _08922_/Y _08905_/Y VPWR VGND sg13cmos5l_o21ai_1
Xhold2103 _07662_/A _10925_/Q VPWR VGND sg13cmos5l_dlygate4sd3_1
Xhold2136 _08549_/A _11359_/Q VPWR VGND sg13cmos5l_dlygate4sd3_1
Xhold2125 _07909_/A _11045_/Q VPWR VGND sg13cmos5l_dlygate4sd3_1
Xhold2114 _08007_/A _11093_/Q VPWR VGND sg13cmos5l_dlygate4sd3_1
Xhold2147 _08297_/A _11235_/Q VPWR VGND sg13cmos5l_dlygate4sd3_1
Xhold2158 _08035_/A _11107_/Q VPWR VGND sg13cmos5l_dlygate4sd3_1
XFILLER_58_948 VPWR VGND sg13cmos5l_decap_4
XFILLER_57_436 VPWR VGND sg13cmos5l_fill_1
XFILLER_57_425 VPWR VGND sg13cmos5l_decap_8
X_08854_ _08854_/Y _08867_/A _08853_/Y _08880_/A1 VPWR VGND sg13cmos5l_o21ai_1
Xhold2169 _08003_/A _11091_/Q VPWR VGND sg13cmos5l_dlygate4sd3_1
X_05997_ _10687_/B _08621_/B _08614_/A _05996_/Y VPWR VGND sg13cmos5l_a21oi_1
X_08785_ _08785_/Y _08784_/A _08784_/B _10719_/B VPWR VGND sg13cmos5l_a21oi_1
X_07805_ _10994_/D _08524_/A1 _07808_/B _07804_/Y VPWR VGND sg13cmos5l_o21ai_1
XFILLER_66_970 VPWR VGND sg13cmos5l_decap_4
XFILLER_44_119 VPWR VGND sg13cmos5l_fill_1
X_07736_ _07736_/Y _07736_/A _07768_/B VPWR VGND sg13cmos5l_nor2_1
XFILLER_81_962 VPWR VGND sg13cmos5l_decap_8
XFILLER_52_152 VPWR VGND sg13cmos5l_decap_8
X_07667_ _10927_/D _08518_/A1 _07684_/B _07666_/Y VPWR VGND sg13cmos5l_a21oi_1
XFILLER_81_995 VPWR VGND sg13cmos5l_decap_8
X_07598_ _07599_/B _11414_/Q _07597_/C _11415_/Q VPWR VGND sg13cmos5l_a21oi_1
XFILLER_40_325 VPWR VGND sg13cmos5l_decap_4
X_06618_ _06619_/B _06639_/A _06618_/B _06618_/C VPWR VGND sg13cmos5l_or3_1
X_09406_ _09406_/Y _09456_/A _09336_/B _09644_/A VPWR VGND sg13cmos5l_o21ai_1
XFILLER_71_49 VPWR VGND sg13cmos5l_fill_1
XFILLER_40_336 VPWR VGND sg13cmos5l_decap_4
X_09337_ _09337_/Y _09354_/A _09336_/B _09403_/B VPWR VGND sg13cmos5l_o21ai_1
X_06549_ _06551_/A _11762_/Q _10881_/Q _11655_/Q _06133_/B VPWR VGND sg13cmos5l_a22oi_1
X_09268_ _10031_/C _09268_/A _09268_/B VPWR VGND sg13cmos5l_xor2_1
X_08219_ _11196_/D fanout81/X _08218_/B _08218_/Y VPWR VGND sg13cmos5l_o21ai_1
X_09199_ _09439_/A _09199_/A _09206_/A VPWR VGND sg13cmos5l_nor2_1
X_11230_ _11230_/Q clkload52/A _11230_/D _11230_/RESET_B VPWR VGND sg13cmos5l_dfrbpq_1
XFILLER_84_1015 VPWR VGND sg13cmos5l_decap_4
XFILLER_84_1004 VPWR VGND sg13cmos5l_fill_1
XFILLER_106_154 VPWR VGND sg13cmos5l_decap_8
XFILLER_1_911 VPWR VGND sg13cmos5l_decap_8
X_11161_ _11161_/Q _11265_/CLK _11161_/D _11161_/RESET_B VPWR VGND sg13cmos5l_dfrbpq_1
XFILLER_96_35 VPWR VGND sg13cmos5l_decap_8
XFILLER_20_97 VPWR VGND sg13cmos5l_fill_1
X_10112_ _11505_/D _10423_/B _10131_/A2 _10111_/X VPWR VGND sg13cmos5l_o21ai_1
XFILLER_95_509 VPWR VGND sg13cmos5l_decap_8
X_11092_ _11092_/Q _11347_/CLK _11092_/D _11092_/RESET_B VPWR VGND sg13cmos5l_dfrbpq_1
XFILLER_0_454 VPWR VGND sg13cmos5l_fill_1
XFILLER_1_988 VPWR VGND sg13cmos5l_decap_8
X_10043_ _10044_/C _10039_/Y _10040_/Y _10041_/Y _10042_/Y _10043_/C1 VPWR VGND sg13cmos5l_a221oi_1
XFILLER_0_476 VPWR VGND sg13cmos5l_decap_8
XFILLER_29_40 VPWR VGND sg13cmos5l_fill_1
XFILLER_29_51 VPWR VGND sg13cmos5l_fill_1
Xhold2670 _06071_/A _06067_/X VPWR VGND sg13cmos5l_dlygate4sd3_1
XFILLER_76_756 VPWR VGND sg13cmos5l_fill_1
Xhold2692 _11637_/D _06907_/Y VPWR VGND sg13cmos5l_dlygate4sd3_1
Xhold2681 _05946_/A _11386_/Q VPWR VGND sg13cmos5l_dlygate4sd3_1
Xhold1980 _08226_/A _11200_/Q VPWR VGND sg13cmos5l_dlygate4sd3_1
XFILLER_57_970 VPWR VGND sg13cmos5l_fill_2
XFILLER_29_661 VPWR VGND sg13cmos5l_decap_4
Xhold1991 _08050_/A _11114_/Q VPWR VGND sg13cmos5l_dlygate4sd3_1
XFILLER_56_480 VPWR VGND sg13cmos5l_decap_8
XFILLER_44_620 VPWR VGND sg13cmos5l_decap_8
XFILLER_29_694 VPWR VGND sg13cmos5l_decap_8
XFILLER_44_653 VPWR VGND sg13cmos5l_decap_8
X_10945_ _10945_/Q _11361_/CLK _10945_/D _10945_/RESET_B VPWR VGND sg13cmos5l_dfrbpq_1
XFILLER_32_815 VPWR VGND sg13cmos5l_decap_8
X_11737__1206 _11737_/RESET_B VPWR VGND sg13cmos5l_tiehi
X_10883__1099 _10883_/RESET_B VPWR VGND sg13cmos5l_tiehi
X_10876_ _10876_/Q _11668_/CLK _10876_/D _10876_/RESET_B VPWR VGND sg13cmos5l_dfrbpq_1
XFILLER_32_837 VPWR VGND sg13cmos5l_decap_8
X_11428_ _11428_/Q _11528_/CLK _11428_/D _11428_/RESET_B VPWR VGND sg13cmos5l_dfrbpq_1
XANTENNA_4 _08376_/Y VPWR VGND sg13cmos5l_antennanp
XFILLER_98_303 VPWR VGND sg13cmos5l_fill_1
X_11359_ _11359_/Q clkload50/A _11359_/D _11359_/RESET_B VPWR VGND sg13cmos5l_dfrbpq_1
XFILLER_3_281 VPWR VGND sg13cmos5l_fill_2
XFILLER_79_594 VPWR VGND sg13cmos5l_fill_1
XFILLER_67_734 VPWR VGND sg13cmos5l_decap_4
XFILLER_6_1004 VPWR VGND sg13cmos5l_decap_8
X_05920_ _09348_/A _09198_/A VPWR VGND sg13cmos5l_inv_1
XFILLER_67_767 VPWR VGND sg13cmos5l_decap_4
XFILLER_39_436 VPWR VGND sg13cmos5l_decap_8
XFILLER_94_597 VPWR VGND sg13cmos5l_fill_2
X_08570_ _11369_/D fanout49/X _08565_/B _08569_/Y VPWR VGND sg13cmos5l_a21oi_1
XFILLER_82_715 VPWR VGND sg13cmos5l_decap_8
XFILLER_47_480 VPWR VGND sg13cmos5l_decap_8
XFILLER_35_631 VPWR VGND sg13cmos5l_fill_1
XFILLER_35_620 VPWR VGND sg13cmos5l_decap_8
X_07521_ _07542_/D _07521_/A _07521_/B _07521_/C _07521_/D VPWR VGND sg13cmos5l_nor4_1
XFILLER_63_962 VPWR VGND sg13cmos5l_decap_8
XFILLER_62_483 VPWR VGND sg13cmos5l_fill_2
XFILLER_62_472 VPWR VGND sg13cmos5l_fill_2
X_07452_ _07452_/Y _07472_/D _07452_/B VPWR VGND sg13cmos5l_nor2_1
X_11419__1452 _11419_/RESET_B VPWR VGND sg13cmos5l_tiehi
X_06403_ _06403_/Y _10641_/A _06665_/B VPWR VGND sg13cmos5l_nand2b_1
X_07383_ _07383_/Y _07383_/A _07383_/B VPWR VGND sg13cmos5l_nor2_1
XFILLER_22_347 VPWR VGND sg13cmos5l_decap_4
X_06334_ _06334_/Y _10672_/A _06332_/A _06333_/Y VPWR VGND sg13cmos5l_a21oi_1
X_09122_ _09123_/B _09102_/B _09118_/A _09109_/A VPWR VGND sg13cmos5l_o21ai_1
X_09053_ _09053_/Y _09049_/Y _09051_/Y _09064_/B1 VPWR VGND sg13cmos5l_o21ai_1
X_06265_ _06269_/A _06265_/A _09909_/A VPWR VGND sg13cmos5l_and2_1
X_06196_ _06591_/A _06197_/A _09189_/A VPWR VGND sg13cmos5l_nand2_1
X_08004_ _11091_/D _08331_/A1 _08011_/B _08003_/Y VPWR VGND sg13cmos5l_a21oi_1
XFILLER_104_669 VPWR VGND sg13cmos5l_fill_2
XFILLER_58_701 VPWR VGND sg13cmos5l_decap_8
Xheichips26_RiMaX_1828 uio_oe[13] VPWR VGND sg13cmos5l_tiehi
X_09955_ _09955_/Y _11109_/Q _09955_/B VPWR VGND sg13cmos5l_nand2_1
XFILLER_106_56 VPWR VGND sg13cmos5l_decap_8
XFILLER_103_168 VPWR VGND sg13cmos5l_decap_8
X_09886_ _09886_/Y _05900_/Y _09970_/B _10026_/A VPWR VGND sg13cmos5l_a21oi_1
X_08906_ _08907_/C _08906_/A _08906_/B VPWR VGND sg13cmos5l_nor2_1
XFILLER_58_745 VPWR VGND sg13cmos5l_decap_8
X_08837_ _08861_/C _11380_/Q _08827_/B _08814_/Y _08816_/B _08812_/X VPWR VGND sg13cmos5l_a221oi_1
XFILLER_39_970 VPWR VGND sg13cmos5l_fill_2
XFILLER_17_108 VPWR VGND sg13cmos5l_fill_2
XFILLER_85_597 VPWR VGND sg13cmos5l_fill_1
X_08768_ _08769_/A _10668_/A _09155_/B _09138_/B _09154_/B1 VPWR VGND sg13cmos5l_a22oi_1
XFILLER_17_119 VPWR VGND sg13cmos5l_fill_2
X_07719_ _10953_/D fanout49/X _07718_/B _07718_/Y VPWR VGND sg13cmos5l_a21oi_1
XFILLER_26_675 VPWR VGND sg13cmos5l_decap_8
X_08699_ _08700_/B _08730_/A _08699_/B VPWR VGND sg13cmos5l_nand2_1
X_10730_ _10730_/Y _10730_/A _10730_/B VPWR VGND sg13cmos5l_nand2_1
XFILLER_54_995 VPWR VGND sg13cmos5l_fill_2
XFILLER_53_472 VPWR VGND sg13cmos5l_fill_2
XFILLER_14_848 VPWR VGND sg13cmos5l_decap_8
X_10661_ _10662_/D _10661_/A _10673_/A VPWR VGND sg13cmos5l_nor2b_1
XFILLER_41_656 VPWR VGND sg13cmos5l_decap_8
X_10853__1136 _10853_/RESET_B VPWR VGND sg13cmos5l_tiehi
XFILLER_51_1003 VPWR VGND sg13cmos5l_decap_8
X_10592_ _10592_/Y _10592_/A _10592_/B VPWR VGND sg13cmos5l_nand2_1
X_11490__1203 _11490_/RESET_B VPWR VGND sg13cmos5l_tiehi
X_10868__1114 _10868_/RESET_B VPWR VGND sg13cmos5l_tiehi
XFILLER_31_74 VPWR VGND sg13cmos5l_fill_1
XFILLER_103_0 VPWR VGND sg13cmos5l_decap_8
XFILLER_5_568 VPWR VGND sg13cmos5l_fill_1
X_11213_ _11213_/Q clkload10/A _11213_/D _11213_/RESET_B VPWR VGND sg13cmos5l_dfrbpq_1
Xoutput41 uo_out[2] _06536_/Y VPWR VGND sg13cmos5l_buf_1
Xoutput30 uio_out[7] _12767_/X VPWR VGND sg13cmos5l_buf_1
X_11144_ _11144_/Q clkload56/A _11144_/D _11144_/RESET_B VPWR VGND sg13cmos5l_dfrbpq_1
XFILLER_96_818 VPWR VGND sg13cmos5l_fill_1
XFILLER_1_730 VPWR VGND sg13cmos5l_decap_8
X_11075_ _11075_/Q clkload56/A _11075_/D _11075_/RESET_B VPWR VGND sg13cmos5l_dfrbpq_1
XFILLER_49_734 VPWR VGND sg13cmos5l_decap_4
XFILLER_76_520 VPWR VGND sg13cmos5l_fill_2
X_10026_ _10026_/Y _10026_/A _10026_/B VPWR VGND sg13cmos5l_nor2_1
XFILLER_48_233 VPWR VGND sg13cmos5l_decap_8
X_11157__1744 _11157_/RESET_B VPWR VGND sg13cmos5l_tiehi
XFILLER_64_704 VPWR VGND sg13cmos5l_decap_4
XFILLER_36_417 VPWR VGND sg13cmos5l_fill_2
XFILLER_64_748 VPWR VGND sg13cmos5l_decap_8
XFILLER_56_82 VPWR VGND sg13cmos5l_fill_2
XFILLER_45_984 VPWR VGND sg13cmos5l_fill_2
X_10928_ _10928_/Q _11671_/CLK _10928_/D _10928_/RESET_B VPWR VGND sg13cmos5l_dfrbpq_1
XFILLER_31_111 VPWR VGND sg13cmos5l_decap_8
XFILLER_32_667 VPWR VGND sg13cmos5l_decap_8
X_10859_ _10859_/Q clkload49/A _10859_/D _10859_/RESET_B VPWR VGND sg13cmos5l_dfrbpq_1
XFILLER_60_987 VPWR VGND sg13cmos5l_fill_2
XFILLER_20_818 VPWR VGND sg13cmos5l_fill_1
XFILLER_31_155 VPWR VGND sg13cmos5l_decap_8
XFILLER_31_166 VPWR VGND sg13cmos5l_fill_1
XFILLER_32_678 VPWR VGND sg13cmos5l_fill_2
XFILLER_75_4 VPWR VGND sg13cmos5l_decap_4
XFILLER_9_885 VPWR VGND sg13cmos5l_fill_2
X_11561__1433 _11561_/RESET_B VPWR VGND sg13cmos5l_tiehi
X_06050_ _06051_/B _06082_/B VPWR VGND sg13cmos5l_inv_1
Xfanout319 _08508_/A1 _07445_/Y VPWR VGND sg13cmos5l_buf_1
XFILLER_98_133 VPWR VGND sg13cmos5l_decap_8
XFILLER_87_807 VPWR VGND sg13cmos5l_fill_1
XFILLER_59_509 VPWR VGND sg13cmos5l_decap_4
Xfanout308 _08451_/A1 _08516_/A1 VPWR VGND sg13cmos5l_buf_1
XFILLER_100_105 VPWR VGND sg13cmos5l_decap_8
X_06952_ _07071_/B _06952_/A _06952_/B VPWR VGND sg13cmos5l_nand2_1
X_09740_ _09740_/Y _11357_/Q _09733_/S _06477_/B VPWR VGND sg13cmos5l_a21oi_1
.ends
